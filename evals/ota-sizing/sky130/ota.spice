* Two-stage Miller OTA, SkyWater SKY130 1.8 V MOS devices, VDD = 1.8 V
* Pins: inp inn out vdd vss ibias. Bias: a 10 uA current flows into ibias.
* Stage 1: NMOS differential pair XM1/XM2, PMOS mirror load XM3/XM4, tail source XM5.
* Stage 2: PMOS common source XM6, NMOS current sink XM7. Miller compensation Cc with zero resistor Rz.
* W and L are in um (the SKY130 model library sets ".option scale=1e-6").
.subckt ota inp inn out vdd vss ibias
XM8 ibias ibias vss vss sky130_fd_pr__nfet_01v8 w=2 l=1 nf=1
XM5 tail ibias vss vss sky130_fd_pr__nfet_01v8 w=4 l=1 nf=1
XM1 x inn tail vss sky130_fd_pr__nfet_01v8 w=4 l=0.5 nf=2
XM2 y inp tail vss sky130_fd_pr__nfet_01v8 w=4 l=0.5 nf=2
XM3 x x vdd vdd sky130_fd_pr__pfet_01v8 w=8 l=0.5 nf=2
XM4 y x vdd vdd sky130_fd_pr__pfet_01v8 w=8 l=0.5 nf=2
XM6 out y vdd vdd sky130_fd_pr__pfet_01v8 w=32 l=0.5 nf=4
XM7 out ibias vss vss sky130_fd_pr__nfet_01v8 w=8 l=1 nf=2
Rz y z 5k
Cc z out 1p
.ends ota
