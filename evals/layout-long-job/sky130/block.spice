* idac: binary-weighted NMOS current-source array (8 branches) with its bias diode and a
* differential input pair with a tail source. Flat: one subcircuit with every device.
* Devices: 21487.

.subckt idac o0 o1 o2 o3 o4 o5 o6 o7 inp inn outp outn ibias vss
M1 o0 ibias vss vss sky130_fd_pr__nfet_01v8 L=0.5u W=1u
M2 o0 ibias vss vss sky130_fd_pr__nfet_01v8 L=0.5u W=1u
M3 o0 ibias vss vss sky130_fd_pr__nfet_01v8 L=0.5u W=1u
M4 o0 ibias vss vss sky130_fd_pr__nfet_01v8 L=0.5u W=1u
M5 o0 ibias vss vss sky130_fd_pr__nfet_01v8 L=0.5u W=1u
M6 o0 ibias vss vss sky130_fd_pr__nfet_01v8 L=0.5u W=1u
M7 o0 ibias vss vss sky130_fd_pr__nfet_01v8 L=0.5u W=1u
M8 o0 ibias vss vss sky130_fd_pr__nfet_01v8 L=0.5u W=1u
M9 o0 ibias vss vss sky130_fd_pr__nfet_01v8 L=0.5u W=1u
M10 o0 ibias vss vss sky130_fd_pr__nfet_01v8 L=0.5u W=1u
M11 o0 ibias vss vss sky130_fd_pr__nfet_01v8 L=0.5u W=1u
M12 o0 ibias vss vss sky130_fd_pr__nfet_01v8 L=0.5u W=1u
M13 o0 ibias vss vss sky130_fd_pr__nfet_01v8 L=0.5u W=1u
M14 o0 ibias vss vss sky130_fd_pr__nfet_01v8 L=0.5u W=1u
M15 o0 ibias vss vss sky130_fd_pr__nfet_01v8 L=0.5u W=1u
M16 o0 ibias vss vss sky130_fd_pr__nfet_01v8 L=0.5u W=1u
M17 o0 ibias vss vss sky130_fd_pr__nfet_01v8 L=0.5u W=1u
M18 o0 ibias vss vss sky130_fd_pr__nfet_01v8 L=0.5u W=1u
M19 o0 ibias vss vss sky130_fd_pr__nfet_01v8 L=0.5u W=1u
M20 o0 ibias vss vss sky130_fd_pr__nfet_01v8 L=0.5u W=1u
M21 o0 ibias vss vss sky130_fd_pr__nfet_01v8 L=0.5u W=1u
M22 o0 ibias vss vss sky130_fd_pr__nfet_01v8 L=0.5u W=1u
M23 o0 ibias vss vss sky130_fd_pr__nfet_01v8 L=0.5u W=1u
M24 o0 ibias vss vss sky130_fd_pr__nfet_01v8 L=0.5u W=1u
M25 o0 ibias vss vss sky130_fd_pr__nfet_01v8 L=0.5u W=1u
M26 o0 ibias vss vss sky130_fd_pr__nfet_01v8 L=0.5u W=1u
M27 o0 ibias vss vss sky130_fd_pr__nfet_01v8 L=0.5u W=1u
M28 o0 ibias vss vss sky130_fd_pr__nfet_01v8 L=0.5u W=1u
M29 o0 ibias vss vss sky130_fd_pr__nfet_01v8 L=0.5u W=1u
M30 o0 ibias vss vss sky130_fd_pr__nfet_01v8 L=0.5u W=1u
M31 o0 ibias vss vss sky130_fd_pr__nfet_01v8 L=0.5u W=1u
M32 o0 ibias vss vss sky130_fd_pr__nfet_01v8 L=0.5u W=1u
M33 o0 ibias vss vss sky130_fd_pr__nfet_01v8 L=0.5u W=1u
M34 o0 ibias vss vss sky130_fd_pr__nfet_01v8 L=0.5u W=1u
M35 o0 ibias vss vss sky130_fd_pr__nfet_01v8 L=0.5u W=1u
M36 o0 ibias vss vss sky130_fd_pr__nfet_01v8 L=0.5u W=1u
M37 o0 ibias vss vss sky130_fd_pr__nfet_01v8 L=0.5u W=1u
M38 o0 ibias vss vss sky130_fd_pr__nfet_01v8 L=0.5u W=1u
M39 o0 ibias vss vss sky130_fd_pr__nfet_01v8 L=0.5u W=1u
M40 o0 ibias vss vss sky130_fd_pr__nfet_01v8 L=0.5u W=1u
M41 o0 ibias vss vss sky130_fd_pr__nfet_01v8 L=0.5u W=1u
M42 o0 ibias vss vss sky130_fd_pr__nfet_01v8 L=0.5u W=1u
M43 o0 ibias vss vss sky130_fd_pr__nfet_01v8 L=0.5u W=1u
M44 o0 ibias vss vss sky130_fd_pr__nfet_01v8 L=0.5u W=1u
M45 o0 ibias vss vss sky130_fd_pr__nfet_01v8 L=0.5u W=1u
M46 o0 ibias vss vss sky130_fd_pr__nfet_01v8 L=0.5u W=1u
M47 o0 ibias vss vss sky130_fd_pr__nfet_01v8 L=0.5u W=1u
M48 o0 ibias vss vss sky130_fd_pr__nfet_01v8 L=0.5u W=1u
M49 o0 ibias vss vss sky130_fd_pr__nfet_01v8 L=0.5u W=1u
M50 o0 ibias vss vss sky130_fd_pr__nfet_01v8 L=0.5u W=1u
M51 o0 ibias vss vss sky130_fd_pr__nfet_01v8 L=0.5u W=1u
M52 o0 ibias vss vss sky130_fd_pr__nfet_01v8 L=0.5u W=1u
M53 o0 ibias vss vss sky130_fd_pr__nfet_01v8 L=0.5u W=1u
M54 o0 ibias vss vss sky130_fd_pr__nfet_01v8 L=0.5u W=1u
M55 o0 ibias vss vss sky130_fd_pr__nfet_01v8 L=0.5u W=1u
M56 o0 ibias vss vss sky130_fd_pr__nfet_01v8 L=0.5u W=1u
M57 o0 ibias vss vss sky130_fd_pr__nfet_01v8 L=0.5u W=1u
M58 o0 ibias vss vss sky130_fd_pr__nfet_01v8 L=0.5u W=1u
M59 o0 ibias vss vss sky130_fd_pr__nfet_01v8 L=0.5u W=1u
M60 o0 ibias vss vss sky130_fd_pr__nfet_01v8 L=0.5u W=1u
M61 o0 ibias vss vss sky130_fd_pr__nfet_01v8 L=0.5u W=1u
M62 o0 ibias vss vss sky130_fd_pr__nfet_01v8 L=0.5u W=1u
M63 o0 ibias vss vss sky130_fd_pr__nfet_01v8 L=0.5u W=1u
M64 o0 ibias vss vss sky130_fd_pr__nfet_01v8 L=0.5u W=1u
M65 o0 ibias vss vss sky130_fd_pr__nfet_01v8 L=0.5u W=1u
M66 o0 ibias vss vss sky130_fd_pr__nfet_01v8 L=0.5u W=1u
M67 o0 ibias vss vss sky130_fd_pr__nfet_01v8 L=0.5u W=1u
M68 o0 ibias vss vss sky130_fd_pr__nfet_01v8 L=0.5u W=1u
M69 o0 ibias vss vss sky130_fd_pr__nfet_01v8 L=0.5u W=1u
M70 o0 ibias vss vss sky130_fd_pr__nfet_01v8 L=0.5u W=1u
M71 o0 ibias vss vss sky130_fd_pr__nfet_01v8 L=0.5u W=1u
M72 o0 ibias vss vss sky130_fd_pr__nfet_01v8 L=0.5u W=1u
M73 o0 ibias vss vss sky130_fd_pr__nfet_01v8 L=0.5u W=1u
M74 o0 ibias vss vss sky130_fd_pr__nfet_01v8 L=0.5u W=1u
M75 o0 ibias vss vss sky130_fd_pr__nfet_01v8 L=0.5u W=1u
M76 o0 ibias vss vss sky130_fd_pr__nfet_01v8 L=0.5u W=1u
M77 o0 ibias vss vss sky130_fd_pr__nfet_01v8 L=0.5u W=1u
M78 o0 ibias vss vss sky130_fd_pr__nfet_01v8 L=0.5u W=1u
M79 o0 ibias vss vss sky130_fd_pr__nfet_01v8 L=0.5u W=1u
M80 o0 ibias vss vss sky130_fd_pr__nfet_01v8 L=0.5u W=1u
M81 o0 ibias vss vss sky130_fd_pr__nfet_01v8 L=0.5u W=1u
M82 o1 ibias vss vss sky130_fd_pr__nfet_01v8 L=0.5u W=1u
M83 o1 ibias vss vss sky130_fd_pr__nfet_01v8 L=0.5u W=1u
M84 o1 ibias vss vss sky130_fd_pr__nfet_01v8 L=0.5u W=1u
M85 o1 ibias vss vss sky130_fd_pr__nfet_01v8 L=0.5u W=1u
M86 o1 ibias vss vss sky130_fd_pr__nfet_01v8 L=0.5u W=1u
M87 o1 ibias vss vss sky130_fd_pr__nfet_01v8 L=0.5u W=1u
M88 o1 ibias vss vss sky130_fd_pr__nfet_01v8 L=0.5u W=1u
M89 o1 ibias vss vss sky130_fd_pr__nfet_01v8 L=0.5u W=1u
M90 o1 ibias vss vss sky130_fd_pr__nfet_01v8 L=0.5u W=1u
M91 o1 ibias vss vss sky130_fd_pr__nfet_01v8 L=0.5u W=1u
M92 o1 ibias vss vss sky130_fd_pr__nfet_01v8 L=0.5u W=1u
M93 o1 ibias vss vss sky130_fd_pr__nfet_01v8 L=0.5u W=1u
M94 o1 ibias vss vss sky130_fd_pr__nfet_01v8 L=0.5u W=1u
M95 o1 ibias vss vss sky130_fd_pr__nfet_01v8 L=0.5u W=1u
M96 o1 ibias vss vss sky130_fd_pr__nfet_01v8 L=0.5u W=1u
M97 o1 ibias vss vss sky130_fd_pr__nfet_01v8 L=0.5u W=1u
M98 o1 ibias vss vss sky130_fd_pr__nfet_01v8 L=0.5u W=1u
M99 o1 ibias vss vss sky130_fd_pr__nfet_01v8 L=0.5u W=1u
M100 o1 ibias vss vss sky130_fd_pr__nfet_01v8 L=0.5u W=1u
M101 o1 ibias vss vss sky130_fd_pr__nfet_01v8 L=0.5u W=1u
M102 o1 ibias vss vss sky130_fd_pr__nfet_01v8 L=0.5u W=1u
M103 o1 ibias vss vss sky130_fd_pr__nfet_01v8 L=0.5u W=1u
M104 o1 ibias vss vss sky130_fd_pr__nfet_01v8 L=0.5u W=1u
M105 o1 ibias vss vss sky130_fd_pr__nfet_01v8 L=0.5u W=1u
M106 o1 ibias vss vss sky130_fd_pr__nfet_01v8 L=0.5u W=1u
M107 o1 ibias vss vss sky130_fd_pr__nfet_01v8 L=0.5u W=1u
M108 o1 ibias vss vss sky130_fd_pr__nfet_01v8 L=0.5u W=1u
M109 o1 ibias vss vss sky130_fd_pr__nfet_01v8 L=0.5u W=1u
M110 o1 ibias vss vss sky130_fd_pr__nfet_01v8 L=0.5u W=1u
M111 o1 ibias vss vss sky130_fd_pr__nfet_01v8 L=0.5u W=1u
M112 o1 ibias vss vss sky130_fd_pr__nfet_01v8 L=0.5u W=1u
M113 o1 ibias vss vss sky130_fd_pr__nfet_01v8 L=0.5u W=1u
M114 o1 ibias vss vss sky130_fd_pr__nfet_01v8 L=0.5u W=1u
M115 o1 ibias vss vss sky130_fd_pr__nfet_01v8 L=0.5u W=1u
M116 o1 ibias vss vss sky130_fd_pr__nfet_01v8 L=0.5u W=1u
M117 o1 ibias vss vss sky130_fd_pr__nfet_01v8 L=0.5u W=1u
M118 o1 ibias vss vss sky130_fd_pr__nfet_01v8 L=0.5u W=1u
M119 o1 ibias vss vss sky130_fd_pr__nfet_01v8 L=0.5u W=1u
M120 o1 ibias vss vss sky130_fd_pr__nfet_01v8 L=0.5u W=1u
M121 o1 ibias vss vss sky130_fd_pr__nfet_01v8 L=0.5u W=1u
M122 o1 ibias vss vss sky130_fd_pr__nfet_01v8 L=0.5u W=1u
M123 o1 ibias vss vss sky130_fd_pr__nfet_01v8 L=0.5u W=1u
M124 o1 ibias vss vss sky130_fd_pr__nfet_01v8 L=0.5u W=1u
M125 o1 ibias vss vss sky130_fd_pr__nfet_01v8 L=0.5u W=1u
M126 o1 ibias vss vss sky130_fd_pr__nfet_01v8 L=0.5u W=1u
M127 o1 ibias vss vss sky130_fd_pr__nfet_01v8 L=0.5u W=1u
M128 o1 ibias vss vss sky130_fd_pr__nfet_01v8 L=0.5u W=1u
M129 o1 ibias vss vss sky130_fd_pr__nfet_01v8 L=0.5u W=1u
M130 o1 ibias vss vss sky130_fd_pr__nfet_01v8 L=0.5u W=1u
M131 o1 ibias vss vss sky130_fd_pr__nfet_01v8 L=0.5u W=1u
M132 o1 ibias vss vss sky130_fd_pr__nfet_01v8 L=0.5u W=1u
M133 o1 ibias vss vss sky130_fd_pr__nfet_01v8 L=0.5u W=1u
M134 o1 ibias vss vss sky130_fd_pr__nfet_01v8 L=0.5u W=1u
M135 o1 ibias vss vss sky130_fd_pr__nfet_01v8 L=0.5u W=1u
M136 o1 ibias vss vss sky130_fd_pr__nfet_01v8 L=0.5u W=1u
M137 o1 ibias vss vss sky130_fd_pr__nfet_01v8 L=0.5u W=1u
M138 o1 ibias vss vss sky130_fd_pr__nfet_01v8 L=0.5u W=1u
M139 o1 ibias vss vss sky130_fd_pr__nfet_01v8 L=0.5u W=1u
M140 o1 ibias vss vss sky130_fd_pr__nfet_01v8 L=0.5u W=1u
M141 o1 ibias vss vss sky130_fd_pr__nfet_01v8 L=0.5u W=1u
M142 o1 ibias vss vss sky130_fd_pr__nfet_01v8 L=0.5u W=1u
M143 o1 ibias vss vss sky130_fd_pr__nfet_01v8 L=0.5u W=1u
M144 o1 ibias vss vss sky130_fd_pr__nfet_01v8 L=0.5u W=1u
M145 o1 ibias vss vss sky130_fd_pr__nfet_01v8 L=0.5u W=1u
M146 o1 ibias vss vss sky130_fd_pr__nfet_01v8 L=0.5u W=1u
M147 o1 ibias vss vss sky130_fd_pr__nfet_01v8 L=0.5u W=1u
M148 o1 ibias vss vss sky130_fd_pr__nfet_01v8 L=0.5u W=1u
M149 o1 ibias vss vss sky130_fd_pr__nfet_01v8 L=0.5u W=1u
M150 o1 ibias vss vss sky130_fd_pr__nfet_01v8 L=0.5u W=1u
M151 o1 ibias vss vss sky130_fd_pr__nfet_01v8 L=0.5u W=1u
M152 o1 ibias vss vss sky130_fd_pr__nfet_01v8 L=0.5u W=1u
M153 o1 ibias vss vss sky130_fd_pr__nfet_01v8 L=0.5u W=1u
M154 o1 ibias vss vss sky130_fd_pr__nfet_01v8 L=0.5u W=1u
M155 o1 ibias vss vss sky130_fd_pr__nfet_01v8 L=0.5u W=1u
M156 o1 ibias vss vss sky130_fd_pr__nfet_01v8 L=0.5u W=1u
M157 o1 ibias vss vss sky130_fd_pr__nfet_01v8 L=0.5u W=1u
M158 o1 ibias vss vss sky130_fd_pr__nfet_01v8 L=0.5u W=1u
M159 o1 ibias vss vss sky130_fd_pr__nfet_01v8 L=0.5u W=1u
M160 o1 ibias vss vss sky130_fd_pr__nfet_01v8 L=0.5u W=1u
M161 o1 ibias vss vss sky130_fd_pr__nfet_01v8 L=0.5u W=1u
M162 o1 ibias vss vss sky130_fd_pr__nfet_01v8 L=0.5u W=1u
M163 o1 ibias vss vss sky130_fd_pr__nfet_01v8 L=0.5u W=1u
M164 o1 ibias vss vss sky130_fd_pr__nfet_01v8 L=0.5u W=1u
M165 o1 ibias vss vss sky130_fd_pr__nfet_01v8 L=0.5u W=1u
M166 o1 ibias vss vss sky130_fd_pr__nfet_01v8 L=0.5u W=1u
M167 o1 ibias vss vss sky130_fd_pr__nfet_01v8 L=0.5u W=1u
M168 o1 ibias vss vss sky130_fd_pr__nfet_01v8 L=0.5u W=1u
M169 o1 ibias vss vss sky130_fd_pr__nfet_01v8 L=0.5u W=1u
M170 o1 ibias vss vss sky130_fd_pr__nfet_01v8 L=0.5u W=1u
M171 o1 ibias vss vss sky130_fd_pr__nfet_01v8 L=0.5u W=1u
M172 o1 ibias vss vss sky130_fd_pr__nfet_01v8 L=0.5u W=1u
M173 o1 ibias vss vss sky130_fd_pr__nfet_01v8 L=0.5u W=1u
M174 o1 ibias vss vss sky130_fd_pr__nfet_01v8 L=0.5u W=1u
M175 o1 ibias vss vss sky130_fd_pr__nfet_01v8 L=0.5u W=1u
M176 o1 ibias vss vss sky130_fd_pr__nfet_01v8 L=0.5u W=1u
M177 o1 ibias vss vss sky130_fd_pr__nfet_01v8 L=0.5u W=1u
M178 o1 ibias vss vss sky130_fd_pr__nfet_01v8 L=0.5u W=1u
M179 o1 ibias vss vss sky130_fd_pr__nfet_01v8 L=0.5u W=1u
M180 o1 ibias vss vss sky130_fd_pr__nfet_01v8 L=0.5u W=1u
M181 o1 ibias vss vss sky130_fd_pr__nfet_01v8 L=0.5u W=1u
M182 o1 ibias vss vss sky130_fd_pr__nfet_01v8 L=0.5u W=1u
M183 o1 ibias vss vss sky130_fd_pr__nfet_01v8 L=0.5u W=1u
M184 o1 ibias vss vss sky130_fd_pr__nfet_01v8 L=0.5u W=1u
M185 o1 ibias vss vss sky130_fd_pr__nfet_01v8 L=0.5u W=1u
M186 o1 ibias vss vss sky130_fd_pr__nfet_01v8 L=0.5u W=1u
M187 o1 ibias vss vss sky130_fd_pr__nfet_01v8 L=0.5u W=1u
M188 o1 ibias vss vss sky130_fd_pr__nfet_01v8 L=0.5u W=1u
M189 o1 ibias vss vss sky130_fd_pr__nfet_01v8 L=0.5u W=1u
M190 o1 ibias vss vss sky130_fd_pr__nfet_01v8 L=0.5u W=1u
M191 o1 ibias vss vss sky130_fd_pr__nfet_01v8 L=0.5u W=1u
M192 o1 ibias vss vss sky130_fd_pr__nfet_01v8 L=0.5u W=1u
M193 o1 ibias vss vss sky130_fd_pr__nfet_01v8 L=0.5u W=1u
M194 o1 ibias vss vss sky130_fd_pr__nfet_01v8 L=0.5u W=1u
M195 o1 ibias vss vss sky130_fd_pr__nfet_01v8 L=0.5u W=1u
M196 o1 ibias vss vss sky130_fd_pr__nfet_01v8 L=0.5u W=1u
M197 o1 ibias vss vss sky130_fd_pr__nfet_01v8 L=0.5u W=1u
M198 o1 ibias vss vss sky130_fd_pr__nfet_01v8 L=0.5u W=1u
M199 o1 ibias vss vss sky130_fd_pr__nfet_01v8 L=0.5u W=1u
M200 o1 ibias vss vss sky130_fd_pr__nfet_01v8 L=0.5u W=1u
M201 o1 ibias vss vss sky130_fd_pr__nfet_01v8 L=0.5u W=1u
M202 o1 ibias vss vss sky130_fd_pr__nfet_01v8 L=0.5u W=1u
M203 o1 ibias vss vss sky130_fd_pr__nfet_01v8 L=0.5u W=1u
M204 o1 ibias vss vss sky130_fd_pr__nfet_01v8 L=0.5u W=1u
M205 o1 ibias vss vss sky130_fd_pr__nfet_01v8 L=0.5u W=1u
M206 o1 ibias vss vss sky130_fd_pr__nfet_01v8 L=0.5u W=1u
M207 o1 ibias vss vss sky130_fd_pr__nfet_01v8 L=0.5u W=1u
M208 o1 ibias vss vss sky130_fd_pr__nfet_01v8 L=0.5u W=1u
M209 o1 ibias vss vss sky130_fd_pr__nfet_01v8 L=0.5u W=1u
M210 o1 ibias vss vss sky130_fd_pr__nfet_01v8 L=0.5u W=1u
M211 o1 ibias vss vss sky130_fd_pr__nfet_01v8 L=0.5u W=1u
M212 o1 ibias vss vss sky130_fd_pr__nfet_01v8 L=0.5u W=1u
M213 o1 ibias vss vss sky130_fd_pr__nfet_01v8 L=0.5u W=1u
M214 o1 ibias vss vss sky130_fd_pr__nfet_01v8 L=0.5u W=1u
M215 o1 ibias vss vss sky130_fd_pr__nfet_01v8 L=0.5u W=1u
M216 o1 ibias vss vss sky130_fd_pr__nfet_01v8 L=0.5u W=1u
M217 o1 ibias vss vss sky130_fd_pr__nfet_01v8 L=0.5u W=1u
M218 o1 ibias vss vss sky130_fd_pr__nfet_01v8 L=0.5u W=1u
M219 o1 ibias vss vss sky130_fd_pr__nfet_01v8 L=0.5u W=1u
M220 o1 ibias vss vss sky130_fd_pr__nfet_01v8 L=0.5u W=1u
M221 o1 ibias vss vss sky130_fd_pr__nfet_01v8 L=0.5u W=1u
M222 o1 ibias vss vss sky130_fd_pr__nfet_01v8 L=0.5u W=1u
M223 o1 ibias vss vss sky130_fd_pr__nfet_01v8 L=0.5u W=1u
M224 o1 ibias vss vss sky130_fd_pr__nfet_01v8 L=0.5u W=1u
M225 o1 ibias vss vss sky130_fd_pr__nfet_01v8 L=0.5u W=1u
M226 o1 ibias vss vss sky130_fd_pr__nfet_01v8 L=0.5u W=1u
M227 o1 ibias vss vss sky130_fd_pr__nfet_01v8 L=0.5u W=1u
M228 o1 ibias vss vss sky130_fd_pr__nfet_01v8 L=0.5u W=1u
M229 o1 ibias vss vss sky130_fd_pr__nfet_01v8 L=0.5u W=1u
M230 o1 ibias vss vss sky130_fd_pr__nfet_01v8 L=0.5u W=1u
M231 o1 ibias vss vss sky130_fd_pr__nfet_01v8 L=0.5u W=1u
M232 o1 ibias vss vss sky130_fd_pr__nfet_01v8 L=0.5u W=1u
M233 o1 ibias vss vss sky130_fd_pr__nfet_01v8 L=0.5u W=1u
M234 o1 ibias vss vss sky130_fd_pr__nfet_01v8 L=0.5u W=1u
M235 o1 ibias vss vss sky130_fd_pr__nfet_01v8 L=0.5u W=1u
M236 o1 ibias vss vss sky130_fd_pr__nfet_01v8 L=0.5u W=1u
M237 o1 ibias vss vss sky130_fd_pr__nfet_01v8 L=0.5u W=1u
M238 o1 ibias vss vss sky130_fd_pr__nfet_01v8 L=0.5u W=1u
M239 o1 ibias vss vss sky130_fd_pr__nfet_01v8 L=0.5u W=1u
M240 o1 ibias vss vss sky130_fd_pr__nfet_01v8 L=0.5u W=1u
M241 o1 ibias vss vss sky130_fd_pr__nfet_01v8 L=0.5u W=1u
M242 o1 ibias vss vss sky130_fd_pr__nfet_01v8 L=0.5u W=1u
M243 o1 ibias vss vss sky130_fd_pr__nfet_01v8 L=0.5u W=1u
M244 o2 ibias vss vss sky130_fd_pr__nfet_01v8 L=0.5u W=1u
M245 o2 ibias vss vss sky130_fd_pr__nfet_01v8 L=0.5u W=1u
M246 o2 ibias vss vss sky130_fd_pr__nfet_01v8 L=0.5u W=1u
M247 o2 ibias vss vss sky130_fd_pr__nfet_01v8 L=0.5u W=1u
M248 o2 ibias vss vss sky130_fd_pr__nfet_01v8 L=0.5u W=1u
M249 o2 ibias vss vss sky130_fd_pr__nfet_01v8 L=0.5u W=1u
M250 o2 ibias vss vss sky130_fd_pr__nfet_01v8 L=0.5u W=1u
M251 o2 ibias vss vss sky130_fd_pr__nfet_01v8 L=0.5u W=1u
M252 o2 ibias vss vss sky130_fd_pr__nfet_01v8 L=0.5u W=1u
M253 o2 ibias vss vss sky130_fd_pr__nfet_01v8 L=0.5u W=1u
M254 o2 ibias vss vss sky130_fd_pr__nfet_01v8 L=0.5u W=1u
M255 o2 ibias vss vss sky130_fd_pr__nfet_01v8 L=0.5u W=1u
M256 o2 ibias vss vss sky130_fd_pr__nfet_01v8 L=0.5u W=1u
M257 o2 ibias vss vss sky130_fd_pr__nfet_01v8 L=0.5u W=1u
M258 o2 ibias vss vss sky130_fd_pr__nfet_01v8 L=0.5u W=1u
M259 o2 ibias vss vss sky130_fd_pr__nfet_01v8 L=0.5u W=1u
M260 o2 ibias vss vss sky130_fd_pr__nfet_01v8 L=0.5u W=1u
M261 o2 ibias vss vss sky130_fd_pr__nfet_01v8 L=0.5u W=1u
M262 o2 ibias vss vss sky130_fd_pr__nfet_01v8 L=0.5u W=1u
M263 o2 ibias vss vss sky130_fd_pr__nfet_01v8 L=0.5u W=1u
M264 o2 ibias vss vss sky130_fd_pr__nfet_01v8 L=0.5u W=1u
M265 o2 ibias vss vss sky130_fd_pr__nfet_01v8 L=0.5u W=1u
M266 o2 ibias vss vss sky130_fd_pr__nfet_01v8 L=0.5u W=1u
M267 o2 ibias vss vss sky130_fd_pr__nfet_01v8 L=0.5u W=1u
M268 o2 ibias vss vss sky130_fd_pr__nfet_01v8 L=0.5u W=1u
M269 o2 ibias vss vss sky130_fd_pr__nfet_01v8 L=0.5u W=1u
M270 o2 ibias vss vss sky130_fd_pr__nfet_01v8 L=0.5u W=1u
M271 o2 ibias vss vss sky130_fd_pr__nfet_01v8 L=0.5u W=1u
M272 o2 ibias vss vss sky130_fd_pr__nfet_01v8 L=0.5u W=1u
M273 o2 ibias vss vss sky130_fd_pr__nfet_01v8 L=0.5u W=1u
M274 o2 ibias vss vss sky130_fd_pr__nfet_01v8 L=0.5u W=1u
M275 o2 ibias vss vss sky130_fd_pr__nfet_01v8 L=0.5u W=1u
M276 o2 ibias vss vss sky130_fd_pr__nfet_01v8 L=0.5u W=1u
M277 o2 ibias vss vss sky130_fd_pr__nfet_01v8 L=0.5u W=1u
M278 o2 ibias vss vss sky130_fd_pr__nfet_01v8 L=0.5u W=1u
M279 o2 ibias vss vss sky130_fd_pr__nfet_01v8 L=0.5u W=1u
M280 o2 ibias vss vss sky130_fd_pr__nfet_01v8 L=0.5u W=1u
M281 o2 ibias vss vss sky130_fd_pr__nfet_01v8 L=0.5u W=1u
M282 o2 ibias vss vss sky130_fd_pr__nfet_01v8 L=0.5u W=1u
M283 o2 ibias vss vss sky130_fd_pr__nfet_01v8 L=0.5u W=1u
M284 o2 ibias vss vss sky130_fd_pr__nfet_01v8 L=0.5u W=1u
M285 o2 ibias vss vss sky130_fd_pr__nfet_01v8 L=0.5u W=1u
M286 o2 ibias vss vss sky130_fd_pr__nfet_01v8 L=0.5u W=1u
M287 o2 ibias vss vss sky130_fd_pr__nfet_01v8 L=0.5u W=1u
M288 o2 ibias vss vss sky130_fd_pr__nfet_01v8 L=0.5u W=1u
M289 o2 ibias vss vss sky130_fd_pr__nfet_01v8 L=0.5u W=1u
M290 o2 ibias vss vss sky130_fd_pr__nfet_01v8 L=0.5u W=1u
M291 o2 ibias vss vss sky130_fd_pr__nfet_01v8 L=0.5u W=1u
M292 o2 ibias vss vss sky130_fd_pr__nfet_01v8 L=0.5u W=1u
M293 o2 ibias vss vss sky130_fd_pr__nfet_01v8 L=0.5u W=1u
M294 o2 ibias vss vss sky130_fd_pr__nfet_01v8 L=0.5u W=1u
M295 o2 ibias vss vss sky130_fd_pr__nfet_01v8 L=0.5u W=1u
M296 o2 ibias vss vss sky130_fd_pr__nfet_01v8 L=0.5u W=1u
M297 o2 ibias vss vss sky130_fd_pr__nfet_01v8 L=0.5u W=1u
M298 o2 ibias vss vss sky130_fd_pr__nfet_01v8 L=0.5u W=1u
M299 o2 ibias vss vss sky130_fd_pr__nfet_01v8 L=0.5u W=1u
M300 o2 ibias vss vss sky130_fd_pr__nfet_01v8 L=0.5u W=1u
M301 o2 ibias vss vss sky130_fd_pr__nfet_01v8 L=0.5u W=1u
M302 o2 ibias vss vss sky130_fd_pr__nfet_01v8 L=0.5u W=1u
M303 o2 ibias vss vss sky130_fd_pr__nfet_01v8 L=0.5u W=1u
M304 o2 ibias vss vss sky130_fd_pr__nfet_01v8 L=0.5u W=1u
M305 o2 ibias vss vss sky130_fd_pr__nfet_01v8 L=0.5u W=1u
M306 o2 ibias vss vss sky130_fd_pr__nfet_01v8 L=0.5u W=1u
M307 o2 ibias vss vss sky130_fd_pr__nfet_01v8 L=0.5u W=1u
M308 o2 ibias vss vss sky130_fd_pr__nfet_01v8 L=0.5u W=1u
M309 o2 ibias vss vss sky130_fd_pr__nfet_01v8 L=0.5u W=1u
M310 o2 ibias vss vss sky130_fd_pr__nfet_01v8 L=0.5u W=1u
M311 o2 ibias vss vss sky130_fd_pr__nfet_01v8 L=0.5u W=1u
M312 o2 ibias vss vss sky130_fd_pr__nfet_01v8 L=0.5u W=1u
M313 o2 ibias vss vss sky130_fd_pr__nfet_01v8 L=0.5u W=1u
M314 o2 ibias vss vss sky130_fd_pr__nfet_01v8 L=0.5u W=1u
M315 o2 ibias vss vss sky130_fd_pr__nfet_01v8 L=0.5u W=1u
M316 o2 ibias vss vss sky130_fd_pr__nfet_01v8 L=0.5u W=1u
M317 o2 ibias vss vss sky130_fd_pr__nfet_01v8 L=0.5u W=1u
M318 o2 ibias vss vss sky130_fd_pr__nfet_01v8 L=0.5u W=1u
M319 o2 ibias vss vss sky130_fd_pr__nfet_01v8 L=0.5u W=1u
M320 o2 ibias vss vss sky130_fd_pr__nfet_01v8 L=0.5u W=1u
M321 o2 ibias vss vss sky130_fd_pr__nfet_01v8 L=0.5u W=1u
M322 o2 ibias vss vss sky130_fd_pr__nfet_01v8 L=0.5u W=1u
M323 o2 ibias vss vss sky130_fd_pr__nfet_01v8 L=0.5u W=1u
M324 o2 ibias vss vss sky130_fd_pr__nfet_01v8 L=0.5u W=1u
M325 o2 ibias vss vss sky130_fd_pr__nfet_01v8 L=0.5u W=1u
M326 o2 ibias vss vss sky130_fd_pr__nfet_01v8 L=0.5u W=1u
M327 o2 ibias vss vss sky130_fd_pr__nfet_01v8 L=0.5u W=1u
M328 o2 ibias vss vss sky130_fd_pr__nfet_01v8 L=0.5u W=1u
M329 o2 ibias vss vss sky130_fd_pr__nfet_01v8 L=0.5u W=1u
M330 o2 ibias vss vss sky130_fd_pr__nfet_01v8 L=0.5u W=1u
M331 o2 ibias vss vss sky130_fd_pr__nfet_01v8 L=0.5u W=1u
M332 o2 ibias vss vss sky130_fd_pr__nfet_01v8 L=0.5u W=1u
M333 o2 ibias vss vss sky130_fd_pr__nfet_01v8 L=0.5u W=1u
M334 o2 ibias vss vss sky130_fd_pr__nfet_01v8 L=0.5u W=1u
M335 o2 ibias vss vss sky130_fd_pr__nfet_01v8 L=0.5u W=1u
M336 o2 ibias vss vss sky130_fd_pr__nfet_01v8 L=0.5u W=1u
M337 o2 ibias vss vss sky130_fd_pr__nfet_01v8 L=0.5u W=1u
M338 o2 ibias vss vss sky130_fd_pr__nfet_01v8 L=0.5u W=1u
M339 o2 ibias vss vss sky130_fd_pr__nfet_01v8 L=0.5u W=1u
M340 o2 ibias vss vss sky130_fd_pr__nfet_01v8 L=0.5u W=1u
M341 o2 ibias vss vss sky130_fd_pr__nfet_01v8 L=0.5u W=1u
M342 o2 ibias vss vss sky130_fd_pr__nfet_01v8 L=0.5u W=1u
M343 o2 ibias vss vss sky130_fd_pr__nfet_01v8 L=0.5u W=1u
M344 o2 ibias vss vss sky130_fd_pr__nfet_01v8 L=0.5u W=1u
M345 o2 ibias vss vss sky130_fd_pr__nfet_01v8 L=0.5u W=1u
M346 o2 ibias vss vss sky130_fd_pr__nfet_01v8 L=0.5u W=1u
M347 o2 ibias vss vss sky130_fd_pr__nfet_01v8 L=0.5u W=1u
M348 o2 ibias vss vss sky130_fd_pr__nfet_01v8 L=0.5u W=1u
M349 o2 ibias vss vss sky130_fd_pr__nfet_01v8 L=0.5u W=1u
M350 o2 ibias vss vss sky130_fd_pr__nfet_01v8 L=0.5u W=1u
M351 o2 ibias vss vss sky130_fd_pr__nfet_01v8 L=0.5u W=1u
M352 o2 ibias vss vss sky130_fd_pr__nfet_01v8 L=0.5u W=1u
M353 o2 ibias vss vss sky130_fd_pr__nfet_01v8 L=0.5u W=1u
M354 o2 ibias vss vss sky130_fd_pr__nfet_01v8 L=0.5u W=1u
M355 o2 ibias vss vss sky130_fd_pr__nfet_01v8 L=0.5u W=1u
M356 o2 ibias vss vss sky130_fd_pr__nfet_01v8 L=0.5u W=1u
M357 o2 ibias vss vss sky130_fd_pr__nfet_01v8 L=0.5u W=1u
M358 o2 ibias vss vss sky130_fd_pr__nfet_01v8 L=0.5u W=1u
M359 o2 ibias vss vss sky130_fd_pr__nfet_01v8 L=0.5u W=1u
M360 o2 ibias vss vss sky130_fd_pr__nfet_01v8 L=0.5u W=1u
M361 o2 ibias vss vss sky130_fd_pr__nfet_01v8 L=0.5u W=1u
M362 o2 ibias vss vss sky130_fd_pr__nfet_01v8 L=0.5u W=1u
M363 o2 ibias vss vss sky130_fd_pr__nfet_01v8 L=0.5u W=1u
M364 o2 ibias vss vss sky130_fd_pr__nfet_01v8 L=0.5u W=1u
M365 o2 ibias vss vss sky130_fd_pr__nfet_01v8 L=0.5u W=1u
M366 o2 ibias vss vss sky130_fd_pr__nfet_01v8 L=0.5u W=1u
M367 o2 ibias vss vss sky130_fd_pr__nfet_01v8 L=0.5u W=1u
M368 o2 ibias vss vss sky130_fd_pr__nfet_01v8 L=0.5u W=1u
M369 o2 ibias vss vss sky130_fd_pr__nfet_01v8 L=0.5u W=1u
M370 o2 ibias vss vss sky130_fd_pr__nfet_01v8 L=0.5u W=1u
M371 o2 ibias vss vss sky130_fd_pr__nfet_01v8 L=0.5u W=1u
M372 o2 ibias vss vss sky130_fd_pr__nfet_01v8 L=0.5u W=1u
M373 o2 ibias vss vss sky130_fd_pr__nfet_01v8 L=0.5u W=1u
M374 o2 ibias vss vss sky130_fd_pr__nfet_01v8 L=0.5u W=1u
M375 o2 ibias vss vss sky130_fd_pr__nfet_01v8 L=0.5u W=1u
M376 o2 ibias vss vss sky130_fd_pr__nfet_01v8 L=0.5u W=1u
M377 o2 ibias vss vss sky130_fd_pr__nfet_01v8 L=0.5u W=1u
M378 o2 ibias vss vss sky130_fd_pr__nfet_01v8 L=0.5u W=1u
M379 o2 ibias vss vss sky130_fd_pr__nfet_01v8 L=0.5u W=1u
M380 o2 ibias vss vss sky130_fd_pr__nfet_01v8 L=0.5u W=1u
M381 o2 ibias vss vss sky130_fd_pr__nfet_01v8 L=0.5u W=1u
M382 o2 ibias vss vss sky130_fd_pr__nfet_01v8 L=0.5u W=1u
M383 o2 ibias vss vss sky130_fd_pr__nfet_01v8 L=0.5u W=1u
M384 o2 ibias vss vss sky130_fd_pr__nfet_01v8 L=0.5u W=1u
M385 o2 ibias vss vss sky130_fd_pr__nfet_01v8 L=0.5u W=1u
M386 o2 ibias vss vss sky130_fd_pr__nfet_01v8 L=0.5u W=1u
M387 o2 ibias vss vss sky130_fd_pr__nfet_01v8 L=0.5u W=1u
M388 o2 ibias vss vss sky130_fd_pr__nfet_01v8 L=0.5u W=1u
M389 o2 ibias vss vss sky130_fd_pr__nfet_01v8 L=0.5u W=1u
M390 o2 ibias vss vss sky130_fd_pr__nfet_01v8 L=0.5u W=1u
M391 o2 ibias vss vss sky130_fd_pr__nfet_01v8 L=0.5u W=1u
M392 o2 ibias vss vss sky130_fd_pr__nfet_01v8 L=0.5u W=1u
M393 o2 ibias vss vss sky130_fd_pr__nfet_01v8 L=0.5u W=1u
M394 o2 ibias vss vss sky130_fd_pr__nfet_01v8 L=0.5u W=1u
M395 o2 ibias vss vss sky130_fd_pr__nfet_01v8 L=0.5u W=1u
M396 o2 ibias vss vss sky130_fd_pr__nfet_01v8 L=0.5u W=1u
M397 o2 ibias vss vss sky130_fd_pr__nfet_01v8 L=0.5u W=1u
M398 o2 ibias vss vss sky130_fd_pr__nfet_01v8 L=0.5u W=1u
M399 o2 ibias vss vss sky130_fd_pr__nfet_01v8 L=0.5u W=1u
M400 o2 ibias vss vss sky130_fd_pr__nfet_01v8 L=0.5u W=1u
M401 o2 ibias vss vss sky130_fd_pr__nfet_01v8 L=0.5u W=1u
M402 o2 ibias vss vss sky130_fd_pr__nfet_01v8 L=0.5u W=1u
M403 o2 ibias vss vss sky130_fd_pr__nfet_01v8 L=0.5u W=1u
M404 o2 ibias vss vss sky130_fd_pr__nfet_01v8 L=0.5u W=1u
M405 o2 ibias vss vss sky130_fd_pr__nfet_01v8 L=0.5u W=1u
M406 o2 ibias vss vss sky130_fd_pr__nfet_01v8 L=0.5u W=1u
M407 o2 ibias vss vss sky130_fd_pr__nfet_01v8 L=0.5u W=1u
M408 o2 ibias vss vss sky130_fd_pr__nfet_01v8 L=0.5u W=1u
M409 o2 ibias vss vss sky130_fd_pr__nfet_01v8 L=0.5u W=1u
M410 o2 ibias vss vss sky130_fd_pr__nfet_01v8 L=0.5u W=1u
M411 o2 ibias vss vss sky130_fd_pr__nfet_01v8 L=0.5u W=1u
M412 o2 ibias vss vss sky130_fd_pr__nfet_01v8 L=0.5u W=1u
M413 o2 ibias vss vss sky130_fd_pr__nfet_01v8 L=0.5u W=1u
M414 o2 ibias vss vss sky130_fd_pr__nfet_01v8 L=0.5u W=1u
M415 o2 ibias vss vss sky130_fd_pr__nfet_01v8 L=0.5u W=1u
M416 o2 ibias vss vss sky130_fd_pr__nfet_01v8 L=0.5u W=1u
M417 o2 ibias vss vss sky130_fd_pr__nfet_01v8 L=0.5u W=1u
M418 o2 ibias vss vss sky130_fd_pr__nfet_01v8 L=0.5u W=1u
M419 o2 ibias vss vss sky130_fd_pr__nfet_01v8 L=0.5u W=1u
M420 o2 ibias vss vss sky130_fd_pr__nfet_01v8 L=0.5u W=1u
M421 o2 ibias vss vss sky130_fd_pr__nfet_01v8 L=0.5u W=1u
M422 o2 ibias vss vss sky130_fd_pr__nfet_01v8 L=0.5u W=1u
M423 o2 ibias vss vss sky130_fd_pr__nfet_01v8 L=0.5u W=1u
M424 o2 ibias vss vss sky130_fd_pr__nfet_01v8 L=0.5u W=1u
M425 o2 ibias vss vss sky130_fd_pr__nfet_01v8 L=0.5u W=1u
M426 o2 ibias vss vss sky130_fd_pr__nfet_01v8 L=0.5u W=1u
M427 o2 ibias vss vss sky130_fd_pr__nfet_01v8 L=0.5u W=1u
M428 o2 ibias vss vss sky130_fd_pr__nfet_01v8 L=0.5u W=1u
M429 o2 ibias vss vss sky130_fd_pr__nfet_01v8 L=0.5u W=1u
M430 o2 ibias vss vss sky130_fd_pr__nfet_01v8 L=0.5u W=1u
M431 o2 ibias vss vss sky130_fd_pr__nfet_01v8 L=0.5u W=1u
M432 o2 ibias vss vss sky130_fd_pr__nfet_01v8 L=0.5u W=1u
M433 o2 ibias vss vss sky130_fd_pr__nfet_01v8 L=0.5u W=1u
M434 o2 ibias vss vss sky130_fd_pr__nfet_01v8 L=0.5u W=1u
M435 o2 ibias vss vss sky130_fd_pr__nfet_01v8 L=0.5u W=1u
M436 o2 ibias vss vss sky130_fd_pr__nfet_01v8 L=0.5u W=1u
M437 o2 ibias vss vss sky130_fd_pr__nfet_01v8 L=0.5u W=1u
M438 o2 ibias vss vss sky130_fd_pr__nfet_01v8 L=0.5u W=1u
M439 o2 ibias vss vss sky130_fd_pr__nfet_01v8 L=0.5u W=1u
M440 o2 ibias vss vss sky130_fd_pr__nfet_01v8 L=0.5u W=1u
M441 o2 ibias vss vss sky130_fd_pr__nfet_01v8 L=0.5u W=1u
M442 o2 ibias vss vss sky130_fd_pr__nfet_01v8 L=0.5u W=1u
M443 o2 ibias vss vss sky130_fd_pr__nfet_01v8 L=0.5u W=1u
M444 o2 ibias vss vss sky130_fd_pr__nfet_01v8 L=0.5u W=1u
M445 o2 ibias vss vss sky130_fd_pr__nfet_01v8 L=0.5u W=1u
M446 o2 ibias vss vss sky130_fd_pr__nfet_01v8 L=0.5u W=1u
M447 o2 ibias vss vss sky130_fd_pr__nfet_01v8 L=0.5u W=1u
M448 o2 ibias vss vss sky130_fd_pr__nfet_01v8 L=0.5u W=1u
M449 o2 ibias vss vss sky130_fd_pr__nfet_01v8 L=0.5u W=1u
M450 o2 ibias vss vss sky130_fd_pr__nfet_01v8 L=0.5u W=1u
M451 o2 ibias vss vss sky130_fd_pr__nfet_01v8 L=0.5u W=1u
M452 o2 ibias vss vss sky130_fd_pr__nfet_01v8 L=0.5u W=1u
M453 o2 ibias vss vss sky130_fd_pr__nfet_01v8 L=0.5u W=1u
M454 o2 ibias vss vss sky130_fd_pr__nfet_01v8 L=0.5u W=1u
M455 o2 ibias vss vss sky130_fd_pr__nfet_01v8 L=0.5u W=1u
M456 o2 ibias vss vss sky130_fd_pr__nfet_01v8 L=0.5u W=1u
M457 o2 ibias vss vss sky130_fd_pr__nfet_01v8 L=0.5u W=1u
M458 o2 ibias vss vss sky130_fd_pr__nfet_01v8 L=0.5u W=1u
M459 o2 ibias vss vss sky130_fd_pr__nfet_01v8 L=0.5u W=1u
M460 o2 ibias vss vss sky130_fd_pr__nfet_01v8 L=0.5u W=1u
M461 o2 ibias vss vss sky130_fd_pr__nfet_01v8 L=0.5u W=1u
M462 o2 ibias vss vss sky130_fd_pr__nfet_01v8 L=0.5u W=1u
M463 o2 ibias vss vss sky130_fd_pr__nfet_01v8 L=0.5u W=1u
M464 o2 ibias vss vss sky130_fd_pr__nfet_01v8 L=0.5u W=1u
M465 o2 ibias vss vss sky130_fd_pr__nfet_01v8 L=0.5u W=1u
M466 o2 ibias vss vss sky130_fd_pr__nfet_01v8 L=0.5u W=1u
M467 o2 ibias vss vss sky130_fd_pr__nfet_01v8 L=0.5u W=1u
M468 o2 ibias vss vss sky130_fd_pr__nfet_01v8 L=0.5u W=1u
M469 o2 ibias vss vss sky130_fd_pr__nfet_01v8 L=0.5u W=1u
M470 o2 ibias vss vss sky130_fd_pr__nfet_01v8 L=0.5u W=1u
M471 o2 ibias vss vss sky130_fd_pr__nfet_01v8 L=0.5u W=1u
M472 o2 ibias vss vss sky130_fd_pr__nfet_01v8 L=0.5u W=1u
M473 o2 ibias vss vss sky130_fd_pr__nfet_01v8 L=0.5u W=1u
M474 o2 ibias vss vss sky130_fd_pr__nfet_01v8 L=0.5u W=1u
M475 o2 ibias vss vss sky130_fd_pr__nfet_01v8 L=0.5u W=1u
M476 o2 ibias vss vss sky130_fd_pr__nfet_01v8 L=0.5u W=1u
M477 o2 ibias vss vss sky130_fd_pr__nfet_01v8 L=0.5u W=1u
M478 o2 ibias vss vss sky130_fd_pr__nfet_01v8 L=0.5u W=1u
M479 o2 ibias vss vss sky130_fd_pr__nfet_01v8 L=0.5u W=1u
M480 o2 ibias vss vss sky130_fd_pr__nfet_01v8 L=0.5u W=1u
M481 o2 ibias vss vss sky130_fd_pr__nfet_01v8 L=0.5u W=1u
M482 o2 ibias vss vss sky130_fd_pr__nfet_01v8 L=0.5u W=1u
M483 o2 ibias vss vss sky130_fd_pr__nfet_01v8 L=0.5u W=1u
M484 o2 ibias vss vss sky130_fd_pr__nfet_01v8 L=0.5u W=1u
M485 o2 ibias vss vss sky130_fd_pr__nfet_01v8 L=0.5u W=1u
M486 o2 ibias vss vss sky130_fd_pr__nfet_01v8 L=0.5u W=1u
M487 o2 ibias vss vss sky130_fd_pr__nfet_01v8 L=0.5u W=1u
M488 o2 ibias vss vss sky130_fd_pr__nfet_01v8 L=0.5u W=1u
M489 o2 ibias vss vss sky130_fd_pr__nfet_01v8 L=0.5u W=1u
M490 o2 ibias vss vss sky130_fd_pr__nfet_01v8 L=0.5u W=1u
M491 o2 ibias vss vss sky130_fd_pr__nfet_01v8 L=0.5u W=1u
M492 o2 ibias vss vss sky130_fd_pr__nfet_01v8 L=0.5u W=1u
M493 o2 ibias vss vss sky130_fd_pr__nfet_01v8 L=0.5u W=1u
M494 o2 ibias vss vss sky130_fd_pr__nfet_01v8 L=0.5u W=1u
M495 o2 ibias vss vss sky130_fd_pr__nfet_01v8 L=0.5u W=1u
M496 o2 ibias vss vss sky130_fd_pr__nfet_01v8 L=0.5u W=1u
M497 o2 ibias vss vss sky130_fd_pr__nfet_01v8 L=0.5u W=1u
M498 o2 ibias vss vss sky130_fd_pr__nfet_01v8 L=0.5u W=1u
M499 o2 ibias vss vss sky130_fd_pr__nfet_01v8 L=0.5u W=1u
M500 o2 ibias vss vss sky130_fd_pr__nfet_01v8 L=0.5u W=1u
M501 o2 ibias vss vss sky130_fd_pr__nfet_01v8 L=0.5u W=1u
M502 o2 ibias vss vss sky130_fd_pr__nfet_01v8 L=0.5u W=1u
M503 o2 ibias vss vss sky130_fd_pr__nfet_01v8 L=0.5u W=1u
M504 o2 ibias vss vss sky130_fd_pr__nfet_01v8 L=0.5u W=1u
M505 o2 ibias vss vss sky130_fd_pr__nfet_01v8 L=0.5u W=1u
M506 o2 ibias vss vss sky130_fd_pr__nfet_01v8 L=0.5u W=1u
M507 o2 ibias vss vss sky130_fd_pr__nfet_01v8 L=0.5u W=1u
M508 o2 ibias vss vss sky130_fd_pr__nfet_01v8 L=0.5u W=1u
M509 o2 ibias vss vss sky130_fd_pr__nfet_01v8 L=0.5u W=1u
M510 o2 ibias vss vss sky130_fd_pr__nfet_01v8 L=0.5u W=1u
M511 o2 ibias vss vss sky130_fd_pr__nfet_01v8 L=0.5u W=1u
M512 o2 ibias vss vss sky130_fd_pr__nfet_01v8 L=0.5u W=1u
M513 o2 ibias vss vss sky130_fd_pr__nfet_01v8 L=0.5u W=1u
M514 o2 ibias vss vss sky130_fd_pr__nfet_01v8 L=0.5u W=1u
M515 o2 ibias vss vss sky130_fd_pr__nfet_01v8 L=0.5u W=1u
M516 o2 ibias vss vss sky130_fd_pr__nfet_01v8 L=0.5u W=1u
M517 o2 ibias vss vss sky130_fd_pr__nfet_01v8 L=0.5u W=1u
M518 o2 ibias vss vss sky130_fd_pr__nfet_01v8 L=0.5u W=1u
M519 o2 ibias vss vss sky130_fd_pr__nfet_01v8 L=0.5u W=1u
M520 o2 ibias vss vss sky130_fd_pr__nfet_01v8 L=0.5u W=1u
M521 o2 ibias vss vss sky130_fd_pr__nfet_01v8 L=0.5u W=1u
M522 o2 ibias vss vss sky130_fd_pr__nfet_01v8 L=0.5u W=1u
M523 o2 ibias vss vss sky130_fd_pr__nfet_01v8 L=0.5u W=1u
M524 o2 ibias vss vss sky130_fd_pr__nfet_01v8 L=0.5u W=1u
M525 o2 ibias vss vss sky130_fd_pr__nfet_01v8 L=0.5u W=1u
M526 o2 ibias vss vss sky130_fd_pr__nfet_01v8 L=0.5u W=1u
M527 o2 ibias vss vss sky130_fd_pr__nfet_01v8 L=0.5u W=1u
M528 o2 ibias vss vss sky130_fd_pr__nfet_01v8 L=0.5u W=1u
M529 o2 ibias vss vss sky130_fd_pr__nfet_01v8 L=0.5u W=1u
M530 o2 ibias vss vss sky130_fd_pr__nfet_01v8 L=0.5u W=1u
M531 o2 ibias vss vss sky130_fd_pr__nfet_01v8 L=0.5u W=1u
M532 o2 ibias vss vss sky130_fd_pr__nfet_01v8 L=0.5u W=1u
M533 o2 ibias vss vss sky130_fd_pr__nfet_01v8 L=0.5u W=1u
M534 o2 ibias vss vss sky130_fd_pr__nfet_01v8 L=0.5u W=1u
M535 o2 ibias vss vss sky130_fd_pr__nfet_01v8 L=0.5u W=1u
M536 o2 ibias vss vss sky130_fd_pr__nfet_01v8 L=0.5u W=1u
M537 o2 ibias vss vss sky130_fd_pr__nfet_01v8 L=0.5u W=1u
M538 o2 ibias vss vss sky130_fd_pr__nfet_01v8 L=0.5u W=1u
M539 o2 ibias vss vss sky130_fd_pr__nfet_01v8 L=0.5u W=1u
M540 o2 ibias vss vss sky130_fd_pr__nfet_01v8 L=0.5u W=1u
M541 o2 ibias vss vss sky130_fd_pr__nfet_01v8 L=0.5u W=1u
M542 o2 ibias vss vss sky130_fd_pr__nfet_01v8 L=0.5u W=1u
M543 o2 ibias vss vss sky130_fd_pr__nfet_01v8 L=0.5u W=1u
M544 o2 ibias vss vss sky130_fd_pr__nfet_01v8 L=0.5u W=1u
M545 o2 ibias vss vss sky130_fd_pr__nfet_01v8 L=0.5u W=1u
M546 o2 ibias vss vss sky130_fd_pr__nfet_01v8 L=0.5u W=1u
M547 o2 ibias vss vss sky130_fd_pr__nfet_01v8 L=0.5u W=1u
M548 o2 ibias vss vss sky130_fd_pr__nfet_01v8 L=0.5u W=1u
M549 o2 ibias vss vss sky130_fd_pr__nfet_01v8 L=0.5u W=1u
M550 o2 ibias vss vss sky130_fd_pr__nfet_01v8 L=0.5u W=1u
M551 o2 ibias vss vss sky130_fd_pr__nfet_01v8 L=0.5u W=1u
M552 o2 ibias vss vss sky130_fd_pr__nfet_01v8 L=0.5u W=1u
M553 o2 ibias vss vss sky130_fd_pr__nfet_01v8 L=0.5u W=1u
M554 o2 ibias vss vss sky130_fd_pr__nfet_01v8 L=0.5u W=1u
M555 o2 ibias vss vss sky130_fd_pr__nfet_01v8 L=0.5u W=1u
M556 o2 ibias vss vss sky130_fd_pr__nfet_01v8 L=0.5u W=1u
M557 o2 ibias vss vss sky130_fd_pr__nfet_01v8 L=0.5u W=1u
M558 o2 ibias vss vss sky130_fd_pr__nfet_01v8 L=0.5u W=1u
M559 o2 ibias vss vss sky130_fd_pr__nfet_01v8 L=0.5u W=1u
M560 o2 ibias vss vss sky130_fd_pr__nfet_01v8 L=0.5u W=1u
M561 o2 ibias vss vss sky130_fd_pr__nfet_01v8 L=0.5u W=1u
M562 o2 ibias vss vss sky130_fd_pr__nfet_01v8 L=0.5u W=1u
M563 o2 ibias vss vss sky130_fd_pr__nfet_01v8 L=0.5u W=1u
M564 o2 ibias vss vss sky130_fd_pr__nfet_01v8 L=0.5u W=1u
M565 o2 ibias vss vss sky130_fd_pr__nfet_01v8 L=0.5u W=1u
M566 o2 ibias vss vss sky130_fd_pr__nfet_01v8 L=0.5u W=1u
M567 o2 ibias vss vss sky130_fd_pr__nfet_01v8 L=0.5u W=1u
M568 o3 ibias vss vss sky130_fd_pr__nfet_01v8 L=0.5u W=1u
M569 o3 ibias vss vss sky130_fd_pr__nfet_01v8 L=0.5u W=1u
M570 o3 ibias vss vss sky130_fd_pr__nfet_01v8 L=0.5u W=1u
M571 o3 ibias vss vss sky130_fd_pr__nfet_01v8 L=0.5u W=1u
M572 o3 ibias vss vss sky130_fd_pr__nfet_01v8 L=0.5u W=1u
M573 o3 ibias vss vss sky130_fd_pr__nfet_01v8 L=0.5u W=1u
M574 o3 ibias vss vss sky130_fd_pr__nfet_01v8 L=0.5u W=1u
M575 o3 ibias vss vss sky130_fd_pr__nfet_01v8 L=0.5u W=1u
M576 o3 ibias vss vss sky130_fd_pr__nfet_01v8 L=0.5u W=1u
M577 o3 ibias vss vss sky130_fd_pr__nfet_01v8 L=0.5u W=1u
M578 o3 ibias vss vss sky130_fd_pr__nfet_01v8 L=0.5u W=1u
M579 o3 ibias vss vss sky130_fd_pr__nfet_01v8 L=0.5u W=1u
M580 o3 ibias vss vss sky130_fd_pr__nfet_01v8 L=0.5u W=1u
M581 o3 ibias vss vss sky130_fd_pr__nfet_01v8 L=0.5u W=1u
M582 o3 ibias vss vss sky130_fd_pr__nfet_01v8 L=0.5u W=1u
M583 o3 ibias vss vss sky130_fd_pr__nfet_01v8 L=0.5u W=1u
M584 o3 ibias vss vss sky130_fd_pr__nfet_01v8 L=0.5u W=1u
M585 o3 ibias vss vss sky130_fd_pr__nfet_01v8 L=0.5u W=1u
M586 o3 ibias vss vss sky130_fd_pr__nfet_01v8 L=0.5u W=1u
M587 o3 ibias vss vss sky130_fd_pr__nfet_01v8 L=0.5u W=1u
M588 o3 ibias vss vss sky130_fd_pr__nfet_01v8 L=0.5u W=1u
M589 o3 ibias vss vss sky130_fd_pr__nfet_01v8 L=0.5u W=1u
M590 o3 ibias vss vss sky130_fd_pr__nfet_01v8 L=0.5u W=1u
M591 o3 ibias vss vss sky130_fd_pr__nfet_01v8 L=0.5u W=1u
M592 o3 ibias vss vss sky130_fd_pr__nfet_01v8 L=0.5u W=1u
M593 o3 ibias vss vss sky130_fd_pr__nfet_01v8 L=0.5u W=1u
M594 o3 ibias vss vss sky130_fd_pr__nfet_01v8 L=0.5u W=1u
M595 o3 ibias vss vss sky130_fd_pr__nfet_01v8 L=0.5u W=1u
M596 o3 ibias vss vss sky130_fd_pr__nfet_01v8 L=0.5u W=1u
M597 o3 ibias vss vss sky130_fd_pr__nfet_01v8 L=0.5u W=1u
M598 o3 ibias vss vss sky130_fd_pr__nfet_01v8 L=0.5u W=1u
M599 o3 ibias vss vss sky130_fd_pr__nfet_01v8 L=0.5u W=1u
M600 o3 ibias vss vss sky130_fd_pr__nfet_01v8 L=0.5u W=1u
M601 o3 ibias vss vss sky130_fd_pr__nfet_01v8 L=0.5u W=1u
M602 o3 ibias vss vss sky130_fd_pr__nfet_01v8 L=0.5u W=1u
M603 o3 ibias vss vss sky130_fd_pr__nfet_01v8 L=0.5u W=1u
M604 o3 ibias vss vss sky130_fd_pr__nfet_01v8 L=0.5u W=1u
M605 o3 ibias vss vss sky130_fd_pr__nfet_01v8 L=0.5u W=1u
M606 o3 ibias vss vss sky130_fd_pr__nfet_01v8 L=0.5u W=1u
M607 o3 ibias vss vss sky130_fd_pr__nfet_01v8 L=0.5u W=1u
M608 o3 ibias vss vss sky130_fd_pr__nfet_01v8 L=0.5u W=1u
M609 o3 ibias vss vss sky130_fd_pr__nfet_01v8 L=0.5u W=1u
M610 o3 ibias vss vss sky130_fd_pr__nfet_01v8 L=0.5u W=1u
M611 o3 ibias vss vss sky130_fd_pr__nfet_01v8 L=0.5u W=1u
M612 o3 ibias vss vss sky130_fd_pr__nfet_01v8 L=0.5u W=1u
M613 o3 ibias vss vss sky130_fd_pr__nfet_01v8 L=0.5u W=1u
M614 o3 ibias vss vss sky130_fd_pr__nfet_01v8 L=0.5u W=1u
M615 o3 ibias vss vss sky130_fd_pr__nfet_01v8 L=0.5u W=1u
M616 o3 ibias vss vss sky130_fd_pr__nfet_01v8 L=0.5u W=1u
M617 o3 ibias vss vss sky130_fd_pr__nfet_01v8 L=0.5u W=1u
M618 o3 ibias vss vss sky130_fd_pr__nfet_01v8 L=0.5u W=1u
M619 o3 ibias vss vss sky130_fd_pr__nfet_01v8 L=0.5u W=1u
M620 o3 ibias vss vss sky130_fd_pr__nfet_01v8 L=0.5u W=1u
M621 o3 ibias vss vss sky130_fd_pr__nfet_01v8 L=0.5u W=1u
M622 o3 ibias vss vss sky130_fd_pr__nfet_01v8 L=0.5u W=1u
M623 o3 ibias vss vss sky130_fd_pr__nfet_01v8 L=0.5u W=1u
M624 o3 ibias vss vss sky130_fd_pr__nfet_01v8 L=0.5u W=1u
M625 o3 ibias vss vss sky130_fd_pr__nfet_01v8 L=0.5u W=1u
M626 o3 ibias vss vss sky130_fd_pr__nfet_01v8 L=0.5u W=1u
M627 o3 ibias vss vss sky130_fd_pr__nfet_01v8 L=0.5u W=1u
M628 o3 ibias vss vss sky130_fd_pr__nfet_01v8 L=0.5u W=1u
M629 o3 ibias vss vss sky130_fd_pr__nfet_01v8 L=0.5u W=1u
M630 o3 ibias vss vss sky130_fd_pr__nfet_01v8 L=0.5u W=1u
M631 o3 ibias vss vss sky130_fd_pr__nfet_01v8 L=0.5u W=1u
M632 o3 ibias vss vss sky130_fd_pr__nfet_01v8 L=0.5u W=1u
M633 o3 ibias vss vss sky130_fd_pr__nfet_01v8 L=0.5u W=1u
M634 o3 ibias vss vss sky130_fd_pr__nfet_01v8 L=0.5u W=1u
M635 o3 ibias vss vss sky130_fd_pr__nfet_01v8 L=0.5u W=1u
M636 o3 ibias vss vss sky130_fd_pr__nfet_01v8 L=0.5u W=1u
M637 o3 ibias vss vss sky130_fd_pr__nfet_01v8 L=0.5u W=1u
M638 o3 ibias vss vss sky130_fd_pr__nfet_01v8 L=0.5u W=1u
M639 o3 ibias vss vss sky130_fd_pr__nfet_01v8 L=0.5u W=1u
M640 o3 ibias vss vss sky130_fd_pr__nfet_01v8 L=0.5u W=1u
M641 o3 ibias vss vss sky130_fd_pr__nfet_01v8 L=0.5u W=1u
M642 o3 ibias vss vss sky130_fd_pr__nfet_01v8 L=0.5u W=1u
M643 o3 ibias vss vss sky130_fd_pr__nfet_01v8 L=0.5u W=1u
M644 o3 ibias vss vss sky130_fd_pr__nfet_01v8 L=0.5u W=1u
M645 o3 ibias vss vss sky130_fd_pr__nfet_01v8 L=0.5u W=1u
M646 o3 ibias vss vss sky130_fd_pr__nfet_01v8 L=0.5u W=1u
M647 o3 ibias vss vss sky130_fd_pr__nfet_01v8 L=0.5u W=1u
M648 o3 ibias vss vss sky130_fd_pr__nfet_01v8 L=0.5u W=1u
M649 o3 ibias vss vss sky130_fd_pr__nfet_01v8 L=0.5u W=1u
M650 o3 ibias vss vss sky130_fd_pr__nfet_01v8 L=0.5u W=1u
M651 o3 ibias vss vss sky130_fd_pr__nfet_01v8 L=0.5u W=1u
M652 o3 ibias vss vss sky130_fd_pr__nfet_01v8 L=0.5u W=1u
M653 o3 ibias vss vss sky130_fd_pr__nfet_01v8 L=0.5u W=1u
M654 o3 ibias vss vss sky130_fd_pr__nfet_01v8 L=0.5u W=1u
M655 o3 ibias vss vss sky130_fd_pr__nfet_01v8 L=0.5u W=1u
M656 o3 ibias vss vss sky130_fd_pr__nfet_01v8 L=0.5u W=1u
M657 o3 ibias vss vss sky130_fd_pr__nfet_01v8 L=0.5u W=1u
M658 o3 ibias vss vss sky130_fd_pr__nfet_01v8 L=0.5u W=1u
M659 o3 ibias vss vss sky130_fd_pr__nfet_01v8 L=0.5u W=1u
M660 o3 ibias vss vss sky130_fd_pr__nfet_01v8 L=0.5u W=1u
M661 o3 ibias vss vss sky130_fd_pr__nfet_01v8 L=0.5u W=1u
M662 o3 ibias vss vss sky130_fd_pr__nfet_01v8 L=0.5u W=1u
M663 o3 ibias vss vss sky130_fd_pr__nfet_01v8 L=0.5u W=1u
M664 o3 ibias vss vss sky130_fd_pr__nfet_01v8 L=0.5u W=1u
M665 o3 ibias vss vss sky130_fd_pr__nfet_01v8 L=0.5u W=1u
M666 o3 ibias vss vss sky130_fd_pr__nfet_01v8 L=0.5u W=1u
M667 o3 ibias vss vss sky130_fd_pr__nfet_01v8 L=0.5u W=1u
M668 o3 ibias vss vss sky130_fd_pr__nfet_01v8 L=0.5u W=1u
M669 o3 ibias vss vss sky130_fd_pr__nfet_01v8 L=0.5u W=1u
M670 o3 ibias vss vss sky130_fd_pr__nfet_01v8 L=0.5u W=1u
M671 o3 ibias vss vss sky130_fd_pr__nfet_01v8 L=0.5u W=1u
M672 o3 ibias vss vss sky130_fd_pr__nfet_01v8 L=0.5u W=1u
M673 o3 ibias vss vss sky130_fd_pr__nfet_01v8 L=0.5u W=1u
M674 o3 ibias vss vss sky130_fd_pr__nfet_01v8 L=0.5u W=1u
M675 o3 ibias vss vss sky130_fd_pr__nfet_01v8 L=0.5u W=1u
M676 o3 ibias vss vss sky130_fd_pr__nfet_01v8 L=0.5u W=1u
M677 o3 ibias vss vss sky130_fd_pr__nfet_01v8 L=0.5u W=1u
M678 o3 ibias vss vss sky130_fd_pr__nfet_01v8 L=0.5u W=1u
M679 o3 ibias vss vss sky130_fd_pr__nfet_01v8 L=0.5u W=1u
M680 o3 ibias vss vss sky130_fd_pr__nfet_01v8 L=0.5u W=1u
M681 o3 ibias vss vss sky130_fd_pr__nfet_01v8 L=0.5u W=1u
M682 o3 ibias vss vss sky130_fd_pr__nfet_01v8 L=0.5u W=1u
M683 o3 ibias vss vss sky130_fd_pr__nfet_01v8 L=0.5u W=1u
M684 o3 ibias vss vss sky130_fd_pr__nfet_01v8 L=0.5u W=1u
M685 o3 ibias vss vss sky130_fd_pr__nfet_01v8 L=0.5u W=1u
M686 o3 ibias vss vss sky130_fd_pr__nfet_01v8 L=0.5u W=1u
M687 o3 ibias vss vss sky130_fd_pr__nfet_01v8 L=0.5u W=1u
M688 o3 ibias vss vss sky130_fd_pr__nfet_01v8 L=0.5u W=1u
M689 o3 ibias vss vss sky130_fd_pr__nfet_01v8 L=0.5u W=1u
M690 o3 ibias vss vss sky130_fd_pr__nfet_01v8 L=0.5u W=1u
M691 o3 ibias vss vss sky130_fd_pr__nfet_01v8 L=0.5u W=1u
M692 o3 ibias vss vss sky130_fd_pr__nfet_01v8 L=0.5u W=1u
M693 o3 ibias vss vss sky130_fd_pr__nfet_01v8 L=0.5u W=1u
M694 o3 ibias vss vss sky130_fd_pr__nfet_01v8 L=0.5u W=1u
M695 o3 ibias vss vss sky130_fd_pr__nfet_01v8 L=0.5u W=1u
M696 o3 ibias vss vss sky130_fd_pr__nfet_01v8 L=0.5u W=1u
M697 o3 ibias vss vss sky130_fd_pr__nfet_01v8 L=0.5u W=1u
M698 o3 ibias vss vss sky130_fd_pr__nfet_01v8 L=0.5u W=1u
M699 o3 ibias vss vss sky130_fd_pr__nfet_01v8 L=0.5u W=1u
M700 o3 ibias vss vss sky130_fd_pr__nfet_01v8 L=0.5u W=1u
M701 o3 ibias vss vss sky130_fd_pr__nfet_01v8 L=0.5u W=1u
M702 o3 ibias vss vss sky130_fd_pr__nfet_01v8 L=0.5u W=1u
M703 o3 ibias vss vss sky130_fd_pr__nfet_01v8 L=0.5u W=1u
M704 o3 ibias vss vss sky130_fd_pr__nfet_01v8 L=0.5u W=1u
M705 o3 ibias vss vss sky130_fd_pr__nfet_01v8 L=0.5u W=1u
M706 o3 ibias vss vss sky130_fd_pr__nfet_01v8 L=0.5u W=1u
M707 o3 ibias vss vss sky130_fd_pr__nfet_01v8 L=0.5u W=1u
M708 o3 ibias vss vss sky130_fd_pr__nfet_01v8 L=0.5u W=1u
M709 o3 ibias vss vss sky130_fd_pr__nfet_01v8 L=0.5u W=1u
M710 o3 ibias vss vss sky130_fd_pr__nfet_01v8 L=0.5u W=1u
M711 o3 ibias vss vss sky130_fd_pr__nfet_01v8 L=0.5u W=1u
M712 o3 ibias vss vss sky130_fd_pr__nfet_01v8 L=0.5u W=1u
M713 o3 ibias vss vss sky130_fd_pr__nfet_01v8 L=0.5u W=1u
M714 o3 ibias vss vss sky130_fd_pr__nfet_01v8 L=0.5u W=1u
M715 o3 ibias vss vss sky130_fd_pr__nfet_01v8 L=0.5u W=1u
M716 o3 ibias vss vss sky130_fd_pr__nfet_01v8 L=0.5u W=1u
M717 o3 ibias vss vss sky130_fd_pr__nfet_01v8 L=0.5u W=1u
M718 o3 ibias vss vss sky130_fd_pr__nfet_01v8 L=0.5u W=1u
M719 o3 ibias vss vss sky130_fd_pr__nfet_01v8 L=0.5u W=1u
M720 o3 ibias vss vss sky130_fd_pr__nfet_01v8 L=0.5u W=1u
M721 o3 ibias vss vss sky130_fd_pr__nfet_01v8 L=0.5u W=1u
M722 o3 ibias vss vss sky130_fd_pr__nfet_01v8 L=0.5u W=1u
M723 o3 ibias vss vss sky130_fd_pr__nfet_01v8 L=0.5u W=1u
M724 o3 ibias vss vss sky130_fd_pr__nfet_01v8 L=0.5u W=1u
M725 o3 ibias vss vss sky130_fd_pr__nfet_01v8 L=0.5u W=1u
M726 o3 ibias vss vss sky130_fd_pr__nfet_01v8 L=0.5u W=1u
M727 o3 ibias vss vss sky130_fd_pr__nfet_01v8 L=0.5u W=1u
M728 o3 ibias vss vss sky130_fd_pr__nfet_01v8 L=0.5u W=1u
M729 o3 ibias vss vss sky130_fd_pr__nfet_01v8 L=0.5u W=1u
M730 o3 ibias vss vss sky130_fd_pr__nfet_01v8 L=0.5u W=1u
M731 o3 ibias vss vss sky130_fd_pr__nfet_01v8 L=0.5u W=1u
M732 o3 ibias vss vss sky130_fd_pr__nfet_01v8 L=0.5u W=1u
M733 o3 ibias vss vss sky130_fd_pr__nfet_01v8 L=0.5u W=1u
M734 o3 ibias vss vss sky130_fd_pr__nfet_01v8 L=0.5u W=1u
M735 o3 ibias vss vss sky130_fd_pr__nfet_01v8 L=0.5u W=1u
M736 o3 ibias vss vss sky130_fd_pr__nfet_01v8 L=0.5u W=1u
M737 o3 ibias vss vss sky130_fd_pr__nfet_01v8 L=0.5u W=1u
M738 o3 ibias vss vss sky130_fd_pr__nfet_01v8 L=0.5u W=1u
M739 o3 ibias vss vss sky130_fd_pr__nfet_01v8 L=0.5u W=1u
M740 o3 ibias vss vss sky130_fd_pr__nfet_01v8 L=0.5u W=1u
M741 o3 ibias vss vss sky130_fd_pr__nfet_01v8 L=0.5u W=1u
M742 o3 ibias vss vss sky130_fd_pr__nfet_01v8 L=0.5u W=1u
M743 o3 ibias vss vss sky130_fd_pr__nfet_01v8 L=0.5u W=1u
M744 o3 ibias vss vss sky130_fd_pr__nfet_01v8 L=0.5u W=1u
M745 o3 ibias vss vss sky130_fd_pr__nfet_01v8 L=0.5u W=1u
M746 o3 ibias vss vss sky130_fd_pr__nfet_01v8 L=0.5u W=1u
M747 o3 ibias vss vss sky130_fd_pr__nfet_01v8 L=0.5u W=1u
M748 o3 ibias vss vss sky130_fd_pr__nfet_01v8 L=0.5u W=1u
M749 o3 ibias vss vss sky130_fd_pr__nfet_01v8 L=0.5u W=1u
M750 o3 ibias vss vss sky130_fd_pr__nfet_01v8 L=0.5u W=1u
M751 o3 ibias vss vss sky130_fd_pr__nfet_01v8 L=0.5u W=1u
M752 o3 ibias vss vss sky130_fd_pr__nfet_01v8 L=0.5u W=1u
M753 o3 ibias vss vss sky130_fd_pr__nfet_01v8 L=0.5u W=1u
M754 o3 ibias vss vss sky130_fd_pr__nfet_01v8 L=0.5u W=1u
M755 o3 ibias vss vss sky130_fd_pr__nfet_01v8 L=0.5u W=1u
M756 o3 ibias vss vss sky130_fd_pr__nfet_01v8 L=0.5u W=1u
M757 o3 ibias vss vss sky130_fd_pr__nfet_01v8 L=0.5u W=1u
M758 o3 ibias vss vss sky130_fd_pr__nfet_01v8 L=0.5u W=1u
M759 o3 ibias vss vss sky130_fd_pr__nfet_01v8 L=0.5u W=1u
M760 o3 ibias vss vss sky130_fd_pr__nfet_01v8 L=0.5u W=1u
M761 o3 ibias vss vss sky130_fd_pr__nfet_01v8 L=0.5u W=1u
M762 o3 ibias vss vss sky130_fd_pr__nfet_01v8 L=0.5u W=1u
M763 o3 ibias vss vss sky130_fd_pr__nfet_01v8 L=0.5u W=1u
M764 o3 ibias vss vss sky130_fd_pr__nfet_01v8 L=0.5u W=1u
M765 o3 ibias vss vss sky130_fd_pr__nfet_01v8 L=0.5u W=1u
M766 o3 ibias vss vss sky130_fd_pr__nfet_01v8 L=0.5u W=1u
M767 o3 ibias vss vss sky130_fd_pr__nfet_01v8 L=0.5u W=1u
M768 o3 ibias vss vss sky130_fd_pr__nfet_01v8 L=0.5u W=1u
M769 o3 ibias vss vss sky130_fd_pr__nfet_01v8 L=0.5u W=1u
M770 o3 ibias vss vss sky130_fd_pr__nfet_01v8 L=0.5u W=1u
M771 o3 ibias vss vss sky130_fd_pr__nfet_01v8 L=0.5u W=1u
M772 o3 ibias vss vss sky130_fd_pr__nfet_01v8 L=0.5u W=1u
M773 o3 ibias vss vss sky130_fd_pr__nfet_01v8 L=0.5u W=1u
M774 o3 ibias vss vss sky130_fd_pr__nfet_01v8 L=0.5u W=1u
M775 o3 ibias vss vss sky130_fd_pr__nfet_01v8 L=0.5u W=1u
M776 o3 ibias vss vss sky130_fd_pr__nfet_01v8 L=0.5u W=1u
M777 o3 ibias vss vss sky130_fd_pr__nfet_01v8 L=0.5u W=1u
M778 o3 ibias vss vss sky130_fd_pr__nfet_01v8 L=0.5u W=1u
M779 o3 ibias vss vss sky130_fd_pr__nfet_01v8 L=0.5u W=1u
M780 o3 ibias vss vss sky130_fd_pr__nfet_01v8 L=0.5u W=1u
M781 o3 ibias vss vss sky130_fd_pr__nfet_01v8 L=0.5u W=1u
M782 o3 ibias vss vss sky130_fd_pr__nfet_01v8 L=0.5u W=1u
M783 o3 ibias vss vss sky130_fd_pr__nfet_01v8 L=0.5u W=1u
M784 o3 ibias vss vss sky130_fd_pr__nfet_01v8 L=0.5u W=1u
M785 o3 ibias vss vss sky130_fd_pr__nfet_01v8 L=0.5u W=1u
M786 o3 ibias vss vss sky130_fd_pr__nfet_01v8 L=0.5u W=1u
M787 o3 ibias vss vss sky130_fd_pr__nfet_01v8 L=0.5u W=1u
M788 o3 ibias vss vss sky130_fd_pr__nfet_01v8 L=0.5u W=1u
M789 o3 ibias vss vss sky130_fd_pr__nfet_01v8 L=0.5u W=1u
M790 o3 ibias vss vss sky130_fd_pr__nfet_01v8 L=0.5u W=1u
M791 o3 ibias vss vss sky130_fd_pr__nfet_01v8 L=0.5u W=1u
M792 o3 ibias vss vss sky130_fd_pr__nfet_01v8 L=0.5u W=1u
M793 o3 ibias vss vss sky130_fd_pr__nfet_01v8 L=0.5u W=1u
M794 o3 ibias vss vss sky130_fd_pr__nfet_01v8 L=0.5u W=1u
M795 o3 ibias vss vss sky130_fd_pr__nfet_01v8 L=0.5u W=1u
M796 o3 ibias vss vss sky130_fd_pr__nfet_01v8 L=0.5u W=1u
M797 o3 ibias vss vss sky130_fd_pr__nfet_01v8 L=0.5u W=1u
M798 o3 ibias vss vss sky130_fd_pr__nfet_01v8 L=0.5u W=1u
M799 o3 ibias vss vss sky130_fd_pr__nfet_01v8 L=0.5u W=1u
M800 o3 ibias vss vss sky130_fd_pr__nfet_01v8 L=0.5u W=1u
M801 o3 ibias vss vss sky130_fd_pr__nfet_01v8 L=0.5u W=1u
M802 o3 ibias vss vss sky130_fd_pr__nfet_01v8 L=0.5u W=1u
M803 o3 ibias vss vss sky130_fd_pr__nfet_01v8 L=0.5u W=1u
M804 o3 ibias vss vss sky130_fd_pr__nfet_01v8 L=0.5u W=1u
M805 o3 ibias vss vss sky130_fd_pr__nfet_01v8 L=0.5u W=1u
M806 o3 ibias vss vss sky130_fd_pr__nfet_01v8 L=0.5u W=1u
M807 o3 ibias vss vss sky130_fd_pr__nfet_01v8 L=0.5u W=1u
M808 o3 ibias vss vss sky130_fd_pr__nfet_01v8 L=0.5u W=1u
M809 o3 ibias vss vss sky130_fd_pr__nfet_01v8 L=0.5u W=1u
M810 o3 ibias vss vss sky130_fd_pr__nfet_01v8 L=0.5u W=1u
M811 o3 ibias vss vss sky130_fd_pr__nfet_01v8 L=0.5u W=1u
M812 o3 ibias vss vss sky130_fd_pr__nfet_01v8 L=0.5u W=1u
M813 o3 ibias vss vss sky130_fd_pr__nfet_01v8 L=0.5u W=1u
M814 o3 ibias vss vss sky130_fd_pr__nfet_01v8 L=0.5u W=1u
M815 o3 ibias vss vss sky130_fd_pr__nfet_01v8 L=0.5u W=1u
M816 o3 ibias vss vss sky130_fd_pr__nfet_01v8 L=0.5u W=1u
M817 o3 ibias vss vss sky130_fd_pr__nfet_01v8 L=0.5u W=1u
M818 o3 ibias vss vss sky130_fd_pr__nfet_01v8 L=0.5u W=1u
M819 o3 ibias vss vss sky130_fd_pr__nfet_01v8 L=0.5u W=1u
M820 o3 ibias vss vss sky130_fd_pr__nfet_01v8 L=0.5u W=1u
M821 o3 ibias vss vss sky130_fd_pr__nfet_01v8 L=0.5u W=1u
M822 o3 ibias vss vss sky130_fd_pr__nfet_01v8 L=0.5u W=1u
M823 o3 ibias vss vss sky130_fd_pr__nfet_01v8 L=0.5u W=1u
M824 o3 ibias vss vss sky130_fd_pr__nfet_01v8 L=0.5u W=1u
M825 o3 ibias vss vss sky130_fd_pr__nfet_01v8 L=0.5u W=1u
M826 o3 ibias vss vss sky130_fd_pr__nfet_01v8 L=0.5u W=1u
M827 o3 ibias vss vss sky130_fd_pr__nfet_01v8 L=0.5u W=1u
M828 o3 ibias vss vss sky130_fd_pr__nfet_01v8 L=0.5u W=1u
M829 o3 ibias vss vss sky130_fd_pr__nfet_01v8 L=0.5u W=1u
M830 o3 ibias vss vss sky130_fd_pr__nfet_01v8 L=0.5u W=1u
M831 o3 ibias vss vss sky130_fd_pr__nfet_01v8 L=0.5u W=1u
M832 o3 ibias vss vss sky130_fd_pr__nfet_01v8 L=0.5u W=1u
M833 o3 ibias vss vss sky130_fd_pr__nfet_01v8 L=0.5u W=1u
M834 o3 ibias vss vss sky130_fd_pr__nfet_01v8 L=0.5u W=1u
M835 o3 ibias vss vss sky130_fd_pr__nfet_01v8 L=0.5u W=1u
M836 o3 ibias vss vss sky130_fd_pr__nfet_01v8 L=0.5u W=1u
M837 o3 ibias vss vss sky130_fd_pr__nfet_01v8 L=0.5u W=1u
M838 o3 ibias vss vss sky130_fd_pr__nfet_01v8 L=0.5u W=1u
M839 o3 ibias vss vss sky130_fd_pr__nfet_01v8 L=0.5u W=1u
M840 o3 ibias vss vss sky130_fd_pr__nfet_01v8 L=0.5u W=1u
M841 o3 ibias vss vss sky130_fd_pr__nfet_01v8 L=0.5u W=1u
M842 o3 ibias vss vss sky130_fd_pr__nfet_01v8 L=0.5u W=1u
M843 o3 ibias vss vss sky130_fd_pr__nfet_01v8 L=0.5u W=1u
M844 o3 ibias vss vss sky130_fd_pr__nfet_01v8 L=0.5u W=1u
M845 o3 ibias vss vss sky130_fd_pr__nfet_01v8 L=0.5u W=1u
M846 o3 ibias vss vss sky130_fd_pr__nfet_01v8 L=0.5u W=1u
M847 o3 ibias vss vss sky130_fd_pr__nfet_01v8 L=0.5u W=1u
M848 o3 ibias vss vss sky130_fd_pr__nfet_01v8 L=0.5u W=1u
M849 o3 ibias vss vss sky130_fd_pr__nfet_01v8 L=0.5u W=1u
M850 o3 ibias vss vss sky130_fd_pr__nfet_01v8 L=0.5u W=1u
M851 o3 ibias vss vss sky130_fd_pr__nfet_01v8 L=0.5u W=1u
M852 o3 ibias vss vss sky130_fd_pr__nfet_01v8 L=0.5u W=1u
M853 o3 ibias vss vss sky130_fd_pr__nfet_01v8 L=0.5u W=1u
M854 o3 ibias vss vss sky130_fd_pr__nfet_01v8 L=0.5u W=1u
M855 o3 ibias vss vss sky130_fd_pr__nfet_01v8 L=0.5u W=1u
M856 o3 ibias vss vss sky130_fd_pr__nfet_01v8 L=0.5u W=1u
M857 o3 ibias vss vss sky130_fd_pr__nfet_01v8 L=0.5u W=1u
M858 o3 ibias vss vss sky130_fd_pr__nfet_01v8 L=0.5u W=1u
M859 o3 ibias vss vss sky130_fd_pr__nfet_01v8 L=0.5u W=1u
M860 o3 ibias vss vss sky130_fd_pr__nfet_01v8 L=0.5u W=1u
M861 o3 ibias vss vss sky130_fd_pr__nfet_01v8 L=0.5u W=1u
M862 o3 ibias vss vss sky130_fd_pr__nfet_01v8 L=0.5u W=1u
M863 o3 ibias vss vss sky130_fd_pr__nfet_01v8 L=0.5u W=1u
M864 o3 ibias vss vss sky130_fd_pr__nfet_01v8 L=0.5u W=1u
M865 o3 ibias vss vss sky130_fd_pr__nfet_01v8 L=0.5u W=1u
M866 o3 ibias vss vss sky130_fd_pr__nfet_01v8 L=0.5u W=1u
M867 o3 ibias vss vss sky130_fd_pr__nfet_01v8 L=0.5u W=1u
M868 o3 ibias vss vss sky130_fd_pr__nfet_01v8 L=0.5u W=1u
M869 o3 ibias vss vss sky130_fd_pr__nfet_01v8 L=0.5u W=1u
M870 o3 ibias vss vss sky130_fd_pr__nfet_01v8 L=0.5u W=1u
M871 o3 ibias vss vss sky130_fd_pr__nfet_01v8 L=0.5u W=1u
M872 o3 ibias vss vss sky130_fd_pr__nfet_01v8 L=0.5u W=1u
M873 o3 ibias vss vss sky130_fd_pr__nfet_01v8 L=0.5u W=1u
M874 o3 ibias vss vss sky130_fd_pr__nfet_01v8 L=0.5u W=1u
M875 o3 ibias vss vss sky130_fd_pr__nfet_01v8 L=0.5u W=1u
M876 o3 ibias vss vss sky130_fd_pr__nfet_01v8 L=0.5u W=1u
M877 o3 ibias vss vss sky130_fd_pr__nfet_01v8 L=0.5u W=1u
M878 o3 ibias vss vss sky130_fd_pr__nfet_01v8 L=0.5u W=1u
M879 o3 ibias vss vss sky130_fd_pr__nfet_01v8 L=0.5u W=1u
M880 o3 ibias vss vss sky130_fd_pr__nfet_01v8 L=0.5u W=1u
M881 o3 ibias vss vss sky130_fd_pr__nfet_01v8 L=0.5u W=1u
M882 o3 ibias vss vss sky130_fd_pr__nfet_01v8 L=0.5u W=1u
M883 o3 ibias vss vss sky130_fd_pr__nfet_01v8 L=0.5u W=1u
M884 o3 ibias vss vss sky130_fd_pr__nfet_01v8 L=0.5u W=1u
M885 o3 ibias vss vss sky130_fd_pr__nfet_01v8 L=0.5u W=1u
M886 o3 ibias vss vss sky130_fd_pr__nfet_01v8 L=0.5u W=1u
M887 o3 ibias vss vss sky130_fd_pr__nfet_01v8 L=0.5u W=1u
M888 o3 ibias vss vss sky130_fd_pr__nfet_01v8 L=0.5u W=1u
M889 o3 ibias vss vss sky130_fd_pr__nfet_01v8 L=0.5u W=1u
M890 o3 ibias vss vss sky130_fd_pr__nfet_01v8 L=0.5u W=1u
M891 o3 ibias vss vss sky130_fd_pr__nfet_01v8 L=0.5u W=1u
M892 o3 ibias vss vss sky130_fd_pr__nfet_01v8 L=0.5u W=1u
M893 o3 ibias vss vss sky130_fd_pr__nfet_01v8 L=0.5u W=1u
M894 o3 ibias vss vss sky130_fd_pr__nfet_01v8 L=0.5u W=1u
M895 o3 ibias vss vss sky130_fd_pr__nfet_01v8 L=0.5u W=1u
M896 o3 ibias vss vss sky130_fd_pr__nfet_01v8 L=0.5u W=1u
M897 o3 ibias vss vss sky130_fd_pr__nfet_01v8 L=0.5u W=1u
M898 o3 ibias vss vss sky130_fd_pr__nfet_01v8 L=0.5u W=1u
M899 o3 ibias vss vss sky130_fd_pr__nfet_01v8 L=0.5u W=1u
M900 o3 ibias vss vss sky130_fd_pr__nfet_01v8 L=0.5u W=1u
M901 o3 ibias vss vss sky130_fd_pr__nfet_01v8 L=0.5u W=1u
M902 o3 ibias vss vss sky130_fd_pr__nfet_01v8 L=0.5u W=1u
M903 o3 ibias vss vss sky130_fd_pr__nfet_01v8 L=0.5u W=1u
M904 o3 ibias vss vss sky130_fd_pr__nfet_01v8 L=0.5u W=1u
M905 o3 ibias vss vss sky130_fd_pr__nfet_01v8 L=0.5u W=1u
M906 o3 ibias vss vss sky130_fd_pr__nfet_01v8 L=0.5u W=1u
M907 o3 ibias vss vss sky130_fd_pr__nfet_01v8 L=0.5u W=1u
M908 o3 ibias vss vss sky130_fd_pr__nfet_01v8 L=0.5u W=1u
M909 o3 ibias vss vss sky130_fd_pr__nfet_01v8 L=0.5u W=1u
M910 o3 ibias vss vss sky130_fd_pr__nfet_01v8 L=0.5u W=1u
M911 o3 ibias vss vss sky130_fd_pr__nfet_01v8 L=0.5u W=1u
M912 o3 ibias vss vss sky130_fd_pr__nfet_01v8 L=0.5u W=1u
M913 o3 ibias vss vss sky130_fd_pr__nfet_01v8 L=0.5u W=1u
M914 o3 ibias vss vss sky130_fd_pr__nfet_01v8 L=0.5u W=1u
M915 o3 ibias vss vss sky130_fd_pr__nfet_01v8 L=0.5u W=1u
M916 o3 ibias vss vss sky130_fd_pr__nfet_01v8 L=0.5u W=1u
M917 o3 ibias vss vss sky130_fd_pr__nfet_01v8 L=0.5u W=1u
M918 o3 ibias vss vss sky130_fd_pr__nfet_01v8 L=0.5u W=1u
M919 o3 ibias vss vss sky130_fd_pr__nfet_01v8 L=0.5u W=1u
M920 o3 ibias vss vss sky130_fd_pr__nfet_01v8 L=0.5u W=1u
M921 o3 ibias vss vss sky130_fd_pr__nfet_01v8 L=0.5u W=1u
M922 o3 ibias vss vss sky130_fd_pr__nfet_01v8 L=0.5u W=1u
M923 o3 ibias vss vss sky130_fd_pr__nfet_01v8 L=0.5u W=1u
M924 o3 ibias vss vss sky130_fd_pr__nfet_01v8 L=0.5u W=1u
M925 o3 ibias vss vss sky130_fd_pr__nfet_01v8 L=0.5u W=1u
M926 o3 ibias vss vss sky130_fd_pr__nfet_01v8 L=0.5u W=1u
M927 o3 ibias vss vss sky130_fd_pr__nfet_01v8 L=0.5u W=1u
M928 o3 ibias vss vss sky130_fd_pr__nfet_01v8 L=0.5u W=1u
M929 o3 ibias vss vss sky130_fd_pr__nfet_01v8 L=0.5u W=1u
M930 o3 ibias vss vss sky130_fd_pr__nfet_01v8 L=0.5u W=1u
M931 o3 ibias vss vss sky130_fd_pr__nfet_01v8 L=0.5u W=1u
M932 o3 ibias vss vss sky130_fd_pr__nfet_01v8 L=0.5u W=1u
M933 o3 ibias vss vss sky130_fd_pr__nfet_01v8 L=0.5u W=1u
M934 o3 ibias vss vss sky130_fd_pr__nfet_01v8 L=0.5u W=1u
M935 o3 ibias vss vss sky130_fd_pr__nfet_01v8 L=0.5u W=1u
M936 o3 ibias vss vss sky130_fd_pr__nfet_01v8 L=0.5u W=1u
M937 o3 ibias vss vss sky130_fd_pr__nfet_01v8 L=0.5u W=1u
M938 o3 ibias vss vss sky130_fd_pr__nfet_01v8 L=0.5u W=1u
M939 o3 ibias vss vss sky130_fd_pr__nfet_01v8 L=0.5u W=1u
M940 o3 ibias vss vss sky130_fd_pr__nfet_01v8 L=0.5u W=1u
M941 o3 ibias vss vss sky130_fd_pr__nfet_01v8 L=0.5u W=1u
M942 o3 ibias vss vss sky130_fd_pr__nfet_01v8 L=0.5u W=1u
M943 o3 ibias vss vss sky130_fd_pr__nfet_01v8 L=0.5u W=1u
M944 o3 ibias vss vss sky130_fd_pr__nfet_01v8 L=0.5u W=1u
M945 o3 ibias vss vss sky130_fd_pr__nfet_01v8 L=0.5u W=1u
M946 o3 ibias vss vss sky130_fd_pr__nfet_01v8 L=0.5u W=1u
M947 o3 ibias vss vss sky130_fd_pr__nfet_01v8 L=0.5u W=1u
M948 o3 ibias vss vss sky130_fd_pr__nfet_01v8 L=0.5u W=1u
M949 o3 ibias vss vss sky130_fd_pr__nfet_01v8 L=0.5u W=1u
M950 o3 ibias vss vss sky130_fd_pr__nfet_01v8 L=0.5u W=1u
M951 o3 ibias vss vss sky130_fd_pr__nfet_01v8 L=0.5u W=1u
M952 o3 ibias vss vss sky130_fd_pr__nfet_01v8 L=0.5u W=1u
M953 o3 ibias vss vss sky130_fd_pr__nfet_01v8 L=0.5u W=1u
M954 o3 ibias vss vss sky130_fd_pr__nfet_01v8 L=0.5u W=1u
M955 o3 ibias vss vss sky130_fd_pr__nfet_01v8 L=0.5u W=1u
M956 o3 ibias vss vss sky130_fd_pr__nfet_01v8 L=0.5u W=1u
M957 o3 ibias vss vss sky130_fd_pr__nfet_01v8 L=0.5u W=1u
M958 o3 ibias vss vss sky130_fd_pr__nfet_01v8 L=0.5u W=1u
M959 o3 ibias vss vss sky130_fd_pr__nfet_01v8 L=0.5u W=1u
M960 o3 ibias vss vss sky130_fd_pr__nfet_01v8 L=0.5u W=1u
M961 o3 ibias vss vss sky130_fd_pr__nfet_01v8 L=0.5u W=1u
M962 o3 ibias vss vss sky130_fd_pr__nfet_01v8 L=0.5u W=1u
M963 o3 ibias vss vss sky130_fd_pr__nfet_01v8 L=0.5u W=1u
M964 o3 ibias vss vss sky130_fd_pr__nfet_01v8 L=0.5u W=1u
M965 o3 ibias vss vss sky130_fd_pr__nfet_01v8 L=0.5u W=1u
M966 o3 ibias vss vss sky130_fd_pr__nfet_01v8 L=0.5u W=1u
M967 o3 ibias vss vss sky130_fd_pr__nfet_01v8 L=0.5u W=1u
M968 o3 ibias vss vss sky130_fd_pr__nfet_01v8 L=0.5u W=1u
M969 o3 ibias vss vss sky130_fd_pr__nfet_01v8 L=0.5u W=1u
M970 o3 ibias vss vss sky130_fd_pr__nfet_01v8 L=0.5u W=1u
M971 o3 ibias vss vss sky130_fd_pr__nfet_01v8 L=0.5u W=1u
M972 o3 ibias vss vss sky130_fd_pr__nfet_01v8 L=0.5u W=1u
M973 o3 ibias vss vss sky130_fd_pr__nfet_01v8 L=0.5u W=1u
M974 o3 ibias vss vss sky130_fd_pr__nfet_01v8 L=0.5u W=1u
M975 o3 ibias vss vss sky130_fd_pr__nfet_01v8 L=0.5u W=1u
M976 o3 ibias vss vss sky130_fd_pr__nfet_01v8 L=0.5u W=1u
M977 o3 ibias vss vss sky130_fd_pr__nfet_01v8 L=0.5u W=1u
M978 o3 ibias vss vss sky130_fd_pr__nfet_01v8 L=0.5u W=1u
M979 o3 ibias vss vss sky130_fd_pr__nfet_01v8 L=0.5u W=1u
M980 o3 ibias vss vss sky130_fd_pr__nfet_01v8 L=0.5u W=1u
M981 o3 ibias vss vss sky130_fd_pr__nfet_01v8 L=0.5u W=1u
M982 o3 ibias vss vss sky130_fd_pr__nfet_01v8 L=0.5u W=1u
M983 o3 ibias vss vss sky130_fd_pr__nfet_01v8 L=0.5u W=1u
M984 o3 ibias vss vss sky130_fd_pr__nfet_01v8 L=0.5u W=1u
M985 o3 ibias vss vss sky130_fd_pr__nfet_01v8 L=0.5u W=1u
M986 o3 ibias vss vss sky130_fd_pr__nfet_01v8 L=0.5u W=1u
M987 o3 ibias vss vss sky130_fd_pr__nfet_01v8 L=0.5u W=1u
M988 o3 ibias vss vss sky130_fd_pr__nfet_01v8 L=0.5u W=1u
M989 o3 ibias vss vss sky130_fd_pr__nfet_01v8 L=0.5u W=1u
M990 o3 ibias vss vss sky130_fd_pr__nfet_01v8 L=0.5u W=1u
M991 o3 ibias vss vss sky130_fd_pr__nfet_01v8 L=0.5u W=1u
M992 o3 ibias vss vss sky130_fd_pr__nfet_01v8 L=0.5u W=1u
M993 o3 ibias vss vss sky130_fd_pr__nfet_01v8 L=0.5u W=1u
M994 o3 ibias vss vss sky130_fd_pr__nfet_01v8 L=0.5u W=1u
M995 o3 ibias vss vss sky130_fd_pr__nfet_01v8 L=0.5u W=1u
M996 o3 ibias vss vss sky130_fd_pr__nfet_01v8 L=0.5u W=1u
M997 o3 ibias vss vss sky130_fd_pr__nfet_01v8 L=0.5u W=1u
M998 o3 ibias vss vss sky130_fd_pr__nfet_01v8 L=0.5u W=1u
M999 o3 ibias vss vss sky130_fd_pr__nfet_01v8 L=0.5u W=1u
M1000 o3 ibias vss vss sky130_fd_pr__nfet_01v8 L=0.5u W=1u
M1001 o3 ibias vss vss sky130_fd_pr__nfet_01v8 L=0.5u W=1u
M1002 o3 ibias vss vss sky130_fd_pr__nfet_01v8 L=0.5u W=1u
M1003 o3 ibias vss vss sky130_fd_pr__nfet_01v8 L=0.5u W=1u
M1004 o3 ibias vss vss sky130_fd_pr__nfet_01v8 L=0.5u W=1u
M1005 o3 ibias vss vss sky130_fd_pr__nfet_01v8 L=0.5u W=1u
M1006 o3 ibias vss vss sky130_fd_pr__nfet_01v8 L=0.5u W=1u
M1007 o3 ibias vss vss sky130_fd_pr__nfet_01v8 L=0.5u W=1u
M1008 o3 ibias vss vss sky130_fd_pr__nfet_01v8 L=0.5u W=1u
M1009 o3 ibias vss vss sky130_fd_pr__nfet_01v8 L=0.5u W=1u
M1010 o3 ibias vss vss sky130_fd_pr__nfet_01v8 L=0.5u W=1u
M1011 o3 ibias vss vss sky130_fd_pr__nfet_01v8 L=0.5u W=1u
M1012 o3 ibias vss vss sky130_fd_pr__nfet_01v8 L=0.5u W=1u
M1013 o3 ibias vss vss sky130_fd_pr__nfet_01v8 L=0.5u W=1u
M1014 o3 ibias vss vss sky130_fd_pr__nfet_01v8 L=0.5u W=1u
M1015 o3 ibias vss vss sky130_fd_pr__nfet_01v8 L=0.5u W=1u
M1016 o3 ibias vss vss sky130_fd_pr__nfet_01v8 L=0.5u W=1u
M1017 o3 ibias vss vss sky130_fd_pr__nfet_01v8 L=0.5u W=1u
M1018 o3 ibias vss vss sky130_fd_pr__nfet_01v8 L=0.5u W=1u
M1019 o3 ibias vss vss sky130_fd_pr__nfet_01v8 L=0.5u W=1u
M1020 o3 ibias vss vss sky130_fd_pr__nfet_01v8 L=0.5u W=1u
M1021 o3 ibias vss vss sky130_fd_pr__nfet_01v8 L=0.5u W=1u
M1022 o3 ibias vss vss sky130_fd_pr__nfet_01v8 L=0.5u W=1u
M1023 o3 ibias vss vss sky130_fd_pr__nfet_01v8 L=0.5u W=1u
M1024 o3 ibias vss vss sky130_fd_pr__nfet_01v8 L=0.5u W=1u
M1025 o3 ibias vss vss sky130_fd_pr__nfet_01v8 L=0.5u W=1u
M1026 o3 ibias vss vss sky130_fd_pr__nfet_01v8 L=0.5u W=1u
M1027 o3 ibias vss vss sky130_fd_pr__nfet_01v8 L=0.5u W=1u
M1028 o3 ibias vss vss sky130_fd_pr__nfet_01v8 L=0.5u W=1u
M1029 o3 ibias vss vss sky130_fd_pr__nfet_01v8 L=0.5u W=1u
M1030 o3 ibias vss vss sky130_fd_pr__nfet_01v8 L=0.5u W=1u
M1031 o3 ibias vss vss sky130_fd_pr__nfet_01v8 L=0.5u W=1u
M1032 o3 ibias vss vss sky130_fd_pr__nfet_01v8 L=0.5u W=1u
M1033 o3 ibias vss vss sky130_fd_pr__nfet_01v8 L=0.5u W=1u
M1034 o3 ibias vss vss sky130_fd_pr__nfet_01v8 L=0.5u W=1u
M1035 o3 ibias vss vss sky130_fd_pr__nfet_01v8 L=0.5u W=1u
M1036 o3 ibias vss vss sky130_fd_pr__nfet_01v8 L=0.5u W=1u
M1037 o3 ibias vss vss sky130_fd_pr__nfet_01v8 L=0.5u W=1u
M1038 o3 ibias vss vss sky130_fd_pr__nfet_01v8 L=0.5u W=1u
M1039 o3 ibias vss vss sky130_fd_pr__nfet_01v8 L=0.5u W=1u
M1040 o3 ibias vss vss sky130_fd_pr__nfet_01v8 L=0.5u W=1u
M1041 o3 ibias vss vss sky130_fd_pr__nfet_01v8 L=0.5u W=1u
M1042 o3 ibias vss vss sky130_fd_pr__nfet_01v8 L=0.5u W=1u
M1043 o3 ibias vss vss sky130_fd_pr__nfet_01v8 L=0.5u W=1u
M1044 o3 ibias vss vss sky130_fd_pr__nfet_01v8 L=0.5u W=1u
M1045 o3 ibias vss vss sky130_fd_pr__nfet_01v8 L=0.5u W=1u
M1046 o3 ibias vss vss sky130_fd_pr__nfet_01v8 L=0.5u W=1u
M1047 o3 ibias vss vss sky130_fd_pr__nfet_01v8 L=0.5u W=1u
M1048 o3 ibias vss vss sky130_fd_pr__nfet_01v8 L=0.5u W=1u
M1049 o3 ibias vss vss sky130_fd_pr__nfet_01v8 L=0.5u W=1u
M1050 o3 ibias vss vss sky130_fd_pr__nfet_01v8 L=0.5u W=1u
M1051 o3 ibias vss vss sky130_fd_pr__nfet_01v8 L=0.5u W=1u
M1052 o3 ibias vss vss sky130_fd_pr__nfet_01v8 L=0.5u W=1u
M1053 o3 ibias vss vss sky130_fd_pr__nfet_01v8 L=0.5u W=1u
M1054 o3 ibias vss vss sky130_fd_pr__nfet_01v8 L=0.5u W=1u
M1055 o3 ibias vss vss sky130_fd_pr__nfet_01v8 L=0.5u W=1u
M1056 o3 ibias vss vss sky130_fd_pr__nfet_01v8 L=0.5u W=1u
M1057 o3 ibias vss vss sky130_fd_pr__nfet_01v8 L=0.5u W=1u
M1058 o3 ibias vss vss sky130_fd_pr__nfet_01v8 L=0.5u W=1u
M1059 o3 ibias vss vss sky130_fd_pr__nfet_01v8 L=0.5u W=1u
M1060 o3 ibias vss vss sky130_fd_pr__nfet_01v8 L=0.5u W=1u
M1061 o3 ibias vss vss sky130_fd_pr__nfet_01v8 L=0.5u W=1u
M1062 o3 ibias vss vss sky130_fd_pr__nfet_01v8 L=0.5u W=1u
M1063 o3 ibias vss vss sky130_fd_pr__nfet_01v8 L=0.5u W=1u
M1064 o3 ibias vss vss sky130_fd_pr__nfet_01v8 L=0.5u W=1u
M1065 o3 ibias vss vss sky130_fd_pr__nfet_01v8 L=0.5u W=1u
M1066 o3 ibias vss vss sky130_fd_pr__nfet_01v8 L=0.5u W=1u
M1067 o3 ibias vss vss sky130_fd_pr__nfet_01v8 L=0.5u W=1u
M1068 o3 ibias vss vss sky130_fd_pr__nfet_01v8 L=0.5u W=1u
M1069 o3 ibias vss vss sky130_fd_pr__nfet_01v8 L=0.5u W=1u
M1070 o3 ibias vss vss sky130_fd_pr__nfet_01v8 L=0.5u W=1u
M1071 o3 ibias vss vss sky130_fd_pr__nfet_01v8 L=0.5u W=1u
M1072 o3 ibias vss vss sky130_fd_pr__nfet_01v8 L=0.5u W=1u
M1073 o3 ibias vss vss sky130_fd_pr__nfet_01v8 L=0.5u W=1u
M1074 o3 ibias vss vss sky130_fd_pr__nfet_01v8 L=0.5u W=1u
M1075 o3 ibias vss vss sky130_fd_pr__nfet_01v8 L=0.5u W=1u
M1076 o3 ibias vss vss sky130_fd_pr__nfet_01v8 L=0.5u W=1u
M1077 o3 ibias vss vss sky130_fd_pr__nfet_01v8 L=0.5u W=1u
M1078 o3 ibias vss vss sky130_fd_pr__nfet_01v8 L=0.5u W=1u
M1079 o3 ibias vss vss sky130_fd_pr__nfet_01v8 L=0.5u W=1u
M1080 o3 ibias vss vss sky130_fd_pr__nfet_01v8 L=0.5u W=1u
M1081 o3 ibias vss vss sky130_fd_pr__nfet_01v8 L=0.5u W=1u
M1082 o3 ibias vss vss sky130_fd_pr__nfet_01v8 L=0.5u W=1u
M1083 o3 ibias vss vss sky130_fd_pr__nfet_01v8 L=0.5u W=1u
M1084 o3 ibias vss vss sky130_fd_pr__nfet_01v8 L=0.5u W=1u
M1085 o3 ibias vss vss sky130_fd_pr__nfet_01v8 L=0.5u W=1u
M1086 o3 ibias vss vss sky130_fd_pr__nfet_01v8 L=0.5u W=1u
M1087 o3 ibias vss vss sky130_fd_pr__nfet_01v8 L=0.5u W=1u
M1088 o3 ibias vss vss sky130_fd_pr__nfet_01v8 L=0.5u W=1u
M1089 o3 ibias vss vss sky130_fd_pr__nfet_01v8 L=0.5u W=1u
M1090 o3 ibias vss vss sky130_fd_pr__nfet_01v8 L=0.5u W=1u
M1091 o3 ibias vss vss sky130_fd_pr__nfet_01v8 L=0.5u W=1u
M1092 o3 ibias vss vss sky130_fd_pr__nfet_01v8 L=0.5u W=1u
M1093 o3 ibias vss vss sky130_fd_pr__nfet_01v8 L=0.5u W=1u
M1094 o3 ibias vss vss sky130_fd_pr__nfet_01v8 L=0.5u W=1u
M1095 o3 ibias vss vss sky130_fd_pr__nfet_01v8 L=0.5u W=1u
M1096 o3 ibias vss vss sky130_fd_pr__nfet_01v8 L=0.5u W=1u
M1097 o3 ibias vss vss sky130_fd_pr__nfet_01v8 L=0.5u W=1u
M1098 o3 ibias vss vss sky130_fd_pr__nfet_01v8 L=0.5u W=1u
M1099 o3 ibias vss vss sky130_fd_pr__nfet_01v8 L=0.5u W=1u
M1100 o3 ibias vss vss sky130_fd_pr__nfet_01v8 L=0.5u W=1u
M1101 o3 ibias vss vss sky130_fd_pr__nfet_01v8 L=0.5u W=1u
M1102 o3 ibias vss vss sky130_fd_pr__nfet_01v8 L=0.5u W=1u
M1103 o3 ibias vss vss sky130_fd_pr__nfet_01v8 L=0.5u W=1u
M1104 o3 ibias vss vss sky130_fd_pr__nfet_01v8 L=0.5u W=1u
M1105 o3 ibias vss vss sky130_fd_pr__nfet_01v8 L=0.5u W=1u
M1106 o3 ibias vss vss sky130_fd_pr__nfet_01v8 L=0.5u W=1u
M1107 o3 ibias vss vss sky130_fd_pr__nfet_01v8 L=0.5u W=1u
M1108 o3 ibias vss vss sky130_fd_pr__nfet_01v8 L=0.5u W=1u
M1109 o3 ibias vss vss sky130_fd_pr__nfet_01v8 L=0.5u W=1u
M1110 o3 ibias vss vss sky130_fd_pr__nfet_01v8 L=0.5u W=1u
M1111 o3 ibias vss vss sky130_fd_pr__nfet_01v8 L=0.5u W=1u
M1112 o3 ibias vss vss sky130_fd_pr__nfet_01v8 L=0.5u W=1u
M1113 o3 ibias vss vss sky130_fd_pr__nfet_01v8 L=0.5u W=1u
M1114 o3 ibias vss vss sky130_fd_pr__nfet_01v8 L=0.5u W=1u
M1115 o3 ibias vss vss sky130_fd_pr__nfet_01v8 L=0.5u W=1u
M1116 o3 ibias vss vss sky130_fd_pr__nfet_01v8 L=0.5u W=1u
M1117 o3 ibias vss vss sky130_fd_pr__nfet_01v8 L=0.5u W=1u
M1118 o3 ibias vss vss sky130_fd_pr__nfet_01v8 L=0.5u W=1u
M1119 o3 ibias vss vss sky130_fd_pr__nfet_01v8 L=0.5u W=1u
M1120 o3 ibias vss vss sky130_fd_pr__nfet_01v8 L=0.5u W=1u
M1121 o3 ibias vss vss sky130_fd_pr__nfet_01v8 L=0.5u W=1u
M1122 o3 ibias vss vss sky130_fd_pr__nfet_01v8 L=0.5u W=1u
M1123 o3 ibias vss vss sky130_fd_pr__nfet_01v8 L=0.5u W=1u
M1124 o3 ibias vss vss sky130_fd_pr__nfet_01v8 L=0.5u W=1u
M1125 o3 ibias vss vss sky130_fd_pr__nfet_01v8 L=0.5u W=1u
M1126 o3 ibias vss vss sky130_fd_pr__nfet_01v8 L=0.5u W=1u
M1127 o3 ibias vss vss sky130_fd_pr__nfet_01v8 L=0.5u W=1u
M1128 o3 ibias vss vss sky130_fd_pr__nfet_01v8 L=0.5u W=1u
M1129 o3 ibias vss vss sky130_fd_pr__nfet_01v8 L=0.5u W=1u
M1130 o3 ibias vss vss sky130_fd_pr__nfet_01v8 L=0.5u W=1u
M1131 o3 ibias vss vss sky130_fd_pr__nfet_01v8 L=0.5u W=1u
M1132 o3 ibias vss vss sky130_fd_pr__nfet_01v8 L=0.5u W=1u
M1133 o3 ibias vss vss sky130_fd_pr__nfet_01v8 L=0.5u W=1u
M1134 o3 ibias vss vss sky130_fd_pr__nfet_01v8 L=0.5u W=1u
M1135 o3 ibias vss vss sky130_fd_pr__nfet_01v8 L=0.5u W=1u
M1136 o3 ibias vss vss sky130_fd_pr__nfet_01v8 L=0.5u W=1u
M1137 o3 ibias vss vss sky130_fd_pr__nfet_01v8 L=0.5u W=1u
M1138 o3 ibias vss vss sky130_fd_pr__nfet_01v8 L=0.5u W=1u
M1139 o3 ibias vss vss sky130_fd_pr__nfet_01v8 L=0.5u W=1u
M1140 o3 ibias vss vss sky130_fd_pr__nfet_01v8 L=0.5u W=1u
M1141 o3 ibias vss vss sky130_fd_pr__nfet_01v8 L=0.5u W=1u
M1142 o3 ibias vss vss sky130_fd_pr__nfet_01v8 L=0.5u W=1u
M1143 o3 ibias vss vss sky130_fd_pr__nfet_01v8 L=0.5u W=1u
M1144 o3 ibias vss vss sky130_fd_pr__nfet_01v8 L=0.5u W=1u
M1145 o3 ibias vss vss sky130_fd_pr__nfet_01v8 L=0.5u W=1u
M1146 o3 ibias vss vss sky130_fd_pr__nfet_01v8 L=0.5u W=1u
M1147 o3 ibias vss vss sky130_fd_pr__nfet_01v8 L=0.5u W=1u
M1148 o3 ibias vss vss sky130_fd_pr__nfet_01v8 L=0.5u W=1u
M1149 o3 ibias vss vss sky130_fd_pr__nfet_01v8 L=0.5u W=1u
M1150 o3 ibias vss vss sky130_fd_pr__nfet_01v8 L=0.5u W=1u
M1151 o3 ibias vss vss sky130_fd_pr__nfet_01v8 L=0.5u W=1u
M1152 o3 ibias vss vss sky130_fd_pr__nfet_01v8 L=0.5u W=1u
M1153 o3 ibias vss vss sky130_fd_pr__nfet_01v8 L=0.5u W=1u
M1154 o3 ibias vss vss sky130_fd_pr__nfet_01v8 L=0.5u W=1u
M1155 o3 ibias vss vss sky130_fd_pr__nfet_01v8 L=0.5u W=1u
M1156 o3 ibias vss vss sky130_fd_pr__nfet_01v8 L=0.5u W=1u
M1157 o3 ibias vss vss sky130_fd_pr__nfet_01v8 L=0.5u W=1u
M1158 o3 ibias vss vss sky130_fd_pr__nfet_01v8 L=0.5u W=1u
M1159 o3 ibias vss vss sky130_fd_pr__nfet_01v8 L=0.5u W=1u
M1160 o3 ibias vss vss sky130_fd_pr__nfet_01v8 L=0.5u W=1u
M1161 o3 ibias vss vss sky130_fd_pr__nfet_01v8 L=0.5u W=1u
M1162 o3 ibias vss vss sky130_fd_pr__nfet_01v8 L=0.5u W=1u
M1163 o3 ibias vss vss sky130_fd_pr__nfet_01v8 L=0.5u W=1u
M1164 o3 ibias vss vss sky130_fd_pr__nfet_01v8 L=0.5u W=1u
M1165 o3 ibias vss vss sky130_fd_pr__nfet_01v8 L=0.5u W=1u
M1166 o3 ibias vss vss sky130_fd_pr__nfet_01v8 L=0.5u W=1u
M1167 o3 ibias vss vss sky130_fd_pr__nfet_01v8 L=0.5u W=1u
M1168 o3 ibias vss vss sky130_fd_pr__nfet_01v8 L=0.5u W=1u
M1169 o3 ibias vss vss sky130_fd_pr__nfet_01v8 L=0.5u W=1u
M1170 o3 ibias vss vss sky130_fd_pr__nfet_01v8 L=0.5u W=1u
M1171 o3 ibias vss vss sky130_fd_pr__nfet_01v8 L=0.5u W=1u
M1172 o3 ibias vss vss sky130_fd_pr__nfet_01v8 L=0.5u W=1u
M1173 o3 ibias vss vss sky130_fd_pr__nfet_01v8 L=0.5u W=1u
M1174 o3 ibias vss vss sky130_fd_pr__nfet_01v8 L=0.5u W=1u
M1175 o3 ibias vss vss sky130_fd_pr__nfet_01v8 L=0.5u W=1u
M1176 o3 ibias vss vss sky130_fd_pr__nfet_01v8 L=0.5u W=1u
M1177 o3 ibias vss vss sky130_fd_pr__nfet_01v8 L=0.5u W=1u
M1178 o3 ibias vss vss sky130_fd_pr__nfet_01v8 L=0.5u W=1u
M1179 o3 ibias vss vss sky130_fd_pr__nfet_01v8 L=0.5u W=1u
M1180 o3 ibias vss vss sky130_fd_pr__nfet_01v8 L=0.5u W=1u
M1181 o3 ibias vss vss sky130_fd_pr__nfet_01v8 L=0.5u W=1u
M1182 o3 ibias vss vss sky130_fd_pr__nfet_01v8 L=0.5u W=1u
M1183 o3 ibias vss vss sky130_fd_pr__nfet_01v8 L=0.5u W=1u
M1184 o3 ibias vss vss sky130_fd_pr__nfet_01v8 L=0.5u W=1u
M1185 o3 ibias vss vss sky130_fd_pr__nfet_01v8 L=0.5u W=1u
M1186 o3 ibias vss vss sky130_fd_pr__nfet_01v8 L=0.5u W=1u
M1187 o3 ibias vss vss sky130_fd_pr__nfet_01v8 L=0.5u W=1u
M1188 o3 ibias vss vss sky130_fd_pr__nfet_01v8 L=0.5u W=1u
M1189 o3 ibias vss vss sky130_fd_pr__nfet_01v8 L=0.5u W=1u
M1190 o3 ibias vss vss sky130_fd_pr__nfet_01v8 L=0.5u W=1u
M1191 o3 ibias vss vss sky130_fd_pr__nfet_01v8 L=0.5u W=1u
M1192 o3 ibias vss vss sky130_fd_pr__nfet_01v8 L=0.5u W=1u
M1193 o3 ibias vss vss sky130_fd_pr__nfet_01v8 L=0.5u W=1u
M1194 o3 ibias vss vss sky130_fd_pr__nfet_01v8 L=0.5u W=1u
M1195 o3 ibias vss vss sky130_fd_pr__nfet_01v8 L=0.5u W=1u
M1196 o3 ibias vss vss sky130_fd_pr__nfet_01v8 L=0.5u W=1u
M1197 o3 ibias vss vss sky130_fd_pr__nfet_01v8 L=0.5u W=1u
M1198 o3 ibias vss vss sky130_fd_pr__nfet_01v8 L=0.5u W=1u
M1199 o3 ibias vss vss sky130_fd_pr__nfet_01v8 L=0.5u W=1u
M1200 o3 ibias vss vss sky130_fd_pr__nfet_01v8 L=0.5u W=1u
M1201 o3 ibias vss vss sky130_fd_pr__nfet_01v8 L=0.5u W=1u
M1202 o3 ibias vss vss sky130_fd_pr__nfet_01v8 L=0.5u W=1u
M1203 o3 ibias vss vss sky130_fd_pr__nfet_01v8 L=0.5u W=1u
M1204 o3 ibias vss vss sky130_fd_pr__nfet_01v8 L=0.5u W=1u
M1205 o3 ibias vss vss sky130_fd_pr__nfet_01v8 L=0.5u W=1u
M1206 o3 ibias vss vss sky130_fd_pr__nfet_01v8 L=0.5u W=1u
M1207 o3 ibias vss vss sky130_fd_pr__nfet_01v8 L=0.5u W=1u
M1208 o3 ibias vss vss sky130_fd_pr__nfet_01v8 L=0.5u W=1u
M1209 o3 ibias vss vss sky130_fd_pr__nfet_01v8 L=0.5u W=1u
M1210 o3 ibias vss vss sky130_fd_pr__nfet_01v8 L=0.5u W=1u
M1211 o3 ibias vss vss sky130_fd_pr__nfet_01v8 L=0.5u W=1u
M1212 o3 ibias vss vss sky130_fd_pr__nfet_01v8 L=0.5u W=1u
M1213 o3 ibias vss vss sky130_fd_pr__nfet_01v8 L=0.5u W=1u
M1214 o3 ibias vss vss sky130_fd_pr__nfet_01v8 L=0.5u W=1u
M1215 o3 ibias vss vss sky130_fd_pr__nfet_01v8 L=0.5u W=1u
M1216 o4 ibias vss vss sky130_fd_pr__nfet_01v8 L=0.5u W=1u
M1217 o4 ibias vss vss sky130_fd_pr__nfet_01v8 L=0.5u W=1u
M1218 o4 ibias vss vss sky130_fd_pr__nfet_01v8 L=0.5u W=1u
M1219 o4 ibias vss vss sky130_fd_pr__nfet_01v8 L=0.5u W=1u
M1220 o4 ibias vss vss sky130_fd_pr__nfet_01v8 L=0.5u W=1u
M1221 o4 ibias vss vss sky130_fd_pr__nfet_01v8 L=0.5u W=1u
M1222 o4 ibias vss vss sky130_fd_pr__nfet_01v8 L=0.5u W=1u
M1223 o4 ibias vss vss sky130_fd_pr__nfet_01v8 L=0.5u W=1u
M1224 o4 ibias vss vss sky130_fd_pr__nfet_01v8 L=0.5u W=1u
M1225 o4 ibias vss vss sky130_fd_pr__nfet_01v8 L=0.5u W=1u
M1226 o4 ibias vss vss sky130_fd_pr__nfet_01v8 L=0.5u W=1u
M1227 o4 ibias vss vss sky130_fd_pr__nfet_01v8 L=0.5u W=1u
M1228 o4 ibias vss vss sky130_fd_pr__nfet_01v8 L=0.5u W=1u
M1229 o4 ibias vss vss sky130_fd_pr__nfet_01v8 L=0.5u W=1u
M1230 o4 ibias vss vss sky130_fd_pr__nfet_01v8 L=0.5u W=1u
M1231 o4 ibias vss vss sky130_fd_pr__nfet_01v8 L=0.5u W=1u
M1232 o4 ibias vss vss sky130_fd_pr__nfet_01v8 L=0.5u W=1u
M1233 o4 ibias vss vss sky130_fd_pr__nfet_01v8 L=0.5u W=1u
M1234 o4 ibias vss vss sky130_fd_pr__nfet_01v8 L=0.5u W=1u
M1235 o4 ibias vss vss sky130_fd_pr__nfet_01v8 L=0.5u W=1u
M1236 o4 ibias vss vss sky130_fd_pr__nfet_01v8 L=0.5u W=1u
M1237 o4 ibias vss vss sky130_fd_pr__nfet_01v8 L=0.5u W=1u
M1238 o4 ibias vss vss sky130_fd_pr__nfet_01v8 L=0.5u W=1u
M1239 o4 ibias vss vss sky130_fd_pr__nfet_01v8 L=0.5u W=1u
M1240 o4 ibias vss vss sky130_fd_pr__nfet_01v8 L=0.5u W=1u
M1241 o4 ibias vss vss sky130_fd_pr__nfet_01v8 L=0.5u W=1u
M1242 o4 ibias vss vss sky130_fd_pr__nfet_01v8 L=0.5u W=1u
M1243 o4 ibias vss vss sky130_fd_pr__nfet_01v8 L=0.5u W=1u
M1244 o4 ibias vss vss sky130_fd_pr__nfet_01v8 L=0.5u W=1u
M1245 o4 ibias vss vss sky130_fd_pr__nfet_01v8 L=0.5u W=1u
M1246 o4 ibias vss vss sky130_fd_pr__nfet_01v8 L=0.5u W=1u
M1247 o4 ibias vss vss sky130_fd_pr__nfet_01v8 L=0.5u W=1u
M1248 o4 ibias vss vss sky130_fd_pr__nfet_01v8 L=0.5u W=1u
M1249 o4 ibias vss vss sky130_fd_pr__nfet_01v8 L=0.5u W=1u
M1250 o4 ibias vss vss sky130_fd_pr__nfet_01v8 L=0.5u W=1u
M1251 o4 ibias vss vss sky130_fd_pr__nfet_01v8 L=0.5u W=1u
M1252 o4 ibias vss vss sky130_fd_pr__nfet_01v8 L=0.5u W=1u
M1253 o4 ibias vss vss sky130_fd_pr__nfet_01v8 L=0.5u W=1u
M1254 o4 ibias vss vss sky130_fd_pr__nfet_01v8 L=0.5u W=1u
M1255 o4 ibias vss vss sky130_fd_pr__nfet_01v8 L=0.5u W=1u
M1256 o4 ibias vss vss sky130_fd_pr__nfet_01v8 L=0.5u W=1u
M1257 o4 ibias vss vss sky130_fd_pr__nfet_01v8 L=0.5u W=1u
M1258 o4 ibias vss vss sky130_fd_pr__nfet_01v8 L=0.5u W=1u
M1259 o4 ibias vss vss sky130_fd_pr__nfet_01v8 L=0.5u W=1u
M1260 o4 ibias vss vss sky130_fd_pr__nfet_01v8 L=0.5u W=1u
M1261 o4 ibias vss vss sky130_fd_pr__nfet_01v8 L=0.5u W=1u
M1262 o4 ibias vss vss sky130_fd_pr__nfet_01v8 L=0.5u W=1u
M1263 o4 ibias vss vss sky130_fd_pr__nfet_01v8 L=0.5u W=1u
M1264 o4 ibias vss vss sky130_fd_pr__nfet_01v8 L=0.5u W=1u
M1265 o4 ibias vss vss sky130_fd_pr__nfet_01v8 L=0.5u W=1u
M1266 o4 ibias vss vss sky130_fd_pr__nfet_01v8 L=0.5u W=1u
M1267 o4 ibias vss vss sky130_fd_pr__nfet_01v8 L=0.5u W=1u
M1268 o4 ibias vss vss sky130_fd_pr__nfet_01v8 L=0.5u W=1u
M1269 o4 ibias vss vss sky130_fd_pr__nfet_01v8 L=0.5u W=1u
M1270 o4 ibias vss vss sky130_fd_pr__nfet_01v8 L=0.5u W=1u
M1271 o4 ibias vss vss sky130_fd_pr__nfet_01v8 L=0.5u W=1u
M1272 o4 ibias vss vss sky130_fd_pr__nfet_01v8 L=0.5u W=1u
M1273 o4 ibias vss vss sky130_fd_pr__nfet_01v8 L=0.5u W=1u
M1274 o4 ibias vss vss sky130_fd_pr__nfet_01v8 L=0.5u W=1u
M1275 o4 ibias vss vss sky130_fd_pr__nfet_01v8 L=0.5u W=1u
M1276 o4 ibias vss vss sky130_fd_pr__nfet_01v8 L=0.5u W=1u
M1277 o4 ibias vss vss sky130_fd_pr__nfet_01v8 L=0.5u W=1u
M1278 o4 ibias vss vss sky130_fd_pr__nfet_01v8 L=0.5u W=1u
M1279 o4 ibias vss vss sky130_fd_pr__nfet_01v8 L=0.5u W=1u
M1280 o4 ibias vss vss sky130_fd_pr__nfet_01v8 L=0.5u W=1u
M1281 o4 ibias vss vss sky130_fd_pr__nfet_01v8 L=0.5u W=1u
M1282 o4 ibias vss vss sky130_fd_pr__nfet_01v8 L=0.5u W=1u
M1283 o4 ibias vss vss sky130_fd_pr__nfet_01v8 L=0.5u W=1u
M1284 o4 ibias vss vss sky130_fd_pr__nfet_01v8 L=0.5u W=1u
M1285 o4 ibias vss vss sky130_fd_pr__nfet_01v8 L=0.5u W=1u
M1286 o4 ibias vss vss sky130_fd_pr__nfet_01v8 L=0.5u W=1u
M1287 o4 ibias vss vss sky130_fd_pr__nfet_01v8 L=0.5u W=1u
M1288 o4 ibias vss vss sky130_fd_pr__nfet_01v8 L=0.5u W=1u
M1289 o4 ibias vss vss sky130_fd_pr__nfet_01v8 L=0.5u W=1u
M1290 o4 ibias vss vss sky130_fd_pr__nfet_01v8 L=0.5u W=1u
M1291 o4 ibias vss vss sky130_fd_pr__nfet_01v8 L=0.5u W=1u
M1292 o4 ibias vss vss sky130_fd_pr__nfet_01v8 L=0.5u W=1u
M1293 o4 ibias vss vss sky130_fd_pr__nfet_01v8 L=0.5u W=1u
M1294 o4 ibias vss vss sky130_fd_pr__nfet_01v8 L=0.5u W=1u
M1295 o4 ibias vss vss sky130_fd_pr__nfet_01v8 L=0.5u W=1u
M1296 o4 ibias vss vss sky130_fd_pr__nfet_01v8 L=0.5u W=1u
M1297 o4 ibias vss vss sky130_fd_pr__nfet_01v8 L=0.5u W=1u
M1298 o4 ibias vss vss sky130_fd_pr__nfet_01v8 L=0.5u W=1u
M1299 o4 ibias vss vss sky130_fd_pr__nfet_01v8 L=0.5u W=1u
M1300 o4 ibias vss vss sky130_fd_pr__nfet_01v8 L=0.5u W=1u
M1301 o4 ibias vss vss sky130_fd_pr__nfet_01v8 L=0.5u W=1u
M1302 o4 ibias vss vss sky130_fd_pr__nfet_01v8 L=0.5u W=1u
M1303 o4 ibias vss vss sky130_fd_pr__nfet_01v8 L=0.5u W=1u
M1304 o4 ibias vss vss sky130_fd_pr__nfet_01v8 L=0.5u W=1u
M1305 o4 ibias vss vss sky130_fd_pr__nfet_01v8 L=0.5u W=1u
M1306 o4 ibias vss vss sky130_fd_pr__nfet_01v8 L=0.5u W=1u
M1307 o4 ibias vss vss sky130_fd_pr__nfet_01v8 L=0.5u W=1u
M1308 o4 ibias vss vss sky130_fd_pr__nfet_01v8 L=0.5u W=1u
M1309 o4 ibias vss vss sky130_fd_pr__nfet_01v8 L=0.5u W=1u
M1310 o4 ibias vss vss sky130_fd_pr__nfet_01v8 L=0.5u W=1u
M1311 o4 ibias vss vss sky130_fd_pr__nfet_01v8 L=0.5u W=1u
M1312 o4 ibias vss vss sky130_fd_pr__nfet_01v8 L=0.5u W=1u
M1313 o4 ibias vss vss sky130_fd_pr__nfet_01v8 L=0.5u W=1u
M1314 o4 ibias vss vss sky130_fd_pr__nfet_01v8 L=0.5u W=1u
M1315 o4 ibias vss vss sky130_fd_pr__nfet_01v8 L=0.5u W=1u
M1316 o4 ibias vss vss sky130_fd_pr__nfet_01v8 L=0.5u W=1u
M1317 o4 ibias vss vss sky130_fd_pr__nfet_01v8 L=0.5u W=1u
M1318 o4 ibias vss vss sky130_fd_pr__nfet_01v8 L=0.5u W=1u
M1319 o4 ibias vss vss sky130_fd_pr__nfet_01v8 L=0.5u W=1u
M1320 o4 ibias vss vss sky130_fd_pr__nfet_01v8 L=0.5u W=1u
M1321 o4 ibias vss vss sky130_fd_pr__nfet_01v8 L=0.5u W=1u
M1322 o4 ibias vss vss sky130_fd_pr__nfet_01v8 L=0.5u W=1u
M1323 o4 ibias vss vss sky130_fd_pr__nfet_01v8 L=0.5u W=1u
M1324 o4 ibias vss vss sky130_fd_pr__nfet_01v8 L=0.5u W=1u
M1325 o4 ibias vss vss sky130_fd_pr__nfet_01v8 L=0.5u W=1u
M1326 o4 ibias vss vss sky130_fd_pr__nfet_01v8 L=0.5u W=1u
M1327 o4 ibias vss vss sky130_fd_pr__nfet_01v8 L=0.5u W=1u
M1328 o4 ibias vss vss sky130_fd_pr__nfet_01v8 L=0.5u W=1u
M1329 o4 ibias vss vss sky130_fd_pr__nfet_01v8 L=0.5u W=1u
M1330 o4 ibias vss vss sky130_fd_pr__nfet_01v8 L=0.5u W=1u
M1331 o4 ibias vss vss sky130_fd_pr__nfet_01v8 L=0.5u W=1u
M1332 o4 ibias vss vss sky130_fd_pr__nfet_01v8 L=0.5u W=1u
M1333 o4 ibias vss vss sky130_fd_pr__nfet_01v8 L=0.5u W=1u
M1334 o4 ibias vss vss sky130_fd_pr__nfet_01v8 L=0.5u W=1u
M1335 o4 ibias vss vss sky130_fd_pr__nfet_01v8 L=0.5u W=1u
M1336 o4 ibias vss vss sky130_fd_pr__nfet_01v8 L=0.5u W=1u
M1337 o4 ibias vss vss sky130_fd_pr__nfet_01v8 L=0.5u W=1u
M1338 o4 ibias vss vss sky130_fd_pr__nfet_01v8 L=0.5u W=1u
M1339 o4 ibias vss vss sky130_fd_pr__nfet_01v8 L=0.5u W=1u
M1340 o4 ibias vss vss sky130_fd_pr__nfet_01v8 L=0.5u W=1u
M1341 o4 ibias vss vss sky130_fd_pr__nfet_01v8 L=0.5u W=1u
M1342 o4 ibias vss vss sky130_fd_pr__nfet_01v8 L=0.5u W=1u
M1343 o4 ibias vss vss sky130_fd_pr__nfet_01v8 L=0.5u W=1u
M1344 o4 ibias vss vss sky130_fd_pr__nfet_01v8 L=0.5u W=1u
M1345 o4 ibias vss vss sky130_fd_pr__nfet_01v8 L=0.5u W=1u
M1346 o4 ibias vss vss sky130_fd_pr__nfet_01v8 L=0.5u W=1u
M1347 o4 ibias vss vss sky130_fd_pr__nfet_01v8 L=0.5u W=1u
M1348 o4 ibias vss vss sky130_fd_pr__nfet_01v8 L=0.5u W=1u
M1349 o4 ibias vss vss sky130_fd_pr__nfet_01v8 L=0.5u W=1u
M1350 o4 ibias vss vss sky130_fd_pr__nfet_01v8 L=0.5u W=1u
M1351 o4 ibias vss vss sky130_fd_pr__nfet_01v8 L=0.5u W=1u
M1352 o4 ibias vss vss sky130_fd_pr__nfet_01v8 L=0.5u W=1u
M1353 o4 ibias vss vss sky130_fd_pr__nfet_01v8 L=0.5u W=1u
M1354 o4 ibias vss vss sky130_fd_pr__nfet_01v8 L=0.5u W=1u
M1355 o4 ibias vss vss sky130_fd_pr__nfet_01v8 L=0.5u W=1u
M1356 o4 ibias vss vss sky130_fd_pr__nfet_01v8 L=0.5u W=1u
M1357 o4 ibias vss vss sky130_fd_pr__nfet_01v8 L=0.5u W=1u
M1358 o4 ibias vss vss sky130_fd_pr__nfet_01v8 L=0.5u W=1u
M1359 o4 ibias vss vss sky130_fd_pr__nfet_01v8 L=0.5u W=1u
M1360 o4 ibias vss vss sky130_fd_pr__nfet_01v8 L=0.5u W=1u
M1361 o4 ibias vss vss sky130_fd_pr__nfet_01v8 L=0.5u W=1u
M1362 o4 ibias vss vss sky130_fd_pr__nfet_01v8 L=0.5u W=1u
M1363 o4 ibias vss vss sky130_fd_pr__nfet_01v8 L=0.5u W=1u
M1364 o4 ibias vss vss sky130_fd_pr__nfet_01v8 L=0.5u W=1u
M1365 o4 ibias vss vss sky130_fd_pr__nfet_01v8 L=0.5u W=1u
M1366 o4 ibias vss vss sky130_fd_pr__nfet_01v8 L=0.5u W=1u
M1367 o4 ibias vss vss sky130_fd_pr__nfet_01v8 L=0.5u W=1u
M1368 o4 ibias vss vss sky130_fd_pr__nfet_01v8 L=0.5u W=1u
M1369 o4 ibias vss vss sky130_fd_pr__nfet_01v8 L=0.5u W=1u
M1370 o4 ibias vss vss sky130_fd_pr__nfet_01v8 L=0.5u W=1u
M1371 o4 ibias vss vss sky130_fd_pr__nfet_01v8 L=0.5u W=1u
M1372 o4 ibias vss vss sky130_fd_pr__nfet_01v8 L=0.5u W=1u
M1373 o4 ibias vss vss sky130_fd_pr__nfet_01v8 L=0.5u W=1u
M1374 o4 ibias vss vss sky130_fd_pr__nfet_01v8 L=0.5u W=1u
M1375 o4 ibias vss vss sky130_fd_pr__nfet_01v8 L=0.5u W=1u
M1376 o4 ibias vss vss sky130_fd_pr__nfet_01v8 L=0.5u W=1u
M1377 o4 ibias vss vss sky130_fd_pr__nfet_01v8 L=0.5u W=1u
M1378 o4 ibias vss vss sky130_fd_pr__nfet_01v8 L=0.5u W=1u
M1379 o4 ibias vss vss sky130_fd_pr__nfet_01v8 L=0.5u W=1u
M1380 o4 ibias vss vss sky130_fd_pr__nfet_01v8 L=0.5u W=1u
M1381 o4 ibias vss vss sky130_fd_pr__nfet_01v8 L=0.5u W=1u
M1382 o4 ibias vss vss sky130_fd_pr__nfet_01v8 L=0.5u W=1u
M1383 o4 ibias vss vss sky130_fd_pr__nfet_01v8 L=0.5u W=1u
M1384 o4 ibias vss vss sky130_fd_pr__nfet_01v8 L=0.5u W=1u
M1385 o4 ibias vss vss sky130_fd_pr__nfet_01v8 L=0.5u W=1u
M1386 o4 ibias vss vss sky130_fd_pr__nfet_01v8 L=0.5u W=1u
M1387 o4 ibias vss vss sky130_fd_pr__nfet_01v8 L=0.5u W=1u
M1388 o4 ibias vss vss sky130_fd_pr__nfet_01v8 L=0.5u W=1u
M1389 o4 ibias vss vss sky130_fd_pr__nfet_01v8 L=0.5u W=1u
M1390 o4 ibias vss vss sky130_fd_pr__nfet_01v8 L=0.5u W=1u
M1391 o4 ibias vss vss sky130_fd_pr__nfet_01v8 L=0.5u W=1u
M1392 o4 ibias vss vss sky130_fd_pr__nfet_01v8 L=0.5u W=1u
M1393 o4 ibias vss vss sky130_fd_pr__nfet_01v8 L=0.5u W=1u
M1394 o4 ibias vss vss sky130_fd_pr__nfet_01v8 L=0.5u W=1u
M1395 o4 ibias vss vss sky130_fd_pr__nfet_01v8 L=0.5u W=1u
M1396 o4 ibias vss vss sky130_fd_pr__nfet_01v8 L=0.5u W=1u
M1397 o4 ibias vss vss sky130_fd_pr__nfet_01v8 L=0.5u W=1u
M1398 o4 ibias vss vss sky130_fd_pr__nfet_01v8 L=0.5u W=1u
M1399 o4 ibias vss vss sky130_fd_pr__nfet_01v8 L=0.5u W=1u
M1400 o4 ibias vss vss sky130_fd_pr__nfet_01v8 L=0.5u W=1u
M1401 o4 ibias vss vss sky130_fd_pr__nfet_01v8 L=0.5u W=1u
M1402 o4 ibias vss vss sky130_fd_pr__nfet_01v8 L=0.5u W=1u
M1403 o4 ibias vss vss sky130_fd_pr__nfet_01v8 L=0.5u W=1u
M1404 o4 ibias vss vss sky130_fd_pr__nfet_01v8 L=0.5u W=1u
M1405 o4 ibias vss vss sky130_fd_pr__nfet_01v8 L=0.5u W=1u
M1406 o4 ibias vss vss sky130_fd_pr__nfet_01v8 L=0.5u W=1u
M1407 o4 ibias vss vss sky130_fd_pr__nfet_01v8 L=0.5u W=1u
M1408 o4 ibias vss vss sky130_fd_pr__nfet_01v8 L=0.5u W=1u
M1409 o4 ibias vss vss sky130_fd_pr__nfet_01v8 L=0.5u W=1u
M1410 o4 ibias vss vss sky130_fd_pr__nfet_01v8 L=0.5u W=1u
M1411 o4 ibias vss vss sky130_fd_pr__nfet_01v8 L=0.5u W=1u
M1412 o4 ibias vss vss sky130_fd_pr__nfet_01v8 L=0.5u W=1u
M1413 o4 ibias vss vss sky130_fd_pr__nfet_01v8 L=0.5u W=1u
M1414 o4 ibias vss vss sky130_fd_pr__nfet_01v8 L=0.5u W=1u
M1415 o4 ibias vss vss sky130_fd_pr__nfet_01v8 L=0.5u W=1u
M1416 o4 ibias vss vss sky130_fd_pr__nfet_01v8 L=0.5u W=1u
M1417 o4 ibias vss vss sky130_fd_pr__nfet_01v8 L=0.5u W=1u
M1418 o4 ibias vss vss sky130_fd_pr__nfet_01v8 L=0.5u W=1u
M1419 o4 ibias vss vss sky130_fd_pr__nfet_01v8 L=0.5u W=1u
M1420 o4 ibias vss vss sky130_fd_pr__nfet_01v8 L=0.5u W=1u
M1421 o4 ibias vss vss sky130_fd_pr__nfet_01v8 L=0.5u W=1u
M1422 o4 ibias vss vss sky130_fd_pr__nfet_01v8 L=0.5u W=1u
M1423 o4 ibias vss vss sky130_fd_pr__nfet_01v8 L=0.5u W=1u
M1424 o4 ibias vss vss sky130_fd_pr__nfet_01v8 L=0.5u W=1u
M1425 o4 ibias vss vss sky130_fd_pr__nfet_01v8 L=0.5u W=1u
M1426 o4 ibias vss vss sky130_fd_pr__nfet_01v8 L=0.5u W=1u
M1427 o4 ibias vss vss sky130_fd_pr__nfet_01v8 L=0.5u W=1u
M1428 o4 ibias vss vss sky130_fd_pr__nfet_01v8 L=0.5u W=1u
M1429 o4 ibias vss vss sky130_fd_pr__nfet_01v8 L=0.5u W=1u
M1430 o4 ibias vss vss sky130_fd_pr__nfet_01v8 L=0.5u W=1u
M1431 o4 ibias vss vss sky130_fd_pr__nfet_01v8 L=0.5u W=1u
M1432 o4 ibias vss vss sky130_fd_pr__nfet_01v8 L=0.5u W=1u
M1433 o4 ibias vss vss sky130_fd_pr__nfet_01v8 L=0.5u W=1u
M1434 o4 ibias vss vss sky130_fd_pr__nfet_01v8 L=0.5u W=1u
M1435 o4 ibias vss vss sky130_fd_pr__nfet_01v8 L=0.5u W=1u
M1436 o4 ibias vss vss sky130_fd_pr__nfet_01v8 L=0.5u W=1u
M1437 o4 ibias vss vss sky130_fd_pr__nfet_01v8 L=0.5u W=1u
M1438 o4 ibias vss vss sky130_fd_pr__nfet_01v8 L=0.5u W=1u
M1439 o4 ibias vss vss sky130_fd_pr__nfet_01v8 L=0.5u W=1u
M1440 o4 ibias vss vss sky130_fd_pr__nfet_01v8 L=0.5u W=1u
M1441 o4 ibias vss vss sky130_fd_pr__nfet_01v8 L=0.5u W=1u
M1442 o4 ibias vss vss sky130_fd_pr__nfet_01v8 L=0.5u W=1u
M1443 o4 ibias vss vss sky130_fd_pr__nfet_01v8 L=0.5u W=1u
M1444 o4 ibias vss vss sky130_fd_pr__nfet_01v8 L=0.5u W=1u
M1445 o4 ibias vss vss sky130_fd_pr__nfet_01v8 L=0.5u W=1u
M1446 o4 ibias vss vss sky130_fd_pr__nfet_01v8 L=0.5u W=1u
M1447 o4 ibias vss vss sky130_fd_pr__nfet_01v8 L=0.5u W=1u
M1448 o4 ibias vss vss sky130_fd_pr__nfet_01v8 L=0.5u W=1u
M1449 o4 ibias vss vss sky130_fd_pr__nfet_01v8 L=0.5u W=1u
M1450 o4 ibias vss vss sky130_fd_pr__nfet_01v8 L=0.5u W=1u
M1451 o4 ibias vss vss sky130_fd_pr__nfet_01v8 L=0.5u W=1u
M1452 o4 ibias vss vss sky130_fd_pr__nfet_01v8 L=0.5u W=1u
M1453 o4 ibias vss vss sky130_fd_pr__nfet_01v8 L=0.5u W=1u
M1454 o4 ibias vss vss sky130_fd_pr__nfet_01v8 L=0.5u W=1u
M1455 o4 ibias vss vss sky130_fd_pr__nfet_01v8 L=0.5u W=1u
M1456 o4 ibias vss vss sky130_fd_pr__nfet_01v8 L=0.5u W=1u
M1457 o4 ibias vss vss sky130_fd_pr__nfet_01v8 L=0.5u W=1u
M1458 o4 ibias vss vss sky130_fd_pr__nfet_01v8 L=0.5u W=1u
M1459 o4 ibias vss vss sky130_fd_pr__nfet_01v8 L=0.5u W=1u
M1460 o4 ibias vss vss sky130_fd_pr__nfet_01v8 L=0.5u W=1u
M1461 o4 ibias vss vss sky130_fd_pr__nfet_01v8 L=0.5u W=1u
M1462 o4 ibias vss vss sky130_fd_pr__nfet_01v8 L=0.5u W=1u
M1463 o4 ibias vss vss sky130_fd_pr__nfet_01v8 L=0.5u W=1u
M1464 o4 ibias vss vss sky130_fd_pr__nfet_01v8 L=0.5u W=1u
M1465 o4 ibias vss vss sky130_fd_pr__nfet_01v8 L=0.5u W=1u
M1466 o4 ibias vss vss sky130_fd_pr__nfet_01v8 L=0.5u W=1u
M1467 o4 ibias vss vss sky130_fd_pr__nfet_01v8 L=0.5u W=1u
M1468 o4 ibias vss vss sky130_fd_pr__nfet_01v8 L=0.5u W=1u
M1469 o4 ibias vss vss sky130_fd_pr__nfet_01v8 L=0.5u W=1u
M1470 o4 ibias vss vss sky130_fd_pr__nfet_01v8 L=0.5u W=1u
M1471 o4 ibias vss vss sky130_fd_pr__nfet_01v8 L=0.5u W=1u
M1472 o4 ibias vss vss sky130_fd_pr__nfet_01v8 L=0.5u W=1u
M1473 o4 ibias vss vss sky130_fd_pr__nfet_01v8 L=0.5u W=1u
M1474 o4 ibias vss vss sky130_fd_pr__nfet_01v8 L=0.5u W=1u
M1475 o4 ibias vss vss sky130_fd_pr__nfet_01v8 L=0.5u W=1u
M1476 o4 ibias vss vss sky130_fd_pr__nfet_01v8 L=0.5u W=1u
M1477 o4 ibias vss vss sky130_fd_pr__nfet_01v8 L=0.5u W=1u
M1478 o4 ibias vss vss sky130_fd_pr__nfet_01v8 L=0.5u W=1u
M1479 o4 ibias vss vss sky130_fd_pr__nfet_01v8 L=0.5u W=1u
M1480 o4 ibias vss vss sky130_fd_pr__nfet_01v8 L=0.5u W=1u
M1481 o4 ibias vss vss sky130_fd_pr__nfet_01v8 L=0.5u W=1u
M1482 o4 ibias vss vss sky130_fd_pr__nfet_01v8 L=0.5u W=1u
M1483 o4 ibias vss vss sky130_fd_pr__nfet_01v8 L=0.5u W=1u
M1484 o4 ibias vss vss sky130_fd_pr__nfet_01v8 L=0.5u W=1u
M1485 o4 ibias vss vss sky130_fd_pr__nfet_01v8 L=0.5u W=1u
M1486 o4 ibias vss vss sky130_fd_pr__nfet_01v8 L=0.5u W=1u
M1487 o4 ibias vss vss sky130_fd_pr__nfet_01v8 L=0.5u W=1u
M1488 o4 ibias vss vss sky130_fd_pr__nfet_01v8 L=0.5u W=1u
M1489 o4 ibias vss vss sky130_fd_pr__nfet_01v8 L=0.5u W=1u
M1490 o4 ibias vss vss sky130_fd_pr__nfet_01v8 L=0.5u W=1u
M1491 o4 ibias vss vss sky130_fd_pr__nfet_01v8 L=0.5u W=1u
M1492 o4 ibias vss vss sky130_fd_pr__nfet_01v8 L=0.5u W=1u
M1493 o4 ibias vss vss sky130_fd_pr__nfet_01v8 L=0.5u W=1u
M1494 o4 ibias vss vss sky130_fd_pr__nfet_01v8 L=0.5u W=1u
M1495 o4 ibias vss vss sky130_fd_pr__nfet_01v8 L=0.5u W=1u
M1496 o4 ibias vss vss sky130_fd_pr__nfet_01v8 L=0.5u W=1u
M1497 o4 ibias vss vss sky130_fd_pr__nfet_01v8 L=0.5u W=1u
M1498 o4 ibias vss vss sky130_fd_pr__nfet_01v8 L=0.5u W=1u
M1499 o4 ibias vss vss sky130_fd_pr__nfet_01v8 L=0.5u W=1u
M1500 o4 ibias vss vss sky130_fd_pr__nfet_01v8 L=0.5u W=1u
M1501 o4 ibias vss vss sky130_fd_pr__nfet_01v8 L=0.5u W=1u
M1502 o4 ibias vss vss sky130_fd_pr__nfet_01v8 L=0.5u W=1u
M1503 o4 ibias vss vss sky130_fd_pr__nfet_01v8 L=0.5u W=1u
M1504 o4 ibias vss vss sky130_fd_pr__nfet_01v8 L=0.5u W=1u
M1505 o4 ibias vss vss sky130_fd_pr__nfet_01v8 L=0.5u W=1u
M1506 o4 ibias vss vss sky130_fd_pr__nfet_01v8 L=0.5u W=1u
M1507 o4 ibias vss vss sky130_fd_pr__nfet_01v8 L=0.5u W=1u
M1508 o4 ibias vss vss sky130_fd_pr__nfet_01v8 L=0.5u W=1u
M1509 o4 ibias vss vss sky130_fd_pr__nfet_01v8 L=0.5u W=1u
M1510 o4 ibias vss vss sky130_fd_pr__nfet_01v8 L=0.5u W=1u
M1511 o4 ibias vss vss sky130_fd_pr__nfet_01v8 L=0.5u W=1u
M1512 o4 ibias vss vss sky130_fd_pr__nfet_01v8 L=0.5u W=1u
M1513 o4 ibias vss vss sky130_fd_pr__nfet_01v8 L=0.5u W=1u
M1514 o4 ibias vss vss sky130_fd_pr__nfet_01v8 L=0.5u W=1u
M1515 o4 ibias vss vss sky130_fd_pr__nfet_01v8 L=0.5u W=1u
M1516 o4 ibias vss vss sky130_fd_pr__nfet_01v8 L=0.5u W=1u
M1517 o4 ibias vss vss sky130_fd_pr__nfet_01v8 L=0.5u W=1u
M1518 o4 ibias vss vss sky130_fd_pr__nfet_01v8 L=0.5u W=1u
M1519 o4 ibias vss vss sky130_fd_pr__nfet_01v8 L=0.5u W=1u
M1520 o4 ibias vss vss sky130_fd_pr__nfet_01v8 L=0.5u W=1u
M1521 o4 ibias vss vss sky130_fd_pr__nfet_01v8 L=0.5u W=1u
M1522 o4 ibias vss vss sky130_fd_pr__nfet_01v8 L=0.5u W=1u
M1523 o4 ibias vss vss sky130_fd_pr__nfet_01v8 L=0.5u W=1u
M1524 o4 ibias vss vss sky130_fd_pr__nfet_01v8 L=0.5u W=1u
M1525 o4 ibias vss vss sky130_fd_pr__nfet_01v8 L=0.5u W=1u
M1526 o4 ibias vss vss sky130_fd_pr__nfet_01v8 L=0.5u W=1u
M1527 o4 ibias vss vss sky130_fd_pr__nfet_01v8 L=0.5u W=1u
M1528 o4 ibias vss vss sky130_fd_pr__nfet_01v8 L=0.5u W=1u
M1529 o4 ibias vss vss sky130_fd_pr__nfet_01v8 L=0.5u W=1u
M1530 o4 ibias vss vss sky130_fd_pr__nfet_01v8 L=0.5u W=1u
M1531 o4 ibias vss vss sky130_fd_pr__nfet_01v8 L=0.5u W=1u
M1532 o4 ibias vss vss sky130_fd_pr__nfet_01v8 L=0.5u W=1u
M1533 o4 ibias vss vss sky130_fd_pr__nfet_01v8 L=0.5u W=1u
M1534 o4 ibias vss vss sky130_fd_pr__nfet_01v8 L=0.5u W=1u
M1535 o4 ibias vss vss sky130_fd_pr__nfet_01v8 L=0.5u W=1u
M1536 o4 ibias vss vss sky130_fd_pr__nfet_01v8 L=0.5u W=1u
M1537 o4 ibias vss vss sky130_fd_pr__nfet_01v8 L=0.5u W=1u
M1538 o4 ibias vss vss sky130_fd_pr__nfet_01v8 L=0.5u W=1u
M1539 o4 ibias vss vss sky130_fd_pr__nfet_01v8 L=0.5u W=1u
M1540 o4 ibias vss vss sky130_fd_pr__nfet_01v8 L=0.5u W=1u
M1541 o4 ibias vss vss sky130_fd_pr__nfet_01v8 L=0.5u W=1u
M1542 o4 ibias vss vss sky130_fd_pr__nfet_01v8 L=0.5u W=1u
M1543 o4 ibias vss vss sky130_fd_pr__nfet_01v8 L=0.5u W=1u
M1544 o4 ibias vss vss sky130_fd_pr__nfet_01v8 L=0.5u W=1u
M1545 o4 ibias vss vss sky130_fd_pr__nfet_01v8 L=0.5u W=1u
M1546 o4 ibias vss vss sky130_fd_pr__nfet_01v8 L=0.5u W=1u
M1547 o4 ibias vss vss sky130_fd_pr__nfet_01v8 L=0.5u W=1u
M1548 o4 ibias vss vss sky130_fd_pr__nfet_01v8 L=0.5u W=1u
M1549 o4 ibias vss vss sky130_fd_pr__nfet_01v8 L=0.5u W=1u
M1550 o4 ibias vss vss sky130_fd_pr__nfet_01v8 L=0.5u W=1u
M1551 o4 ibias vss vss sky130_fd_pr__nfet_01v8 L=0.5u W=1u
M1552 o4 ibias vss vss sky130_fd_pr__nfet_01v8 L=0.5u W=1u
M1553 o4 ibias vss vss sky130_fd_pr__nfet_01v8 L=0.5u W=1u
M1554 o4 ibias vss vss sky130_fd_pr__nfet_01v8 L=0.5u W=1u
M1555 o4 ibias vss vss sky130_fd_pr__nfet_01v8 L=0.5u W=1u
M1556 o4 ibias vss vss sky130_fd_pr__nfet_01v8 L=0.5u W=1u
M1557 o4 ibias vss vss sky130_fd_pr__nfet_01v8 L=0.5u W=1u
M1558 o4 ibias vss vss sky130_fd_pr__nfet_01v8 L=0.5u W=1u
M1559 o4 ibias vss vss sky130_fd_pr__nfet_01v8 L=0.5u W=1u
M1560 o4 ibias vss vss sky130_fd_pr__nfet_01v8 L=0.5u W=1u
M1561 o4 ibias vss vss sky130_fd_pr__nfet_01v8 L=0.5u W=1u
M1562 o4 ibias vss vss sky130_fd_pr__nfet_01v8 L=0.5u W=1u
M1563 o4 ibias vss vss sky130_fd_pr__nfet_01v8 L=0.5u W=1u
M1564 o4 ibias vss vss sky130_fd_pr__nfet_01v8 L=0.5u W=1u
M1565 o4 ibias vss vss sky130_fd_pr__nfet_01v8 L=0.5u W=1u
M1566 o4 ibias vss vss sky130_fd_pr__nfet_01v8 L=0.5u W=1u
M1567 o4 ibias vss vss sky130_fd_pr__nfet_01v8 L=0.5u W=1u
M1568 o4 ibias vss vss sky130_fd_pr__nfet_01v8 L=0.5u W=1u
M1569 o4 ibias vss vss sky130_fd_pr__nfet_01v8 L=0.5u W=1u
M1570 o4 ibias vss vss sky130_fd_pr__nfet_01v8 L=0.5u W=1u
M1571 o4 ibias vss vss sky130_fd_pr__nfet_01v8 L=0.5u W=1u
M1572 o4 ibias vss vss sky130_fd_pr__nfet_01v8 L=0.5u W=1u
M1573 o4 ibias vss vss sky130_fd_pr__nfet_01v8 L=0.5u W=1u
M1574 o4 ibias vss vss sky130_fd_pr__nfet_01v8 L=0.5u W=1u
M1575 o4 ibias vss vss sky130_fd_pr__nfet_01v8 L=0.5u W=1u
M1576 o4 ibias vss vss sky130_fd_pr__nfet_01v8 L=0.5u W=1u
M1577 o4 ibias vss vss sky130_fd_pr__nfet_01v8 L=0.5u W=1u
M1578 o4 ibias vss vss sky130_fd_pr__nfet_01v8 L=0.5u W=1u
M1579 o4 ibias vss vss sky130_fd_pr__nfet_01v8 L=0.5u W=1u
M1580 o4 ibias vss vss sky130_fd_pr__nfet_01v8 L=0.5u W=1u
M1581 o4 ibias vss vss sky130_fd_pr__nfet_01v8 L=0.5u W=1u
M1582 o4 ibias vss vss sky130_fd_pr__nfet_01v8 L=0.5u W=1u
M1583 o4 ibias vss vss sky130_fd_pr__nfet_01v8 L=0.5u W=1u
M1584 o4 ibias vss vss sky130_fd_pr__nfet_01v8 L=0.5u W=1u
M1585 o4 ibias vss vss sky130_fd_pr__nfet_01v8 L=0.5u W=1u
M1586 o4 ibias vss vss sky130_fd_pr__nfet_01v8 L=0.5u W=1u
M1587 o4 ibias vss vss sky130_fd_pr__nfet_01v8 L=0.5u W=1u
M1588 o4 ibias vss vss sky130_fd_pr__nfet_01v8 L=0.5u W=1u
M1589 o4 ibias vss vss sky130_fd_pr__nfet_01v8 L=0.5u W=1u
M1590 o4 ibias vss vss sky130_fd_pr__nfet_01v8 L=0.5u W=1u
M1591 o4 ibias vss vss sky130_fd_pr__nfet_01v8 L=0.5u W=1u
M1592 o4 ibias vss vss sky130_fd_pr__nfet_01v8 L=0.5u W=1u
M1593 o4 ibias vss vss sky130_fd_pr__nfet_01v8 L=0.5u W=1u
M1594 o4 ibias vss vss sky130_fd_pr__nfet_01v8 L=0.5u W=1u
M1595 o4 ibias vss vss sky130_fd_pr__nfet_01v8 L=0.5u W=1u
M1596 o4 ibias vss vss sky130_fd_pr__nfet_01v8 L=0.5u W=1u
M1597 o4 ibias vss vss sky130_fd_pr__nfet_01v8 L=0.5u W=1u
M1598 o4 ibias vss vss sky130_fd_pr__nfet_01v8 L=0.5u W=1u
M1599 o4 ibias vss vss sky130_fd_pr__nfet_01v8 L=0.5u W=1u
M1600 o4 ibias vss vss sky130_fd_pr__nfet_01v8 L=0.5u W=1u
M1601 o4 ibias vss vss sky130_fd_pr__nfet_01v8 L=0.5u W=1u
M1602 o4 ibias vss vss sky130_fd_pr__nfet_01v8 L=0.5u W=1u
M1603 o4 ibias vss vss sky130_fd_pr__nfet_01v8 L=0.5u W=1u
M1604 o4 ibias vss vss sky130_fd_pr__nfet_01v8 L=0.5u W=1u
M1605 o4 ibias vss vss sky130_fd_pr__nfet_01v8 L=0.5u W=1u
M1606 o4 ibias vss vss sky130_fd_pr__nfet_01v8 L=0.5u W=1u
M1607 o4 ibias vss vss sky130_fd_pr__nfet_01v8 L=0.5u W=1u
M1608 o4 ibias vss vss sky130_fd_pr__nfet_01v8 L=0.5u W=1u
M1609 o4 ibias vss vss sky130_fd_pr__nfet_01v8 L=0.5u W=1u
M1610 o4 ibias vss vss sky130_fd_pr__nfet_01v8 L=0.5u W=1u
M1611 o4 ibias vss vss sky130_fd_pr__nfet_01v8 L=0.5u W=1u
M1612 o4 ibias vss vss sky130_fd_pr__nfet_01v8 L=0.5u W=1u
M1613 o4 ibias vss vss sky130_fd_pr__nfet_01v8 L=0.5u W=1u
M1614 o4 ibias vss vss sky130_fd_pr__nfet_01v8 L=0.5u W=1u
M1615 o4 ibias vss vss sky130_fd_pr__nfet_01v8 L=0.5u W=1u
M1616 o4 ibias vss vss sky130_fd_pr__nfet_01v8 L=0.5u W=1u
M1617 o4 ibias vss vss sky130_fd_pr__nfet_01v8 L=0.5u W=1u
M1618 o4 ibias vss vss sky130_fd_pr__nfet_01v8 L=0.5u W=1u
M1619 o4 ibias vss vss sky130_fd_pr__nfet_01v8 L=0.5u W=1u
M1620 o4 ibias vss vss sky130_fd_pr__nfet_01v8 L=0.5u W=1u
M1621 o4 ibias vss vss sky130_fd_pr__nfet_01v8 L=0.5u W=1u
M1622 o4 ibias vss vss sky130_fd_pr__nfet_01v8 L=0.5u W=1u
M1623 o4 ibias vss vss sky130_fd_pr__nfet_01v8 L=0.5u W=1u
M1624 o4 ibias vss vss sky130_fd_pr__nfet_01v8 L=0.5u W=1u
M1625 o4 ibias vss vss sky130_fd_pr__nfet_01v8 L=0.5u W=1u
M1626 o4 ibias vss vss sky130_fd_pr__nfet_01v8 L=0.5u W=1u
M1627 o4 ibias vss vss sky130_fd_pr__nfet_01v8 L=0.5u W=1u
M1628 o4 ibias vss vss sky130_fd_pr__nfet_01v8 L=0.5u W=1u
M1629 o4 ibias vss vss sky130_fd_pr__nfet_01v8 L=0.5u W=1u
M1630 o4 ibias vss vss sky130_fd_pr__nfet_01v8 L=0.5u W=1u
M1631 o4 ibias vss vss sky130_fd_pr__nfet_01v8 L=0.5u W=1u
M1632 o4 ibias vss vss sky130_fd_pr__nfet_01v8 L=0.5u W=1u
M1633 o4 ibias vss vss sky130_fd_pr__nfet_01v8 L=0.5u W=1u
M1634 o4 ibias vss vss sky130_fd_pr__nfet_01v8 L=0.5u W=1u
M1635 o4 ibias vss vss sky130_fd_pr__nfet_01v8 L=0.5u W=1u
M1636 o4 ibias vss vss sky130_fd_pr__nfet_01v8 L=0.5u W=1u
M1637 o4 ibias vss vss sky130_fd_pr__nfet_01v8 L=0.5u W=1u
M1638 o4 ibias vss vss sky130_fd_pr__nfet_01v8 L=0.5u W=1u
M1639 o4 ibias vss vss sky130_fd_pr__nfet_01v8 L=0.5u W=1u
M1640 o4 ibias vss vss sky130_fd_pr__nfet_01v8 L=0.5u W=1u
M1641 o4 ibias vss vss sky130_fd_pr__nfet_01v8 L=0.5u W=1u
M1642 o4 ibias vss vss sky130_fd_pr__nfet_01v8 L=0.5u W=1u
M1643 o4 ibias vss vss sky130_fd_pr__nfet_01v8 L=0.5u W=1u
M1644 o4 ibias vss vss sky130_fd_pr__nfet_01v8 L=0.5u W=1u
M1645 o4 ibias vss vss sky130_fd_pr__nfet_01v8 L=0.5u W=1u
M1646 o4 ibias vss vss sky130_fd_pr__nfet_01v8 L=0.5u W=1u
M1647 o4 ibias vss vss sky130_fd_pr__nfet_01v8 L=0.5u W=1u
M1648 o4 ibias vss vss sky130_fd_pr__nfet_01v8 L=0.5u W=1u
M1649 o4 ibias vss vss sky130_fd_pr__nfet_01v8 L=0.5u W=1u
M1650 o4 ibias vss vss sky130_fd_pr__nfet_01v8 L=0.5u W=1u
M1651 o4 ibias vss vss sky130_fd_pr__nfet_01v8 L=0.5u W=1u
M1652 o4 ibias vss vss sky130_fd_pr__nfet_01v8 L=0.5u W=1u
M1653 o4 ibias vss vss sky130_fd_pr__nfet_01v8 L=0.5u W=1u
M1654 o4 ibias vss vss sky130_fd_pr__nfet_01v8 L=0.5u W=1u
M1655 o4 ibias vss vss sky130_fd_pr__nfet_01v8 L=0.5u W=1u
M1656 o4 ibias vss vss sky130_fd_pr__nfet_01v8 L=0.5u W=1u
M1657 o4 ibias vss vss sky130_fd_pr__nfet_01v8 L=0.5u W=1u
M1658 o4 ibias vss vss sky130_fd_pr__nfet_01v8 L=0.5u W=1u
M1659 o4 ibias vss vss sky130_fd_pr__nfet_01v8 L=0.5u W=1u
M1660 o4 ibias vss vss sky130_fd_pr__nfet_01v8 L=0.5u W=1u
M1661 o4 ibias vss vss sky130_fd_pr__nfet_01v8 L=0.5u W=1u
M1662 o4 ibias vss vss sky130_fd_pr__nfet_01v8 L=0.5u W=1u
M1663 o4 ibias vss vss sky130_fd_pr__nfet_01v8 L=0.5u W=1u
M1664 o4 ibias vss vss sky130_fd_pr__nfet_01v8 L=0.5u W=1u
M1665 o4 ibias vss vss sky130_fd_pr__nfet_01v8 L=0.5u W=1u
M1666 o4 ibias vss vss sky130_fd_pr__nfet_01v8 L=0.5u W=1u
M1667 o4 ibias vss vss sky130_fd_pr__nfet_01v8 L=0.5u W=1u
M1668 o4 ibias vss vss sky130_fd_pr__nfet_01v8 L=0.5u W=1u
M1669 o4 ibias vss vss sky130_fd_pr__nfet_01v8 L=0.5u W=1u
M1670 o4 ibias vss vss sky130_fd_pr__nfet_01v8 L=0.5u W=1u
M1671 o4 ibias vss vss sky130_fd_pr__nfet_01v8 L=0.5u W=1u
M1672 o4 ibias vss vss sky130_fd_pr__nfet_01v8 L=0.5u W=1u
M1673 o4 ibias vss vss sky130_fd_pr__nfet_01v8 L=0.5u W=1u
M1674 o4 ibias vss vss sky130_fd_pr__nfet_01v8 L=0.5u W=1u
M1675 o4 ibias vss vss sky130_fd_pr__nfet_01v8 L=0.5u W=1u
M1676 o4 ibias vss vss sky130_fd_pr__nfet_01v8 L=0.5u W=1u
M1677 o4 ibias vss vss sky130_fd_pr__nfet_01v8 L=0.5u W=1u
M1678 o4 ibias vss vss sky130_fd_pr__nfet_01v8 L=0.5u W=1u
M1679 o4 ibias vss vss sky130_fd_pr__nfet_01v8 L=0.5u W=1u
M1680 o4 ibias vss vss sky130_fd_pr__nfet_01v8 L=0.5u W=1u
M1681 o4 ibias vss vss sky130_fd_pr__nfet_01v8 L=0.5u W=1u
M1682 o4 ibias vss vss sky130_fd_pr__nfet_01v8 L=0.5u W=1u
M1683 o4 ibias vss vss sky130_fd_pr__nfet_01v8 L=0.5u W=1u
M1684 o4 ibias vss vss sky130_fd_pr__nfet_01v8 L=0.5u W=1u
M1685 o4 ibias vss vss sky130_fd_pr__nfet_01v8 L=0.5u W=1u
M1686 o4 ibias vss vss sky130_fd_pr__nfet_01v8 L=0.5u W=1u
M1687 o4 ibias vss vss sky130_fd_pr__nfet_01v8 L=0.5u W=1u
M1688 o4 ibias vss vss sky130_fd_pr__nfet_01v8 L=0.5u W=1u
M1689 o4 ibias vss vss sky130_fd_pr__nfet_01v8 L=0.5u W=1u
M1690 o4 ibias vss vss sky130_fd_pr__nfet_01v8 L=0.5u W=1u
M1691 o4 ibias vss vss sky130_fd_pr__nfet_01v8 L=0.5u W=1u
M1692 o4 ibias vss vss sky130_fd_pr__nfet_01v8 L=0.5u W=1u
M1693 o4 ibias vss vss sky130_fd_pr__nfet_01v8 L=0.5u W=1u
M1694 o4 ibias vss vss sky130_fd_pr__nfet_01v8 L=0.5u W=1u
M1695 o4 ibias vss vss sky130_fd_pr__nfet_01v8 L=0.5u W=1u
M1696 o4 ibias vss vss sky130_fd_pr__nfet_01v8 L=0.5u W=1u
M1697 o4 ibias vss vss sky130_fd_pr__nfet_01v8 L=0.5u W=1u
M1698 o4 ibias vss vss sky130_fd_pr__nfet_01v8 L=0.5u W=1u
M1699 o4 ibias vss vss sky130_fd_pr__nfet_01v8 L=0.5u W=1u
M1700 o4 ibias vss vss sky130_fd_pr__nfet_01v8 L=0.5u W=1u
M1701 o4 ibias vss vss sky130_fd_pr__nfet_01v8 L=0.5u W=1u
M1702 o4 ibias vss vss sky130_fd_pr__nfet_01v8 L=0.5u W=1u
M1703 o4 ibias vss vss sky130_fd_pr__nfet_01v8 L=0.5u W=1u
M1704 o4 ibias vss vss sky130_fd_pr__nfet_01v8 L=0.5u W=1u
M1705 o4 ibias vss vss sky130_fd_pr__nfet_01v8 L=0.5u W=1u
M1706 o4 ibias vss vss sky130_fd_pr__nfet_01v8 L=0.5u W=1u
M1707 o4 ibias vss vss sky130_fd_pr__nfet_01v8 L=0.5u W=1u
M1708 o4 ibias vss vss sky130_fd_pr__nfet_01v8 L=0.5u W=1u
M1709 o4 ibias vss vss sky130_fd_pr__nfet_01v8 L=0.5u W=1u
M1710 o4 ibias vss vss sky130_fd_pr__nfet_01v8 L=0.5u W=1u
M1711 o4 ibias vss vss sky130_fd_pr__nfet_01v8 L=0.5u W=1u
M1712 o4 ibias vss vss sky130_fd_pr__nfet_01v8 L=0.5u W=1u
M1713 o4 ibias vss vss sky130_fd_pr__nfet_01v8 L=0.5u W=1u
M1714 o4 ibias vss vss sky130_fd_pr__nfet_01v8 L=0.5u W=1u
M1715 o4 ibias vss vss sky130_fd_pr__nfet_01v8 L=0.5u W=1u
M1716 o4 ibias vss vss sky130_fd_pr__nfet_01v8 L=0.5u W=1u
M1717 o4 ibias vss vss sky130_fd_pr__nfet_01v8 L=0.5u W=1u
M1718 o4 ibias vss vss sky130_fd_pr__nfet_01v8 L=0.5u W=1u
M1719 o4 ibias vss vss sky130_fd_pr__nfet_01v8 L=0.5u W=1u
M1720 o4 ibias vss vss sky130_fd_pr__nfet_01v8 L=0.5u W=1u
M1721 o4 ibias vss vss sky130_fd_pr__nfet_01v8 L=0.5u W=1u
M1722 o4 ibias vss vss sky130_fd_pr__nfet_01v8 L=0.5u W=1u
M1723 o4 ibias vss vss sky130_fd_pr__nfet_01v8 L=0.5u W=1u
M1724 o4 ibias vss vss sky130_fd_pr__nfet_01v8 L=0.5u W=1u
M1725 o4 ibias vss vss sky130_fd_pr__nfet_01v8 L=0.5u W=1u
M1726 o4 ibias vss vss sky130_fd_pr__nfet_01v8 L=0.5u W=1u
M1727 o4 ibias vss vss sky130_fd_pr__nfet_01v8 L=0.5u W=1u
M1728 o4 ibias vss vss sky130_fd_pr__nfet_01v8 L=0.5u W=1u
M1729 o4 ibias vss vss sky130_fd_pr__nfet_01v8 L=0.5u W=1u
M1730 o4 ibias vss vss sky130_fd_pr__nfet_01v8 L=0.5u W=1u
M1731 o4 ibias vss vss sky130_fd_pr__nfet_01v8 L=0.5u W=1u
M1732 o4 ibias vss vss sky130_fd_pr__nfet_01v8 L=0.5u W=1u
M1733 o4 ibias vss vss sky130_fd_pr__nfet_01v8 L=0.5u W=1u
M1734 o4 ibias vss vss sky130_fd_pr__nfet_01v8 L=0.5u W=1u
M1735 o4 ibias vss vss sky130_fd_pr__nfet_01v8 L=0.5u W=1u
M1736 o4 ibias vss vss sky130_fd_pr__nfet_01v8 L=0.5u W=1u
M1737 o4 ibias vss vss sky130_fd_pr__nfet_01v8 L=0.5u W=1u
M1738 o4 ibias vss vss sky130_fd_pr__nfet_01v8 L=0.5u W=1u
M1739 o4 ibias vss vss sky130_fd_pr__nfet_01v8 L=0.5u W=1u
M1740 o4 ibias vss vss sky130_fd_pr__nfet_01v8 L=0.5u W=1u
M1741 o4 ibias vss vss sky130_fd_pr__nfet_01v8 L=0.5u W=1u
M1742 o4 ibias vss vss sky130_fd_pr__nfet_01v8 L=0.5u W=1u
M1743 o4 ibias vss vss sky130_fd_pr__nfet_01v8 L=0.5u W=1u
M1744 o4 ibias vss vss sky130_fd_pr__nfet_01v8 L=0.5u W=1u
M1745 o4 ibias vss vss sky130_fd_pr__nfet_01v8 L=0.5u W=1u
M1746 o4 ibias vss vss sky130_fd_pr__nfet_01v8 L=0.5u W=1u
M1747 o4 ibias vss vss sky130_fd_pr__nfet_01v8 L=0.5u W=1u
M1748 o4 ibias vss vss sky130_fd_pr__nfet_01v8 L=0.5u W=1u
M1749 o4 ibias vss vss sky130_fd_pr__nfet_01v8 L=0.5u W=1u
M1750 o4 ibias vss vss sky130_fd_pr__nfet_01v8 L=0.5u W=1u
M1751 o4 ibias vss vss sky130_fd_pr__nfet_01v8 L=0.5u W=1u
M1752 o4 ibias vss vss sky130_fd_pr__nfet_01v8 L=0.5u W=1u
M1753 o4 ibias vss vss sky130_fd_pr__nfet_01v8 L=0.5u W=1u
M1754 o4 ibias vss vss sky130_fd_pr__nfet_01v8 L=0.5u W=1u
M1755 o4 ibias vss vss sky130_fd_pr__nfet_01v8 L=0.5u W=1u
M1756 o4 ibias vss vss sky130_fd_pr__nfet_01v8 L=0.5u W=1u
M1757 o4 ibias vss vss sky130_fd_pr__nfet_01v8 L=0.5u W=1u
M1758 o4 ibias vss vss sky130_fd_pr__nfet_01v8 L=0.5u W=1u
M1759 o4 ibias vss vss sky130_fd_pr__nfet_01v8 L=0.5u W=1u
M1760 o4 ibias vss vss sky130_fd_pr__nfet_01v8 L=0.5u W=1u
M1761 o4 ibias vss vss sky130_fd_pr__nfet_01v8 L=0.5u W=1u
M1762 o4 ibias vss vss sky130_fd_pr__nfet_01v8 L=0.5u W=1u
M1763 o4 ibias vss vss sky130_fd_pr__nfet_01v8 L=0.5u W=1u
M1764 o4 ibias vss vss sky130_fd_pr__nfet_01v8 L=0.5u W=1u
M1765 o4 ibias vss vss sky130_fd_pr__nfet_01v8 L=0.5u W=1u
M1766 o4 ibias vss vss sky130_fd_pr__nfet_01v8 L=0.5u W=1u
M1767 o4 ibias vss vss sky130_fd_pr__nfet_01v8 L=0.5u W=1u
M1768 o4 ibias vss vss sky130_fd_pr__nfet_01v8 L=0.5u W=1u
M1769 o4 ibias vss vss sky130_fd_pr__nfet_01v8 L=0.5u W=1u
M1770 o4 ibias vss vss sky130_fd_pr__nfet_01v8 L=0.5u W=1u
M1771 o4 ibias vss vss sky130_fd_pr__nfet_01v8 L=0.5u W=1u
M1772 o4 ibias vss vss sky130_fd_pr__nfet_01v8 L=0.5u W=1u
M1773 o4 ibias vss vss sky130_fd_pr__nfet_01v8 L=0.5u W=1u
M1774 o4 ibias vss vss sky130_fd_pr__nfet_01v8 L=0.5u W=1u
M1775 o4 ibias vss vss sky130_fd_pr__nfet_01v8 L=0.5u W=1u
M1776 o4 ibias vss vss sky130_fd_pr__nfet_01v8 L=0.5u W=1u
M1777 o4 ibias vss vss sky130_fd_pr__nfet_01v8 L=0.5u W=1u
M1778 o4 ibias vss vss sky130_fd_pr__nfet_01v8 L=0.5u W=1u
M1779 o4 ibias vss vss sky130_fd_pr__nfet_01v8 L=0.5u W=1u
M1780 o4 ibias vss vss sky130_fd_pr__nfet_01v8 L=0.5u W=1u
M1781 o4 ibias vss vss sky130_fd_pr__nfet_01v8 L=0.5u W=1u
M1782 o4 ibias vss vss sky130_fd_pr__nfet_01v8 L=0.5u W=1u
M1783 o4 ibias vss vss sky130_fd_pr__nfet_01v8 L=0.5u W=1u
M1784 o4 ibias vss vss sky130_fd_pr__nfet_01v8 L=0.5u W=1u
M1785 o4 ibias vss vss sky130_fd_pr__nfet_01v8 L=0.5u W=1u
M1786 o4 ibias vss vss sky130_fd_pr__nfet_01v8 L=0.5u W=1u
M1787 o4 ibias vss vss sky130_fd_pr__nfet_01v8 L=0.5u W=1u
M1788 o4 ibias vss vss sky130_fd_pr__nfet_01v8 L=0.5u W=1u
M1789 o4 ibias vss vss sky130_fd_pr__nfet_01v8 L=0.5u W=1u
M1790 o4 ibias vss vss sky130_fd_pr__nfet_01v8 L=0.5u W=1u
M1791 o4 ibias vss vss sky130_fd_pr__nfet_01v8 L=0.5u W=1u
M1792 o4 ibias vss vss sky130_fd_pr__nfet_01v8 L=0.5u W=1u
M1793 o4 ibias vss vss sky130_fd_pr__nfet_01v8 L=0.5u W=1u
M1794 o4 ibias vss vss sky130_fd_pr__nfet_01v8 L=0.5u W=1u
M1795 o4 ibias vss vss sky130_fd_pr__nfet_01v8 L=0.5u W=1u
M1796 o4 ibias vss vss sky130_fd_pr__nfet_01v8 L=0.5u W=1u
M1797 o4 ibias vss vss sky130_fd_pr__nfet_01v8 L=0.5u W=1u
M1798 o4 ibias vss vss sky130_fd_pr__nfet_01v8 L=0.5u W=1u
M1799 o4 ibias vss vss sky130_fd_pr__nfet_01v8 L=0.5u W=1u
M1800 o4 ibias vss vss sky130_fd_pr__nfet_01v8 L=0.5u W=1u
M1801 o4 ibias vss vss sky130_fd_pr__nfet_01v8 L=0.5u W=1u
M1802 o4 ibias vss vss sky130_fd_pr__nfet_01v8 L=0.5u W=1u
M1803 o4 ibias vss vss sky130_fd_pr__nfet_01v8 L=0.5u W=1u
M1804 o4 ibias vss vss sky130_fd_pr__nfet_01v8 L=0.5u W=1u
M1805 o4 ibias vss vss sky130_fd_pr__nfet_01v8 L=0.5u W=1u
M1806 o4 ibias vss vss sky130_fd_pr__nfet_01v8 L=0.5u W=1u
M1807 o4 ibias vss vss sky130_fd_pr__nfet_01v8 L=0.5u W=1u
M1808 o4 ibias vss vss sky130_fd_pr__nfet_01v8 L=0.5u W=1u
M1809 o4 ibias vss vss sky130_fd_pr__nfet_01v8 L=0.5u W=1u
M1810 o4 ibias vss vss sky130_fd_pr__nfet_01v8 L=0.5u W=1u
M1811 o4 ibias vss vss sky130_fd_pr__nfet_01v8 L=0.5u W=1u
M1812 o4 ibias vss vss sky130_fd_pr__nfet_01v8 L=0.5u W=1u
M1813 o4 ibias vss vss sky130_fd_pr__nfet_01v8 L=0.5u W=1u
M1814 o4 ibias vss vss sky130_fd_pr__nfet_01v8 L=0.5u W=1u
M1815 o4 ibias vss vss sky130_fd_pr__nfet_01v8 L=0.5u W=1u
M1816 o4 ibias vss vss sky130_fd_pr__nfet_01v8 L=0.5u W=1u
M1817 o4 ibias vss vss sky130_fd_pr__nfet_01v8 L=0.5u W=1u
M1818 o4 ibias vss vss sky130_fd_pr__nfet_01v8 L=0.5u W=1u
M1819 o4 ibias vss vss sky130_fd_pr__nfet_01v8 L=0.5u W=1u
M1820 o4 ibias vss vss sky130_fd_pr__nfet_01v8 L=0.5u W=1u
M1821 o4 ibias vss vss sky130_fd_pr__nfet_01v8 L=0.5u W=1u
M1822 o4 ibias vss vss sky130_fd_pr__nfet_01v8 L=0.5u W=1u
M1823 o4 ibias vss vss sky130_fd_pr__nfet_01v8 L=0.5u W=1u
M1824 o4 ibias vss vss sky130_fd_pr__nfet_01v8 L=0.5u W=1u
M1825 o4 ibias vss vss sky130_fd_pr__nfet_01v8 L=0.5u W=1u
M1826 o4 ibias vss vss sky130_fd_pr__nfet_01v8 L=0.5u W=1u
M1827 o4 ibias vss vss sky130_fd_pr__nfet_01v8 L=0.5u W=1u
M1828 o4 ibias vss vss sky130_fd_pr__nfet_01v8 L=0.5u W=1u
M1829 o4 ibias vss vss sky130_fd_pr__nfet_01v8 L=0.5u W=1u
M1830 o4 ibias vss vss sky130_fd_pr__nfet_01v8 L=0.5u W=1u
M1831 o4 ibias vss vss sky130_fd_pr__nfet_01v8 L=0.5u W=1u
M1832 o4 ibias vss vss sky130_fd_pr__nfet_01v8 L=0.5u W=1u
M1833 o4 ibias vss vss sky130_fd_pr__nfet_01v8 L=0.5u W=1u
M1834 o4 ibias vss vss sky130_fd_pr__nfet_01v8 L=0.5u W=1u
M1835 o4 ibias vss vss sky130_fd_pr__nfet_01v8 L=0.5u W=1u
M1836 o4 ibias vss vss sky130_fd_pr__nfet_01v8 L=0.5u W=1u
M1837 o4 ibias vss vss sky130_fd_pr__nfet_01v8 L=0.5u W=1u
M1838 o4 ibias vss vss sky130_fd_pr__nfet_01v8 L=0.5u W=1u
M1839 o4 ibias vss vss sky130_fd_pr__nfet_01v8 L=0.5u W=1u
M1840 o4 ibias vss vss sky130_fd_pr__nfet_01v8 L=0.5u W=1u
M1841 o4 ibias vss vss sky130_fd_pr__nfet_01v8 L=0.5u W=1u
M1842 o4 ibias vss vss sky130_fd_pr__nfet_01v8 L=0.5u W=1u
M1843 o4 ibias vss vss sky130_fd_pr__nfet_01v8 L=0.5u W=1u
M1844 o4 ibias vss vss sky130_fd_pr__nfet_01v8 L=0.5u W=1u
M1845 o4 ibias vss vss sky130_fd_pr__nfet_01v8 L=0.5u W=1u
M1846 o4 ibias vss vss sky130_fd_pr__nfet_01v8 L=0.5u W=1u
M1847 o4 ibias vss vss sky130_fd_pr__nfet_01v8 L=0.5u W=1u
M1848 o4 ibias vss vss sky130_fd_pr__nfet_01v8 L=0.5u W=1u
M1849 o4 ibias vss vss sky130_fd_pr__nfet_01v8 L=0.5u W=1u
M1850 o4 ibias vss vss sky130_fd_pr__nfet_01v8 L=0.5u W=1u
M1851 o4 ibias vss vss sky130_fd_pr__nfet_01v8 L=0.5u W=1u
M1852 o4 ibias vss vss sky130_fd_pr__nfet_01v8 L=0.5u W=1u
M1853 o4 ibias vss vss sky130_fd_pr__nfet_01v8 L=0.5u W=1u
M1854 o4 ibias vss vss sky130_fd_pr__nfet_01v8 L=0.5u W=1u
M1855 o4 ibias vss vss sky130_fd_pr__nfet_01v8 L=0.5u W=1u
M1856 o4 ibias vss vss sky130_fd_pr__nfet_01v8 L=0.5u W=1u
M1857 o4 ibias vss vss sky130_fd_pr__nfet_01v8 L=0.5u W=1u
M1858 o4 ibias vss vss sky130_fd_pr__nfet_01v8 L=0.5u W=1u
M1859 o4 ibias vss vss sky130_fd_pr__nfet_01v8 L=0.5u W=1u
M1860 o4 ibias vss vss sky130_fd_pr__nfet_01v8 L=0.5u W=1u
M1861 o4 ibias vss vss sky130_fd_pr__nfet_01v8 L=0.5u W=1u
M1862 o4 ibias vss vss sky130_fd_pr__nfet_01v8 L=0.5u W=1u
M1863 o4 ibias vss vss sky130_fd_pr__nfet_01v8 L=0.5u W=1u
M1864 o4 ibias vss vss sky130_fd_pr__nfet_01v8 L=0.5u W=1u
M1865 o4 ibias vss vss sky130_fd_pr__nfet_01v8 L=0.5u W=1u
M1866 o4 ibias vss vss sky130_fd_pr__nfet_01v8 L=0.5u W=1u
M1867 o4 ibias vss vss sky130_fd_pr__nfet_01v8 L=0.5u W=1u
M1868 o4 ibias vss vss sky130_fd_pr__nfet_01v8 L=0.5u W=1u
M1869 o4 ibias vss vss sky130_fd_pr__nfet_01v8 L=0.5u W=1u
M1870 o4 ibias vss vss sky130_fd_pr__nfet_01v8 L=0.5u W=1u
M1871 o4 ibias vss vss sky130_fd_pr__nfet_01v8 L=0.5u W=1u
M1872 o4 ibias vss vss sky130_fd_pr__nfet_01v8 L=0.5u W=1u
M1873 o4 ibias vss vss sky130_fd_pr__nfet_01v8 L=0.5u W=1u
M1874 o4 ibias vss vss sky130_fd_pr__nfet_01v8 L=0.5u W=1u
M1875 o4 ibias vss vss sky130_fd_pr__nfet_01v8 L=0.5u W=1u
M1876 o4 ibias vss vss sky130_fd_pr__nfet_01v8 L=0.5u W=1u
M1877 o4 ibias vss vss sky130_fd_pr__nfet_01v8 L=0.5u W=1u
M1878 o4 ibias vss vss sky130_fd_pr__nfet_01v8 L=0.5u W=1u
M1879 o4 ibias vss vss sky130_fd_pr__nfet_01v8 L=0.5u W=1u
M1880 o4 ibias vss vss sky130_fd_pr__nfet_01v8 L=0.5u W=1u
M1881 o4 ibias vss vss sky130_fd_pr__nfet_01v8 L=0.5u W=1u
M1882 o4 ibias vss vss sky130_fd_pr__nfet_01v8 L=0.5u W=1u
M1883 o4 ibias vss vss sky130_fd_pr__nfet_01v8 L=0.5u W=1u
M1884 o4 ibias vss vss sky130_fd_pr__nfet_01v8 L=0.5u W=1u
M1885 o4 ibias vss vss sky130_fd_pr__nfet_01v8 L=0.5u W=1u
M1886 o4 ibias vss vss sky130_fd_pr__nfet_01v8 L=0.5u W=1u
M1887 o4 ibias vss vss sky130_fd_pr__nfet_01v8 L=0.5u W=1u
M1888 o4 ibias vss vss sky130_fd_pr__nfet_01v8 L=0.5u W=1u
M1889 o4 ibias vss vss sky130_fd_pr__nfet_01v8 L=0.5u W=1u
M1890 o4 ibias vss vss sky130_fd_pr__nfet_01v8 L=0.5u W=1u
M1891 o4 ibias vss vss sky130_fd_pr__nfet_01v8 L=0.5u W=1u
M1892 o4 ibias vss vss sky130_fd_pr__nfet_01v8 L=0.5u W=1u
M1893 o4 ibias vss vss sky130_fd_pr__nfet_01v8 L=0.5u W=1u
M1894 o4 ibias vss vss sky130_fd_pr__nfet_01v8 L=0.5u W=1u
M1895 o4 ibias vss vss sky130_fd_pr__nfet_01v8 L=0.5u W=1u
M1896 o4 ibias vss vss sky130_fd_pr__nfet_01v8 L=0.5u W=1u
M1897 o4 ibias vss vss sky130_fd_pr__nfet_01v8 L=0.5u W=1u
M1898 o4 ibias vss vss sky130_fd_pr__nfet_01v8 L=0.5u W=1u
M1899 o4 ibias vss vss sky130_fd_pr__nfet_01v8 L=0.5u W=1u
M1900 o4 ibias vss vss sky130_fd_pr__nfet_01v8 L=0.5u W=1u
M1901 o4 ibias vss vss sky130_fd_pr__nfet_01v8 L=0.5u W=1u
M1902 o4 ibias vss vss sky130_fd_pr__nfet_01v8 L=0.5u W=1u
M1903 o4 ibias vss vss sky130_fd_pr__nfet_01v8 L=0.5u W=1u
M1904 o4 ibias vss vss sky130_fd_pr__nfet_01v8 L=0.5u W=1u
M1905 o4 ibias vss vss sky130_fd_pr__nfet_01v8 L=0.5u W=1u
M1906 o4 ibias vss vss sky130_fd_pr__nfet_01v8 L=0.5u W=1u
M1907 o4 ibias vss vss sky130_fd_pr__nfet_01v8 L=0.5u W=1u
M1908 o4 ibias vss vss sky130_fd_pr__nfet_01v8 L=0.5u W=1u
M1909 o4 ibias vss vss sky130_fd_pr__nfet_01v8 L=0.5u W=1u
M1910 o4 ibias vss vss sky130_fd_pr__nfet_01v8 L=0.5u W=1u
M1911 o4 ibias vss vss sky130_fd_pr__nfet_01v8 L=0.5u W=1u
M1912 o4 ibias vss vss sky130_fd_pr__nfet_01v8 L=0.5u W=1u
M1913 o4 ibias vss vss sky130_fd_pr__nfet_01v8 L=0.5u W=1u
M1914 o4 ibias vss vss sky130_fd_pr__nfet_01v8 L=0.5u W=1u
M1915 o4 ibias vss vss sky130_fd_pr__nfet_01v8 L=0.5u W=1u
M1916 o4 ibias vss vss sky130_fd_pr__nfet_01v8 L=0.5u W=1u
M1917 o4 ibias vss vss sky130_fd_pr__nfet_01v8 L=0.5u W=1u
M1918 o4 ibias vss vss sky130_fd_pr__nfet_01v8 L=0.5u W=1u
M1919 o4 ibias vss vss sky130_fd_pr__nfet_01v8 L=0.5u W=1u
M1920 o4 ibias vss vss sky130_fd_pr__nfet_01v8 L=0.5u W=1u
M1921 o4 ibias vss vss sky130_fd_pr__nfet_01v8 L=0.5u W=1u
M1922 o4 ibias vss vss sky130_fd_pr__nfet_01v8 L=0.5u W=1u
M1923 o4 ibias vss vss sky130_fd_pr__nfet_01v8 L=0.5u W=1u
M1924 o4 ibias vss vss sky130_fd_pr__nfet_01v8 L=0.5u W=1u
M1925 o4 ibias vss vss sky130_fd_pr__nfet_01v8 L=0.5u W=1u
M1926 o4 ibias vss vss sky130_fd_pr__nfet_01v8 L=0.5u W=1u
M1927 o4 ibias vss vss sky130_fd_pr__nfet_01v8 L=0.5u W=1u
M1928 o4 ibias vss vss sky130_fd_pr__nfet_01v8 L=0.5u W=1u
M1929 o4 ibias vss vss sky130_fd_pr__nfet_01v8 L=0.5u W=1u
M1930 o4 ibias vss vss sky130_fd_pr__nfet_01v8 L=0.5u W=1u
M1931 o4 ibias vss vss sky130_fd_pr__nfet_01v8 L=0.5u W=1u
M1932 o4 ibias vss vss sky130_fd_pr__nfet_01v8 L=0.5u W=1u
M1933 o4 ibias vss vss sky130_fd_pr__nfet_01v8 L=0.5u W=1u
M1934 o4 ibias vss vss sky130_fd_pr__nfet_01v8 L=0.5u W=1u
M1935 o4 ibias vss vss sky130_fd_pr__nfet_01v8 L=0.5u W=1u
M1936 o4 ibias vss vss sky130_fd_pr__nfet_01v8 L=0.5u W=1u
M1937 o4 ibias vss vss sky130_fd_pr__nfet_01v8 L=0.5u W=1u
M1938 o4 ibias vss vss sky130_fd_pr__nfet_01v8 L=0.5u W=1u
M1939 o4 ibias vss vss sky130_fd_pr__nfet_01v8 L=0.5u W=1u
M1940 o4 ibias vss vss sky130_fd_pr__nfet_01v8 L=0.5u W=1u
M1941 o4 ibias vss vss sky130_fd_pr__nfet_01v8 L=0.5u W=1u
M1942 o4 ibias vss vss sky130_fd_pr__nfet_01v8 L=0.5u W=1u
M1943 o4 ibias vss vss sky130_fd_pr__nfet_01v8 L=0.5u W=1u
M1944 o4 ibias vss vss sky130_fd_pr__nfet_01v8 L=0.5u W=1u
M1945 o4 ibias vss vss sky130_fd_pr__nfet_01v8 L=0.5u W=1u
M1946 o4 ibias vss vss sky130_fd_pr__nfet_01v8 L=0.5u W=1u
M1947 o4 ibias vss vss sky130_fd_pr__nfet_01v8 L=0.5u W=1u
M1948 o4 ibias vss vss sky130_fd_pr__nfet_01v8 L=0.5u W=1u
M1949 o4 ibias vss vss sky130_fd_pr__nfet_01v8 L=0.5u W=1u
M1950 o4 ibias vss vss sky130_fd_pr__nfet_01v8 L=0.5u W=1u
M1951 o4 ibias vss vss sky130_fd_pr__nfet_01v8 L=0.5u W=1u
M1952 o4 ibias vss vss sky130_fd_pr__nfet_01v8 L=0.5u W=1u
M1953 o4 ibias vss vss sky130_fd_pr__nfet_01v8 L=0.5u W=1u
M1954 o4 ibias vss vss sky130_fd_pr__nfet_01v8 L=0.5u W=1u
M1955 o4 ibias vss vss sky130_fd_pr__nfet_01v8 L=0.5u W=1u
M1956 o4 ibias vss vss sky130_fd_pr__nfet_01v8 L=0.5u W=1u
M1957 o4 ibias vss vss sky130_fd_pr__nfet_01v8 L=0.5u W=1u
M1958 o4 ibias vss vss sky130_fd_pr__nfet_01v8 L=0.5u W=1u
M1959 o4 ibias vss vss sky130_fd_pr__nfet_01v8 L=0.5u W=1u
M1960 o4 ibias vss vss sky130_fd_pr__nfet_01v8 L=0.5u W=1u
M1961 o4 ibias vss vss sky130_fd_pr__nfet_01v8 L=0.5u W=1u
M1962 o4 ibias vss vss sky130_fd_pr__nfet_01v8 L=0.5u W=1u
M1963 o4 ibias vss vss sky130_fd_pr__nfet_01v8 L=0.5u W=1u
M1964 o4 ibias vss vss sky130_fd_pr__nfet_01v8 L=0.5u W=1u
M1965 o4 ibias vss vss sky130_fd_pr__nfet_01v8 L=0.5u W=1u
M1966 o4 ibias vss vss sky130_fd_pr__nfet_01v8 L=0.5u W=1u
M1967 o4 ibias vss vss sky130_fd_pr__nfet_01v8 L=0.5u W=1u
M1968 o4 ibias vss vss sky130_fd_pr__nfet_01v8 L=0.5u W=1u
M1969 o4 ibias vss vss sky130_fd_pr__nfet_01v8 L=0.5u W=1u
M1970 o4 ibias vss vss sky130_fd_pr__nfet_01v8 L=0.5u W=1u
M1971 o4 ibias vss vss sky130_fd_pr__nfet_01v8 L=0.5u W=1u
M1972 o4 ibias vss vss sky130_fd_pr__nfet_01v8 L=0.5u W=1u
M1973 o4 ibias vss vss sky130_fd_pr__nfet_01v8 L=0.5u W=1u
M1974 o4 ibias vss vss sky130_fd_pr__nfet_01v8 L=0.5u W=1u
M1975 o4 ibias vss vss sky130_fd_pr__nfet_01v8 L=0.5u W=1u
M1976 o4 ibias vss vss sky130_fd_pr__nfet_01v8 L=0.5u W=1u
M1977 o4 ibias vss vss sky130_fd_pr__nfet_01v8 L=0.5u W=1u
M1978 o4 ibias vss vss sky130_fd_pr__nfet_01v8 L=0.5u W=1u
M1979 o4 ibias vss vss sky130_fd_pr__nfet_01v8 L=0.5u W=1u
M1980 o4 ibias vss vss sky130_fd_pr__nfet_01v8 L=0.5u W=1u
M1981 o4 ibias vss vss sky130_fd_pr__nfet_01v8 L=0.5u W=1u
M1982 o4 ibias vss vss sky130_fd_pr__nfet_01v8 L=0.5u W=1u
M1983 o4 ibias vss vss sky130_fd_pr__nfet_01v8 L=0.5u W=1u
M1984 o4 ibias vss vss sky130_fd_pr__nfet_01v8 L=0.5u W=1u
M1985 o4 ibias vss vss sky130_fd_pr__nfet_01v8 L=0.5u W=1u
M1986 o4 ibias vss vss sky130_fd_pr__nfet_01v8 L=0.5u W=1u
M1987 o4 ibias vss vss sky130_fd_pr__nfet_01v8 L=0.5u W=1u
M1988 o4 ibias vss vss sky130_fd_pr__nfet_01v8 L=0.5u W=1u
M1989 o4 ibias vss vss sky130_fd_pr__nfet_01v8 L=0.5u W=1u
M1990 o4 ibias vss vss sky130_fd_pr__nfet_01v8 L=0.5u W=1u
M1991 o4 ibias vss vss sky130_fd_pr__nfet_01v8 L=0.5u W=1u
M1992 o4 ibias vss vss sky130_fd_pr__nfet_01v8 L=0.5u W=1u
M1993 o4 ibias vss vss sky130_fd_pr__nfet_01v8 L=0.5u W=1u
M1994 o4 ibias vss vss sky130_fd_pr__nfet_01v8 L=0.5u W=1u
M1995 o4 ibias vss vss sky130_fd_pr__nfet_01v8 L=0.5u W=1u
M1996 o4 ibias vss vss sky130_fd_pr__nfet_01v8 L=0.5u W=1u
M1997 o4 ibias vss vss sky130_fd_pr__nfet_01v8 L=0.5u W=1u
M1998 o4 ibias vss vss sky130_fd_pr__nfet_01v8 L=0.5u W=1u
M1999 o4 ibias vss vss sky130_fd_pr__nfet_01v8 L=0.5u W=1u
M2000 o4 ibias vss vss sky130_fd_pr__nfet_01v8 L=0.5u W=1u
M2001 o4 ibias vss vss sky130_fd_pr__nfet_01v8 L=0.5u W=1u
M2002 o4 ibias vss vss sky130_fd_pr__nfet_01v8 L=0.5u W=1u
M2003 o4 ibias vss vss sky130_fd_pr__nfet_01v8 L=0.5u W=1u
M2004 o4 ibias vss vss sky130_fd_pr__nfet_01v8 L=0.5u W=1u
M2005 o4 ibias vss vss sky130_fd_pr__nfet_01v8 L=0.5u W=1u
M2006 o4 ibias vss vss sky130_fd_pr__nfet_01v8 L=0.5u W=1u
M2007 o4 ibias vss vss sky130_fd_pr__nfet_01v8 L=0.5u W=1u
M2008 o4 ibias vss vss sky130_fd_pr__nfet_01v8 L=0.5u W=1u
M2009 o4 ibias vss vss sky130_fd_pr__nfet_01v8 L=0.5u W=1u
M2010 o4 ibias vss vss sky130_fd_pr__nfet_01v8 L=0.5u W=1u
M2011 o4 ibias vss vss sky130_fd_pr__nfet_01v8 L=0.5u W=1u
M2012 o4 ibias vss vss sky130_fd_pr__nfet_01v8 L=0.5u W=1u
M2013 o4 ibias vss vss sky130_fd_pr__nfet_01v8 L=0.5u W=1u
M2014 o4 ibias vss vss sky130_fd_pr__nfet_01v8 L=0.5u W=1u
M2015 o4 ibias vss vss sky130_fd_pr__nfet_01v8 L=0.5u W=1u
M2016 o4 ibias vss vss sky130_fd_pr__nfet_01v8 L=0.5u W=1u
M2017 o4 ibias vss vss sky130_fd_pr__nfet_01v8 L=0.5u W=1u
M2018 o4 ibias vss vss sky130_fd_pr__nfet_01v8 L=0.5u W=1u
M2019 o4 ibias vss vss sky130_fd_pr__nfet_01v8 L=0.5u W=1u
M2020 o4 ibias vss vss sky130_fd_pr__nfet_01v8 L=0.5u W=1u
M2021 o4 ibias vss vss sky130_fd_pr__nfet_01v8 L=0.5u W=1u
M2022 o4 ibias vss vss sky130_fd_pr__nfet_01v8 L=0.5u W=1u
M2023 o4 ibias vss vss sky130_fd_pr__nfet_01v8 L=0.5u W=1u
M2024 o4 ibias vss vss sky130_fd_pr__nfet_01v8 L=0.5u W=1u
M2025 o4 ibias vss vss sky130_fd_pr__nfet_01v8 L=0.5u W=1u
M2026 o4 ibias vss vss sky130_fd_pr__nfet_01v8 L=0.5u W=1u
M2027 o4 ibias vss vss sky130_fd_pr__nfet_01v8 L=0.5u W=1u
M2028 o4 ibias vss vss sky130_fd_pr__nfet_01v8 L=0.5u W=1u
M2029 o4 ibias vss vss sky130_fd_pr__nfet_01v8 L=0.5u W=1u
M2030 o4 ibias vss vss sky130_fd_pr__nfet_01v8 L=0.5u W=1u
M2031 o4 ibias vss vss sky130_fd_pr__nfet_01v8 L=0.5u W=1u
M2032 o4 ibias vss vss sky130_fd_pr__nfet_01v8 L=0.5u W=1u
M2033 o4 ibias vss vss sky130_fd_pr__nfet_01v8 L=0.5u W=1u
M2034 o4 ibias vss vss sky130_fd_pr__nfet_01v8 L=0.5u W=1u
M2035 o4 ibias vss vss sky130_fd_pr__nfet_01v8 L=0.5u W=1u
M2036 o4 ibias vss vss sky130_fd_pr__nfet_01v8 L=0.5u W=1u
M2037 o4 ibias vss vss sky130_fd_pr__nfet_01v8 L=0.5u W=1u
M2038 o4 ibias vss vss sky130_fd_pr__nfet_01v8 L=0.5u W=1u
M2039 o4 ibias vss vss sky130_fd_pr__nfet_01v8 L=0.5u W=1u
M2040 o4 ibias vss vss sky130_fd_pr__nfet_01v8 L=0.5u W=1u
M2041 o4 ibias vss vss sky130_fd_pr__nfet_01v8 L=0.5u W=1u
M2042 o4 ibias vss vss sky130_fd_pr__nfet_01v8 L=0.5u W=1u
M2043 o4 ibias vss vss sky130_fd_pr__nfet_01v8 L=0.5u W=1u
M2044 o4 ibias vss vss sky130_fd_pr__nfet_01v8 L=0.5u W=1u
M2045 o4 ibias vss vss sky130_fd_pr__nfet_01v8 L=0.5u W=1u
M2046 o4 ibias vss vss sky130_fd_pr__nfet_01v8 L=0.5u W=1u
M2047 o4 ibias vss vss sky130_fd_pr__nfet_01v8 L=0.5u W=1u
M2048 o4 ibias vss vss sky130_fd_pr__nfet_01v8 L=0.5u W=1u
M2049 o4 ibias vss vss sky130_fd_pr__nfet_01v8 L=0.5u W=1u
M2050 o4 ibias vss vss sky130_fd_pr__nfet_01v8 L=0.5u W=1u
M2051 o4 ibias vss vss sky130_fd_pr__nfet_01v8 L=0.5u W=1u
M2052 o4 ibias vss vss sky130_fd_pr__nfet_01v8 L=0.5u W=1u
M2053 o4 ibias vss vss sky130_fd_pr__nfet_01v8 L=0.5u W=1u
M2054 o4 ibias vss vss sky130_fd_pr__nfet_01v8 L=0.5u W=1u
M2055 o4 ibias vss vss sky130_fd_pr__nfet_01v8 L=0.5u W=1u
M2056 o4 ibias vss vss sky130_fd_pr__nfet_01v8 L=0.5u W=1u
M2057 o4 ibias vss vss sky130_fd_pr__nfet_01v8 L=0.5u W=1u
M2058 o4 ibias vss vss sky130_fd_pr__nfet_01v8 L=0.5u W=1u
M2059 o4 ibias vss vss sky130_fd_pr__nfet_01v8 L=0.5u W=1u
M2060 o4 ibias vss vss sky130_fd_pr__nfet_01v8 L=0.5u W=1u
M2061 o4 ibias vss vss sky130_fd_pr__nfet_01v8 L=0.5u W=1u
M2062 o4 ibias vss vss sky130_fd_pr__nfet_01v8 L=0.5u W=1u
M2063 o4 ibias vss vss sky130_fd_pr__nfet_01v8 L=0.5u W=1u
M2064 o4 ibias vss vss sky130_fd_pr__nfet_01v8 L=0.5u W=1u
M2065 o4 ibias vss vss sky130_fd_pr__nfet_01v8 L=0.5u W=1u
M2066 o4 ibias vss vss sky130_fd_pr__nfet_01v8 L=0.5u W=1u
M2067 o4 ibias vss vss sky130_fd_pr__nfet_01v8 L=0.5u W=1u
M2068 o4 ibias vss vss sky130_fd_pr__nfet_01v8 L=0.5u W=1u
M2069 o4 ibias vss vss sky130_fd_pr__nfet_01v8 L=0.5u W=1u
M2070 o4 ibias vss vss sky130_fd_pr__nfet_01v8 L=0.5u W=1u
M2071 o4 ibias vss vss sky130_fd_pr__nfet_01v8 L=0.5u W=1u
M2072 o4 ibias vss vss sky130_fd_pr__nfet_01v8 L=0.5u W=1u
M2073 o4 ibias vss vss sky130_fd_pr__nfet_01v8 L=0.5u W=1u
M2074 o4 ibias vss vss sky130_fd_pr__nfet_01v8 L=0.5u W=1u
M2075 o4 ibias vss vss sky130_fd_pr__nfet_01v8 L=0.5u W=1u
M2076 o4 ibias vss vss sky130_fd_pr__nfet_01v8 L=0.5u W=1u
M2077 o4 ibias vss vss sky130_fd_pr__nfet_01v8 L=0.5u W=1u
M2078 o4 ibias vss vss sky130_fd_pr__nfet_01v8 L=0.5u W=1u
M2079 o4 ibias vss vss sky130_fd_pr__nfet_01v8 L=0.5u W=1u
M2080 o4 ibias vss vss sky130_fd_pr__nfet_01v8 L=0.5u W=1u
M2081 o4 ibias vss vss sky130_fd_pr__nfet_01v8 L=0.5u W=1u
M2082 o4 ibias vss vss sky130_fd_pr__nfet_01v8 L=0.5u W=1u
M2083 o4 ibias vss vss sky130_fd_pr__nfet_01v8 L=0.5u W=1u
M2084 o4 ibias vss vss sky130_fd_pr__nfet_01v8 L=0.5u W=1u
M2085 o4 ibias vss vss sky130_fd_pr__nfet_01v8 L=0.5u W=1u
M2086 o4 ibias vss vss sky130_fd_pr__nfet_01v8 L=0.5u W=1u
M2087 o4 ibias vss vss sky130_fd_pr__nfet_01v8 L=0.5u W=1u
M2088 o4 ibias vss vss sky130_fd_pr__nfet_01v8 L=0.5u W=1u
M2089 o4 ibias vss vss sky130_fd_pr__nfet_01v8 L=0.5u W=1u
M2090 o4 ibias vss vss sky130_fd_pr__nfet_01v8 L=0.5u W=1u
M2091 o4 ibias vss vss sky130_fd_pr__nfet_01v8 L=0.5u W=1u
M2092 o4 ibias vss vss sky130_fd_pr__nfet_01v8 L=0.5u W=1u
M2093 o4 ibias vss vss sky130_fd_pr__nfet_01v8 L=0.5u W=1u
M2094 o4 ibias vss vss sky130_fd_pr__nfet_01v8 L=0.5u W=1u
M2095 o4 ibias vss vss sky130_fd_pr__nfet_01v8 L=0.5u W=1u
M2096 o4 ibias vss vss sky130_fd_pr__nfet_01v8 L=0.5u W=1u
M2097 o4 ibias vss vss sky130_fd_pr__nfet_01v8 L=0.5u W=1u
M2098 o4 ibias vss vss sky130_fd_pr__nfet_01v8 L=0.5u W=1u
M2099 o4 ibias vss vss sky130_fd_pr__nfet_01v8 L=0.5u W=1u
M2100 o4 ibias vss vss sky130_fd_pr__nfet_01v8 L=0.5u W=1u
M2101 o4 ibias vss vss sky130_fd_pr__nfet_01v8 L=0.5u W=1u
M2102 o4 ibias vss vss sky130_fd_pr__nfet_01v8 L=0.5u W=1u
M2103 o4 ibias vss vss sky130_fd_pr__nfet_01v8 L=0.5u W=1u
M2104 o4 ibias vss vss sky130_fd_pr__nfet_01v8 L=0.5u W=1u
M2105 o4 ibias vss vss sky130_fd_pr__nfet_01v8 L=0.5u W=1u
M2106 o4 ibias vss vss sky130_fd_pr__nfet_01v8 L=0.5u W=1u
M2107 o4 ibias vss vss sky130_fd_pr__nfet_01v8 L=0.5u W=1u
M2108 o4 ibias vss vss sky130_fd_pr__nfet_01v8 L=0.5u W=1u
M2109 o4 ibias vss vss sky130_fd_pr__nfet_01v8 L=0.5u W=1u
M2110 o4 ibias vss vss sky130_fd_pr__nfet_01v8 L=0.5u W=1u
M2111 o4 ibias vss vss sky130_fd_pr__nfet_01v8 L=0.5u W=1u
M2112 o4 ibias vss vss sky130_fd_pr__nfet_01v8 L=0.5u W=1u
M2113 o4 ibias vss vss sky130_fd_pr__nfet_01v8 L=0.5u W=1u
M2114 o4 ibias vss vss sky130_fd_pr__nfet_01v8 L=0.5u W=1u
M2115 o4 ibias vss vss sky130_fd_pr__nfet_01v8 L=0.5u W=1u
M2116 o4 ibias vss vss sky130_fd_pr__nfet_01v8 L=0.5u W=1u
M2117 o4 ibias vss vss sky130_fd_pr__nfet_01v8 L=0.5u W=1u
M2118 o4 ibias vss vss sky130_fd_pr__nfet_01v8 L=0.5u W=1u
M2119 o4 ibias vss vss sky130_fd_pr__nfet_01v8 L=0.5u W=1u
M2120 o4 ibias vss vss sky130_fd_pr__nfet_01v8 L=0.5u W=1u
M2121 o4 ibias vss vss sky130_fd_pr__nfet_01v8 L=0.5u W=1u
M2122 o4 ibias vss vss sky130_fd_pr__nfet_01v8 L=0.5u W=1u
M2123 o4 ibias vss vss sky130_fd_pr__nfet_01v8 L=0.5u W=1u
M2124 o4 ibias vss vss sky130_fd_pr__nfet_01v8 L=0.5u W=1u
M2125 o4 ibias vss vss sky130_fd_pr__nfet_01v8 L=0.5u W=1u
M2126 o4 ibias vss vss sky130_fd_pr__nfet_01v8 L=0.5u W=1u
M2127 o4 ibias vss vss sky130_fd_pr__nfet_01v8 L=0.5u W=1u
M2128 o4 ibias vss vss sky130_fd_pr__nfet_01v8 L=0.5u W=1u
M2129 o4 ibias vss vss sky130_fd_pr__nfet_01v8 L=0.5u W=1u
M2130 o4 ibias vss vss sky130_fd_pr__nfet_01v8 L=0.5u W=1u
M2131 o4 ibias vss vss sky130_fd_pr__nfet_01v8 L=0.5u W=1u
M2132 o4 ibias vss vss sky130_fd_pr__nfet_01v8 L=0.5u W=1u
M2133 o4 ibias vss vss sky130_fd_pr__nfet_01v8 L=0.5u W=1u
M2134 o4 ibias vss vss sky130_fd_pr__nfet_01v8 L=0.5u W=1u
M2135 o4 ibias vss vss sky130_fd_pr__nfet_01v8 L=0.5u W=1u
M2136 o4 ibias vss vss sky130_fd_pr__nfet_01v8 L=0.5u W=1u
M2137 o4 ibias vss vss sky130_fd_pr__nfet_01v8 L=0.5u W=1u
M2138 o4 ibias vss vss sky130_fd_pr__nfet_01v8 L=0.5u W=1u
M2139 o4 ibias vss vss sky130_fd_pr__nfet_01v8 L=0.5u W=1u
M2140 o4 ibias vss vss sky130_fd_pr__nfet_01v8 L=0.5u W=1u
M2141 o4 ibias vss vss sky130_fd_pr__nfet_01v8 L=0.5u W=1u
M2142 o4 ibias vss vss sky130_fd_pr__nfet_01v8 L=0.5u W=1u
M2143 o4 ibias vss vss sky130_fd_pr__nfet_01v8 L=0.5u W=1u
M2144 o4 ibias vss vss sky130_fd_pr__nfet_01v8 L=0.5u W=1u
M2145 o4 ibias vss vss sky130_fd_pr__nfet_01v8 L=0.5u W=1u
M2146 o4 ibias vss vss sky130_fd_pr__nfet_01v8 L=0.5u W=1u
M2147 o4 ibias vss vss sky130_fd_pr__nfet_01v8 L=0.5u W=1u
M2148 o4 ibias vss vss sky130_fd_pr__nfet_01v8 L=0.5u W=1u
M2149 o4 ibias vss vss sky130_fd_pr__nfet_01v8 L=0.5u W=1u
M2150 o4 ibias vss vss sky130_fd_pr__nfet_01v8 L=0.5u W=1u
M2151 o4 ibias vss vss sky130_fd_pr__nfet_01v8 L=0.5u W=1u
M2152 o4 ibias vss vss sky130_fd_pr__nfet_01v8 L=0.5u W=1u
M2153 o4 ibias vss vss sky130_fd_pr__nfet_01v8 L=0.5u W=1u
M2154 o4 ibias vss vss sky130_fd_pr__nfet_01v8 L=0.5u W=1u
M2155 o4 ibias vss vss sky130_fd_pr__nfet_01v8 L=0.5u W=1u
M2156 o4 ibias vss vss sky130_fd_pr__nfet_01v8 L=0.5u W=1u
M2157 o4 ibias vss vss sky130_fd_pr__nfet_01v8 L=0.5u W=1u
M2158 o4 ibias vss vss sky130_fd_pr__nfet_01v8 L=0.5u W=1u
M2159 o4 ibias vss vss sky130_fd_pr__nfet_01v8 L=0.5u W=1u
M2160 o4 ibias vss vss sky130_fd_pr__nfet_01v8 L=0.5u W=1u
M2161 o4 ibias vss vss sky130_fd_pr__nfet_01v8 L=0.5u W=1u
M2162 o4 ibias vss vss sky130_fd_pr__nfet_01v8 L=0.5u W=1u
M2163 o4 ibias vss vss sky130_fd_pr__nfet_01v8 L=0.5u W=1u
M2164 o4 ibias vss vss sky130_fd_pr__nfet_01v8 L=0.5u W=1u
M2165 o4 ibias vss vss sky130_fd_pr__nfet_01v8 L=0.5u W=1u
M2166 o4 ibias vss vss sky130_fd_pr__nfet_01v8 L=0.5u W=1u
M2167 o4 ibias vss vss sky130_fd_pr__nfet_01v8 L=0.5u W=1u
M2168 o4 ibias vss vss sky130_fd_pr__nfet_01v8 L=0.5u W=1u
M2169 o4 ibias vss vss sky130_fd_pr__nfet_01v8 L=0.5u W=1u
M2170 o4 ibias vss vss sky130_fd_pr__nfet_01v8 L=0.5u W=1u
M2171 o4 ibias vss vss sky130_fd_pr__nfet_01v8 L=0.5u W=1u
M2172 o4 ibias vss vss sky130_fd_pr__nfet_01v8 L=0.5u W=1u
M2173 o4 ibias vss vss sky130_fd_pr__nfet_01v8 L=0.5u W=1u
M2174 o4 ibias vss vss sky130_fd_pr__nfet_01v8 L=0.5u W=1u
M2175 o4 ibias vss vss sky130_fd_pr__nfet_01v8 L=0.5u W=1u
M2176 o4 ibias vss vss sky130_fd_pr__nfet_01v8 L=0.5u W=1u
M2177 o4 ibias vss vss sky130_fd_pr__nfet_01v8 L=0.5u W=1u
M2178 o4 ibias vss vss sky130_fd_pr__nfet_01v8 L=0.5u W=1u
M2179 o4 ibias vss vss sky130_fd_pr__nfet_01v8 L=0.5u W=1u
M2180 o4 ibias vss vss sky130_fd_pr__nfet_01v8 L=0.5u W=1u
M2181 o4 ibias vss vss sky130_fd_pr__nfet_01v8 L=0.5u W=1u
M2182 o4 ibias vss vss sky130_fd_pr__nfet_01v8 L=0.5u W=1u
M2183 o4 ibias vss vss sky130_fd_pr__nfet_01v8 L=0.5u W=1u
M2184 o4 ibias vss vss sky130_fd_pr__nfet_01v8 L=0.5u W=1u
M2185 o4 ibias vss vss sky130_fd_pr__nfet_01v8 L=0.5u W=1u
M2186 o4 ibias vss vss sky130_fd_pr__nfet_01v8 L=0.5u W=1u
M2187 o4 ibias vss vss sky130_fd_pr__nfet_01v8 L=0.5u W=1u
M2188 o4 ibias vss vss sky130_fd_pr__nfet_01v8 L=0.5u W=1u
M2189 o4 ibias vss vss sky130_fd_pr__nfet_01v8 L=0.5u W=1u
M2190 o4 ibias vss vss sky130_fd_pr__nfet_01v8 L=0.5u W=1u
M2191 o4 ibias vss vss sky130_fd_pr__nfet_01v8 L=0.5u W=1u
M2192 o4 ibias vss vss sky130_fd_pr__nfet_01v8 L=0.5u W=1u
M2193 o4 ibias vss vss sky130_fd_pr__nfet_01v8 L=0.5u W=1u
M2194 o4 ibias vss vss sky130_fd_pr__nfet_01v8 L=0.5u W=1u
M2195 o4 ibias vss vss sky130_fd_pr__nfet_01v8 L=0.5u W=1u
M2196 o4 ibias vss vss sky130_fd_pr__nfet_01v8 L=0.5u W=1u
M2197 o4 ibias vss vss sky130_fd_pr__nfet_01v8 L=0.5u W=1u
M2198 o4 ibias vss vss sky130_fd_pr__nfet_01v8 L=0.5u W=1u
M2199 o4 ibias vss vss sky130_fd_pr__nfet_01v8 L=0.5u W=1u
M2200 o4 ibias vss vss sky130_fd_pr__nfet_01v8 L=0.5u W=1u
M2201 o4 ibias vss vss sky130_fd_pr__nfet_01v8 L=0.5u W=1u
M2202 o4 ibias vss vss sky130_fd_pr__nfet_01v8 L=0.5u W=1u
M2203 o4 ibias vss vss sky130_fd_pr__nfet_01v8 L=0.5u W=1u
M2204 o4 ibias vss vss sky130_fd_pr__nfet_01v8 L=0.5u W=1u
M2205 o4 ibias vss vss sky130_fd_pr__nfet_01v8 L=0.5u W=1u
M2206 o4 ibias vss vss sky130_fd_pr__nfet_01v8 L=0.5u W=1u
M2207 o4 ibias vss vss sky130_fd_pr__nfet_01v8 L=0.5u W=1u
M2208 o4 ibias vss vss sky130_fd_pr__nfet_01v8 L=0.5u W=1u
M2209 o4 ibias vss vss sky130_fd_pr__nfet_01v8 L=0.5u W=1u
M2210 o4 ibias vss vss sky130_fd_pr__nfet_01v8 L=0.5u W=1u
M2211 o4 ibias vss vss sky130_fd_pr__nfet_01v8 L=0.5u W=1u
M2212 o4 ibias vss vss sky130_fd_pr__nfet_01v8 L=0.5u W=1u
M2213 o4 ibias vss vss sky130_fd_pr__nfet_01v8 L=0.5u W=1u
M2214 o4 ibias vss vss sky130_fd_pr__nfet_01v8 L=0.5u W=1u
M2215 o4 ibias vss vss sky130_fd_pr__nfet_01v8 L=0.5u W=1u
M2216 o4 ibias vss vss sky130_fd_pr__nfet_01v8 L=0.5u W=1u
M2217 o4 ibias vss vss sky130_fd_pr__nfet_01v8 L=0.5u W=1u
M2218 o4 ibias vss vss sky130_fd_pr__nfet_01v8 L=0.5u W=1u
M2219 o4 ibias vss vss sky130_fd_pr__nfet_01v8 L=0.5u W=1u
M2220 o4 ibias vss vss sky130_fd_pr__nfet_01v8 L=0.5u W=1u
M2221 o4 ibias vss vss sky130_fd_pr__nfet_01v8 L=0.5u W=1u
M2222 o4 ibias vss vss sky130_fd_pr__nfet_01v8 L=0.5u W=1u
M2223 o4 ibias vss vss sky130_fd_pr__nfet_01v8 L=0.5u W=1u
M2224 o4 ibias vss vss sky130_fd_pr__nfet_01v8 L=0.5u W=1u
M2225 o4 ibias vss vss sky130_fd_pr__nfet_01v8 L=0.5u W=1u
M2226 o4 ibias vss vss sky130_fd_pr__nfet_01v8 L=0.5u W=1u
M2227 o4 ibias vss vss sky130_fd_pr__nfet_01v8 L=0.5u W=1u
M2228 o4 ibias vss vss sky130_fd_pr__nfet_01v8 L=0.5u W=1u
M2229 o4 ibias vss vss sky130_fd_pr__nfet_01v8 L=0.5u W=1u
M2230 o4 ibias vss vss sky130_fd_pr__nfet_01v8 L=0.5u W=1u
M2231 o4 ibias vss vss sky130_fd_pr__nfet_01v8 L=0.5u W=1u
M2232 o4 ibias vss vss sky130_fd_pr__nfet_01v8 L=0.5u W=1u
M2233 o4 ibias vss vss sky130_fd_pr__nfet_01v8 L=0.5u W=1u
M2234 o4 ibias vss vss sky130_fd_pr__nfet_01v8 L=0.5u W=1u
M2235 o4 ibias vss vss sky130_fd_pr__nfet_01v8 L=0.5u W=1u
M2236 o4 ibias vss vss sky130_fd_pr__nfet_01v8 L=0.5u W=1u
M2237 o4 ibias vss vss sky130_fd_pr__nfet_01v8 L=0.5u W=1u
M2238 o4 ibias vss vss sky130_fd_pr__nfet_01v8 L=0.5u W=1u
M2239 o4 ibias vss vss sky130_fd_pr__nfet_01v8 L=0.5u W=1u
M2240 o4 ibias vss vss sky130_fd_pr__nfet_01v8 L=0.5u W=1u
M2241 o4 ibias vss vss sky130_fd_pr__nfet_01v8 L=0.5u W=1u
M2242 o4 ibias vss vss sky130_fd_pr__nfet_01v8 L=0.5u W=1u
M2243 o4 ibias vss vss sky130_fd_pr__nfet_01v8 L=0.5u W=1u
M2244 o4 ibias vss vss sky130_fd_pr__nfet_01v8 L=0.5u W=1u
M2245 o4 ibias vss vss sky130_fd_pr__nfet_01v8 L=0.5u W=1u
M2246 o4 ibias vss vss sky130_fd_pr__nfet_01v8 L=0.5u W=1u
M2247 o4 ibias vss vss sky130_fd_pr__nfet_01v8 L=0.5u W=1u
M2248 o4 ibias vss vss sky130_fd_pr__nfet_01v8 L=0.5u W=1u
M2249 o4 ibias vss vss sky130_fd_pr__nfet_01v8 L=0.5u W=1u
M2250 o4 ibias vss vss sky130_fd_pr__nfet_01v8 L=0.5u W=1u
M2251 o4 ibias vss vss sky130_fd_pr__nfet_01v8 L=0.5u W=1u
M2252 o4 ibias vss vss sky130_fd_pr__nfet_01v8 L=0.5u W=1u
M2253 o4 ibias vss vss sky130_fd_pr__nfet_01v8 L=0.5u W=1u
M2254 o4 ibias vss vss sky130_fd_pr__nfet_01v8 L=0.5u W=1u
M2255 o4 ibias vss vss sky130_fd_pr__nfet_01v8 L=0.5u W=1u
M2256 o4 ibias vss vss sky130_fd_pr__nfet_01v8 L=0.5u W=1u
M2257 o4 ibias vss vss sky130_fd_pr__nfet_01v8 L=0.5u W=1u
M2258 o4 ibias vss vss sky130_fd_pr__nfet_01v8 L=0.5u W=1u
M2259 o4 ibias vss vss sky130_fd_pr__nfet_01v8 L=0.5u W=1u
M2260 o4 ibias vss vss sky130_fd_pr__nfet_01v8 L=0.5u W=1u
M2261 o4 ibias vss vss sky130_fd_pr__nfet_01v8 L=0.5u W=1u
M2262 o4 ibias vss vss sky130_fd_pr__nfet_01v8 L=0.5u W=1u
M2263 o4 ibias vss vss sky130_fd_pr__nfet_01v8 L=0.5u W=1u
M2264 o4 ibias vss vss sky130_fd_pr__nfet_01v8 L=0.5u W=1u
M2265 o4 ibias vss vss sky130_fd_pr__nfet_01v8 L=0.5u W=1u
M2266 o4 ibias vss vss sky130_fd_pr__nfet_01v8 L=0.5u W=1u
M2267 o4 ibias vss vss sky130_fd_pr__nfet_01v8 L=0.5u W=1u
M2268 o4 ibias vss vss sky130_fd_pr__nfet_01v8 L=0.5u W=1u
M2269 o4 ibias vss vss sky130_fd_pr__nfet_01v8 L=0.5u W=1u
M2270 o4 ibias vss vss sky130_fd_pr__nfet_01v8 L=0.5u W=1u
M2271 o4 ibias vss vss sky130_fd_pr__nfet_01v8 L=0.5u W=1u
M2272 o4 ibias vss vss sky130_fd_pr__nfet_01v8 L=0.5u W=1u
M2273 o4 ibias vss vss sky130_fd_pr__nfet_01v8 L=0.5u W=1u
M2274 o4 ibias vss vss sky130_fd_pr__nfet_01v8 L=0.5u W=1u
M2275 o4 ibias vss vss sky130_fd_pr__nfet_01v8 L=0.5u W=1u
M2276 o4 ibias vss vss sky130_fd_pr__nfet_01v8 L=0.5u W=1u
M2277 o4 ibias vss vss sky130_fd_pr__nfet_01v8 L=0.5u W=1u
M2278 o4 ibias vss vss sky130_fd_pr__nfet_01v8 L=0.5u W=1u
M2279 o4 ibias vss vss sky130_fd_pr__nfet_01v8 L=0.5u W=1u
M2280 o4 ibias vss vss sky130_fd_pr__nfet_01v8 L=0.5u W=1u
M2281 o4 ibias vss vss sky130_fd_pr__nfet_01v8 L=0.5u W=1u
M2282 o4 ibias vss vss sky130_fd_pr__nfet_01v8 L=0.5u W=1u
M2283 o4 ibias vss vss sky130_fd_pr__nfet_01v8 L=0.5u W=1u
M2284 o4 ibias vss vss sky130_fd_pr__nfet_01v8 L=0.5u W=1u
M2285 o4 ibias vss vss sky130_fd_pr__nfet_01v8 L=0.5u W=1u
M2286 o4 ibias vss vss sky130_fd_pr__nfet_01v8 L=0.5u W=1u
M2287 o4 ibias vss vss sky130_fd_pr__nfet_01v8 L=0.5u W=1u
M2288 o4 ibias vss vss sky130_fd_pr__nfet_01v8 L=0.5u W=1u
M2289 o4 ibias vss vss sky130_fd_pr__nfet_01v8 L=0.5u W=1u
M2290 o4 ibias vss vss sky130_fd_pr__nfet_01v8 L=0.5u W=1u
M2291 o4 ibias vss vss sky130_fd_pr__nfet_01v8 L=0.5u W=1u
M2292 o4 ibias vss vss sky130_fd_pr__nfet_01v8 L=0.5u W=1u
M2293 o4 ibias vss vss sky130_fd_pr__nfet_01v8 L=0.5u W=1u
M2294 o4 ibias vss vss sky130_fd_pr__nfet_01v8 L=0.5u W=1u
M2295 o4 ibias vss vss sky130_fd_pr__nfet_01v8 L=0.5u W=1u
M2296 o4 ibias vss vss sky130_fd_pr__nfet_01v8 L=0.5u W=1u
M2297 o4 ibias vss vss sky130_fd_pr__nfet_01v8 L=0.5u W=1u
M2298 o4 ibias vss vss sky130_fd_pr__nfet_01v8 L=0.5u W=1u
M2299 o4 ibias vss vss sky130_fd_pr__nfet_01v8 L=0.5u W=1u
M2300 o4 ibias vss vss sky130_fd_pr__nfet_01v8 L=0.5u W=1u
M2301 o4 ibias vss vss sky130_fd_pr__nfet_01v8 L=0.5u W=1u
M2302 o4 ibias vss vss sky130_fd_pr__nfet_01v8 L=0.5u W=1u
M2303 o4 ibias vss vss sky130_fd_pr__nfet_01v8 L=0.5u W=1u
M2304 o4 ibias vss vss sky130_fd_pr__nfet_01v8 L=0.5u W=1u
M2305 o4 ibias vss vss sky130_fd_pr__nfet_01v8 L=0.5u W=1u
M2306 o4 ibias vss vss sky130_fd_pr__nfet_01v8 L=0.5u W=1u
M2307 o4 ibias vss vss sky130_fd_pr__nfet_01v8 L=0.5u W=1u
M2308 o4 ibias vss vss sky130_fd_pr__nfet_01v8 L=0.5u W=1u
M2309 o4 ibias vss vss sky130_fd_pr__nfet_01v8 L=0.5u W=1u
M2310 o4 ibias vss vss sky130_fd_pr__nfet_01v8 L=0.5u W=1u
M2311 o4 ibias vss vss sky130_fd_pr__nfet_01v8 L=0.5u W=1u
M2312 o4 ibias vss vss sky130_fd_pr__nfet_01v8 L=0.5u W=1u
M2313 o4 ibias vss vss sky130_fd_pr__nfet_01v8 L=0.5u W=1u
M2314 o4 ibias vss vss sky130_fd_pr__nfet_01v8 L=0.5u W=1u
M2315 o4 ibias vss vss sky130_fd_pr__nfet_01v8 L=0.5u W=1u
M2316 o4 ibias vss vss sky130_fd_pr__nfet_01v8 L=0.5u W=1u
M2317 o4 ibias vss vss sky130_fd_pr__nfet_01v8 L=0.5u W=1u
M2318 o4 ibias vss vss sky130_fd_pr__nfet_01v8 L=0.5u W=1u
M2319 o4 ibias vss vss sky130_fd_pr__nfet_01v8 L=0.5u W=1u
M2320 o4 ibias vss vss sky130_fd_pr__nfet_01v8 L=0.5u W=1u
M2321 o4 ibias vss vss sky130_fd_pr__nfet_01v8 L=0.5u W=1u
M2322 o4 ibias vss vss sky130_fd_pr__nfet_01v8 L=0.5u W=1u
M2323 o4 ibias vss vss sky130_fd_pr__nfet_01v8 L=0.5u W=1u
M2324 o4 ibias vss vss sky130_fd_pr__nfet_01v8 L=0.5u W=1u
M2325 o4 ibias vss vss sky130_fd_pr__nfet_01v8 L=0.5u W=1u
M2326 o4 ibias vss vss sky130_fd_pr__nfet_01v8 L=0.5u W=1u
M2327 o4 ibias vss vss sky130_fd_pr__nfet_01v8 L=0.5u W=1u
M2328 o4 ibias vss vss sky130_fd_pr__nfet_01v8 L=0.5u W=1u
M2329 o4 ibias vss vss sky130_fd_pr__nfet_01v8 L=0.5u W=1u
M2330 o4 ibias vss vss sky130_fd_pr__nfet_01v8 L=0.5u W=1u
M2331 o4 ibias vss vss sky130_fd_pr__nfet_01v8 L=0.5u W=1u
M2332 o4 ibias vss vss sky130_fd_pr__nfet_01v8 L=0.5u W=1u
M2333 o4 ibias vss vss sky130_fd_pr__nfet_01v8 L=0.5u W=1u
M2334 o4 ibias vss vss sky130_fd_pr__nfet_01v8 L=0.5u W=1u
M2335 o4 ibias vss vss sky130_fd_pr__nfet_01v8 L=0.5u W=1u
M2336 o4 ibias vss vss sky130_fd_pr__nfet_01v8 L=0.5u W=1u
M2337 o4 ibias vss vss sky130_fd_pr__nfet_01v8 L=0.5u W=1u
M2338 o4 ibias vss vss sky130_fd_pr__nfet_01v8 L=0.5u W=1u
M2339 o4 ibias vss vss sky130_fd_pr__nfet_01v8 L=0.5u W=1u
M2340 o4 ibias vss vss sky130_fd_pr__nfet_01v8 L=0.5u W=1u
M2341 o4 ibias vss vss sky130_fd_pr__nfet_01v8 L=0.5u W=1u
M2342 o4 ibias vss vss sky130_fd_pr__nfet_01v8 L=0.5u W=1u
M2343 o4 ibias vss vss sky130_fd_pr__nfet_01v8 L=0.5u W=1u
M2344 o4 ibias vss vss sky130_fd_pr__nfet_01v8 L=0.5u W=1u
M2345 o4 ibias vss vss sky130_fd_pr__nfet_01v8 L=0.5u W=1u
M2346 o4 ibias vss vss sky130_fd_pr__nfet_01v8 L=0.5u W=1u
M2347 o4 ibias vss vss sky130_fd_pr__nfet_01v8 L=0.5u W=1u
M2348 o4 ibias vss vss sky130_fd_pr__nfet_01v8 L=0.5u W=1u
M2349 o4 ibias vss vss sky130_fd_pr__nfet_01v8 L=0.5u W=1u
M2350 o4 ibias vss vss sky130_fd_pr__nfet_01v8 L=0.5u W=1u
M2351 o4 ibias vss vss sky130_fd_pr__nfet_01v8 L=0.5u W=1u
M2352 o4 ibias vss vss sky130_fd_pr__nfet_01v8 L=0.5u W=1u
M2353 o4 ibias vss vss sky130_fd_pr__nfet_01v8 L=0.5u W=1u
M2354 o4 ibias vss vss sky130_fd_pr__nfet_01v8 L=0.5u W=1u
M2355 o4 ibias vss vss sky130_fd_pr__nfet_01v8 L=0.5u W=1u
M2356 o4 ibias vss vss sky130_fd_pr__nfet_01v8 L=0.5u W=1u
M2357 o4 ibias vss vss sky130_fd_pr__nfet_01v8 L=0.5u W=1u
M2358 o4 ibias vss vss sky130_fd_pr__nfet_01v8 L=0.5u W=1u
M2359 o4 ibias vss vss sky130_fd_pr__nfet_01v8 L=0.5u W=1u
M2360 o4 ibias vss vss sky130_fd_pr__nfet_01v8 L=0.5u W=1u
M2361 o4 ibias vss vss sky130_fd_pr__nfet_01v8 L=0.5u W=1u
M2362 o4 ibias vss vss sky130_fd_pr__nfet_01v8 L=0.5u W=1u
M2363 o4 ibias vss vss sky130_fd_pr__nfet_01v8 L=0.5u W=1u
M2364 o4 ibias vss vss sky130_fd_pr__nfet_01v8 L=0.5u W=1u
M2365 o4 ibias vss vss sky130_fd_pr__nfet_01v8 L=0.5u W=1u
M2366 o4 ibias vss vss sky130_fd_pr__nfet_01v8 L=0.5u W=1u
M2367 o4 ibias vss vss sky130_fd_pr__nfet_01v8 L=0.5u W=1u
M2368 o4 ibias vss vss sky130_fd_pr__nfet_01v8 L=0.5u W=1u
M2369 o4 ibias vss vss sky130_fd_pr__nfet_01v8 L=0.5u W=1u
M2370 o4 ibias vss vss sky130_fd_pr__nfet_01v8 L=0.5u W=1u
M2371 o4 ibias vss vss sky130_fd_pr__nfet_01v8 L=0.5u W=1u
M2372 o4 ibias vss vss sky130_fd_pr__nfet_01v8 L=0.5u W=1u
M2373 o4 ibias vss vss sky130_fd_pr__nfet_01v8 L=0.5u W=1u
M2374 o4 ibias vss vss sky130_fd_pr__nfet_01v8 L=0.5u W=1u
M2375 o4 ibias vss vss sky130_fd_pr__nfet_01v8 L=0.5u W=1u
M2376 o4 ibias vss vss sky130_fd_pr__nfet_01v8 L=0.5u W=1u
M2377 o4 ibias vss vss sky130_fd_pr__nfet_01v8 L=0.5u W=1u
M2378 o4 ibias vss vss sky130_fd_pr__nfet_01v8 L=0.5u W=1u
M2379 o4 ibias vss vss sky130_fd_pr__nfet_01v8 L=0.5u W=1u
M2380 o4 ibias vss vss sky130_fd_pr__nfet_01v8 L=0.5u W=1u
M2381 o4 ibias vss vss sky130_fd_pr__nfet_01v8 L=0.5u W=1u
M2382 o4 ibias vss vss sky130_fd_pr__nfet_01v8 L=0.5u W=1u
M2383 o4 ibias vss vss sky130_fd_pr__nfet_01v8 L=0.5u W=1u
M2384 o4 ibias vss vss sky130_fd_pr__nfet_01v8 L=0.5u W=1u
M2385 o4 ibias vss vss sky130_fd_pr__nfet_01v8 L=0.5u W=1u
M2386 o4 ibias vss vss sky130_fd_pr__nfet_01v8 L=0.5u W=1u
M2387 o4 ibias vss vss sky130_fd_pr__nfet_01v8 L=0.5u W=1u
M2388 o4 ibias vss vss sky130_fd_pr__nfet_01v8 L=0.5u W=1u
M2389 o4 ibias vss vss sky130_fd_pr__nfet_01v8 L=0.5u W=1u
M2390 o4 ibias vss vss sky130_fd_pr__nfet_01v8 L=0.5u W=1u
M2391 o4 ibias vss vss sky130_fd_pr__nfet_01v8 L=0.5u W=1u
M2392 o4 ibias vss vss sky130_fd_pr__nfet_01v8 L=0.5u W=1u
M2393 o4 ibias vss vss sky130_fd_pr__nfet_01v8 L=0.5u W=1u
M2394 o4 ibias vss vss sky130_fd_pr__nfet_01v8 L=0.5u W=1u
M2395 o4 ibias vss vss sky130_fd_pr__nfet_01v8 L=0.5u W=1u
M2396 o4 ibias vss vss sky130_fd_pr__nfet_01v8 L=0.5u W=1u
M2397 o4 ibias vss vss sky130_fd_pr__nfet_01v8 L=0.5u W=1u
M2398 o4 ibias vss vss sky130_fd_pr__nfet_01v8 L=0.5u W=1u
M2399 o4 ibias vss vss sky130_fd_pr__nfet_01v8 L=0.5u W=1u
M2400 o4 ibias vss vss sky130_fd_pr__nfet_01v8 L=0.5u W=1u
M2401 o4 ibias vss vss sky130_fd_pr__nfet_01v8 L=0.5u W=1u
M2402 o4 ibias vss vss sky130_fd_pr__nfet_01v8 L=0.5u W=1u
M2403 o4 ibias vss vss sky130_fd_pr__nfet_01v8 L=0.5u W=1u
M2404 o4 ibias vss vss sky130_fd_pr__nfet_01v8 L=0.5u W=1u
M2405 o4 ibias vss vss sky130_fd_pr__nfet_01v8 L=0.5u W=1u
M2406 o4 ibias vss vss sky130_fd_pr__nfet_01v8 L=0.5u W=1u
M2407 o4 ibias vss vss sky130_fd_pr__nfet_01v8 L=0.5u W=1u
M2408 o4 ibias vss vss sky130_fd_pr__nfet_01v8 L=0.5u W=1u
M2409 o4 ibias vss vss sky130_fd_pr__nfet_01v8 L=0.5u W=1u
M2410 o4 ibias vss vss sky130_fd_pr__nfet_01v8 L=0.5u W=1u
M2411 o4 ibias vss vss sky130_fd_pr__nfet_01v8 L=0.5u W=1u
M2412 o4 ibias vss vss sky130_fd_pr__nfet_01v8 L=0.5u W=1u
M2413 o4 ibias vss vss sky130_fd_pr__nfet_01v8 L=0.5u W=1u
M2414 o4 ibias vss vss sky130_fd_pr__nfet_01v8 L=0.5u W=1u
M2415 o4 ibias vss vss sky130_fd_pr__nfet_01v8 L=0.5u W=1u
M2416 o4 ibias vss vss sky130_fd_pr__nfet_01v8 L=0.5u W=1u
M2417 o4 ibias vss vss sky130_fd_pr__nfet_01v8 L=0.5u W=1u
M2418 o4 ibias vss vss sky130_fd_pr__nfet_01v8 L=0.5u W=1u
M2419 o4 ibias vss vss sky130_fd_pr__nfet_01v8 L=0.5u W=1u
M2420 o4 ibias vss vss sky130_fd_pr__nfet_01v8 L=0.5u W=1u
M2421 o4 ibias vss vss sky130_fd_pr__nfet_01v8 L=0.5u W=1u
M2422 o4 ibias vss vss sky130_fd_pr__nfet_01v8 L=0.5u W=1u
M2423 o4 ibias vss vss sky130_fd_pr__nfet_01v8 L=0.5u W=1u
M2424 o4 ibias vss vss sky130_fd_pr__nfet_01v8 L=0.5u W=1u
M2425 o4 ibias vss vss sky130_fd_pr__nfet_01v8 L=0.5u W=1u
M2426 o4 ibias vss vss sky130_fd_pr__nfet_01v8 L=0.5u W=1u
M2427 o4 ibias vss vss sky130_fd_pr__nfet_01v8 L=0.5u W=1u
M2428 o4 ibias vss vss sky130_fd_pr__nfet_01v8 L=0.5u W=1u
M2429 o4 ibias vss vss sky130_fd_pr__nfet_01v8 L=0.5u W=1u
M2430 o4 ibias vss vss sky130_fd_pr__nfet_01v8 L=0.5u W=1u
M2431 o4 ibias vss vss sky130_fd_pr__nfet_01v8 L=0.5u W=1u
M2432 o4 ibias vss vss sky130_fd_pr__nfet_01v8 L=0.5u W=1u
M2433 o4 ibias vss vss sky130_fd_pr__nfet_01v8 L=0.5u W=1u
M2434 o4 ibias vss vss sky130_fd_pr__nfet_01v8 L=0.5u W=1u
M2435 o4 ibias vss vss sky130_fd_pr__nfet_01v8 L=0.5u W=1u
M2436 o4 ibias vss vss sky130_fd_pr__nfet_01v8 L=0.5u W=1u
M2437 o4 ibias vss vss sky130_fd_pr__nfet_01v8 L=0.5u W=1u
M2438 o4 ibias vss vss sky130_fd_pr__nfet_01v8 L=0.5u W=1u
M2439 o4 ibias vss vss sky130_fd_pr__nfet_01v8 L=0.5u W=1u
M2440 o4 ibias vss vss sky130_fd_pr__nfet_01v8 L=0.5u W=1u
M2441 o4 ibias vss vss sky130_fd_pr__nfet_01v8 L=0.5u W=1u
M2442 o4 ibias vss vss sky130_fd_pr__nfet_01v8 L=0.5u W=1u
M2443 o4 ibias vss vss sky130_fd_pr__nfet_01v8 L=0.5u W=1u
M2444 o4 ibias vss vss sky130_fd_pr__nfet_01v8 L=0.5u W=1u
M2445 o4 ibias vss vss sky130_fd_pr__nfet_01v8 L=0.5u W=1u
M2446 o4 ibias vss vss sky130_fd_pr__nfet_01v8 L=0.5u W=1u
M2447 o4 ibias vss vss sky130_fd_pr__nfet_01v8 L=0.5u W=1u
M2448 o4 ibias vss vss sky130_fd_pr__nfet_01v8 L=0.5u W=1u
M2449 o4 ibias vss vss sky130_fd_pr__nfet_01v8 L=0.5u W=1u
M2450 o4 ibias vss vss sky130_fd_pr__nfet_01v8 L=0.5u W=1u
M2451 o4 ibias vss vss sky130_fd_pr__nfet_01v8 L=0.5u W=1u
M2452 o4 ibias vss vss sky130_fd_pr__nfet_01v8 L=0.5u W=1u
M2453 o4 ibias vss vss sky130_fd_pr__nfet_01v8 L=0.5u W=1u
M2454 o4 ibias vss vss sky130_fd_pr__nfet_01v8 L=0.5u W=1u
M2455 o4 ibias vss vss sky130_fd_pr__nfet_01v8 L=0.5u W=1u
M2456 o4 ibias vss vss sky130_fd_pr__nfet_01v8 L=0.5u W=1u
M2457 o4 ibias vss vss sky130_fd_pr__nfet_01v8 L=0.5u W=1u
M2458 o4 ibias vss vss sky130_fd_pr__nfet_01v8 L=0.5u W=1u
M2459 o4 ibias vss vss sky130_fd_pr__nfet_01v8 L=0.5u W=1u
M2460 o4 ibias vss vss sky130_fd_pr__nfet_01v8 L=0.5u W=1u
M2461 o4 ibias vss vss sky130_fd_pr__nfet_01v8 L=0.5u W=1u
M2462 o4 ibias vss vss sky130_fd_pr__nfet_01v8 L=0.5u W=1u
M2463 o4 ibias vss vss sky130_fd_pr__nfet_01v8 L=0.5u W=1u
M2464 o4 ibias vss vss sky130_fd_pr__nfet_01v8 L=0.5u W=1u
M2465 o4 ibias vss vss sky130_fd_pr__nfet_01v8 L=0.5u W=1u
M2466 o4 ibias vss vss sky130_fd_pr__nfet_01v8 L=0.5u W=1u
M2467 o4 ibias vss vss sky130_fd_pr__nfet_01v8 L=0.5u W=1u
M2468 o4 ibias vss vss sky130_fd_pr__nfet_01v8 L=0.5u W=1u
M2469 o4 ibias vss vss sky130_fd_pr__nfet_01v8 L=0.5u W=1u
M2470 o4 ibias vss vss sky130_fd_pr__nfet_01v8 L=0.5u W=1u
M2471 o4 ibias vss vss sky130_fd_pr__nfet_01v8 L=0.5u W=1u
M2472 o4 ibias vss vss sky130_fd_pr__nfet_01v8 L=0.5u W=1u
M2473 o4 ibias vss vss sky130_fd_pr__nfet_01v8 L=0.5u W=1u
M2474 o4 ibias vss vss sky130_fd_pr__nfet_01v8 L=0.5u W=1u
M2475 o4 ibias vss vss sky130_fd_pr__nfet_01v8 L=0.5u W=1u
M2476 o4 ibias vss vss sky130_fd_pr__nfet_01v8 L=0.5u W=1u
M2477 o4 ibias vss vss sky130_fd_pr__nfet_01v8 L=0.5u W=1u
M2478 o4 ibias vss vss sky130_fd_pr__nfet_01v8 L=0.5u W=1u
M2479 o4 ibias vss vss sky130_fd_pr__nfet_01v8 L=0.5u W=1u
M2480 o4 ibias vss vss sky130_fd_pr__nfet_01v8 L=0.5u W=1u
M2481 o4 ibias vss vss sky130_fd_pr__nfet_01v8 L=0.5u W=1u
M2482 o4 ibias vss vss sky130_fd_pr__nfet_01v8 L=0.5u W=1u
M2483 o4 ibias vss vss sky130_fd_pr__nfet_01v8 L=0.5u W=1u
M2484 o4 ibias vss vss sky130_fd_pr__nfet_01v8 L=0.5u W=1u
M2485 o4 ibias vss vss sky130_fd_pr__nfet_01v8 L=0.5u W=1u
M2486 o4 ibias vss vss sky130_fd_pr__nfet_01v8 L=0.5u W=1u
M2487 o4 ibias vss vss sky130_fd_pr__nfet_01v8 L=0.5u W=1u
M2488 o4 ibias vss vss sky130_fd_pr__nfet_01v8 L=0.5u W=1u
M2489 o4 ibias vss vss sky130_fd_pr__nfet_01v8 L=0.5u W=1u
M2490 o4 ibias vss vss sky130_fd_pr__nfet_01v8 L=0.5u W=1u
M2491 o4 ibias vss vss sky130_fd_pr__nfet_01v8 L=0.5u W=1u
M2492 o4 ibias vss vss sky130_fd_pr__nfet_01v8 L=0.5u W=1u
M2493 o4 ibias vss vss sky130_fd_pr__nfet_01v8 L=0.5u W=1u
M2494 o4 ibias vss vss sky130_fd_pr__nfet_01v8 L=0.5u W=1u
M2495 o4 ibias vss vss sky130_fd_pr__nfet_01v8 L=0.5u W=1u
M2496 o4 ibias vss vss sky130_fd_pr__nfet_01v8 L=0.5u W=1u
M2497 o4 ibias vss vss sky130_fd_pr__nfet_01v8 L=0.5u W=1u
M2498 o4 ibias vss vss sky130_fd_pr__nfet_01v8 L=0.5u W=1u
M2499 o4 ibias vss vss sky130_fd_pr__nfet_01v8 L=0.5u W=1u
M2500 o4 ibias vss vss sky130_fd_pr__nfet_01v8 L=0.5u W=1u
M2501 o4 ibias vss vss sky130_fd_pr__nfet_01v8 L=0.5u W=1u
M2502 o4 ibias vss vss sky130_fd_pr__nfet_01v8 L=0.5u W=1u
M2503 o4 ibias vss vss sky130_fd_pr__nfet_01v8 L=0.5u W=1u
M2504 o4 ibias vss vss sky130_fd_pr__nfet_01v8 L=0.5u W=1u
M2505 o4 ibias vss vss sky130_fd_pr__nfet_01v8 L=0.5u W=1u
M2506 o4 ibias vss vss sky130_fd_pr__nfet_01v8 L=0.5u W=1u
M2507 o4 ibias vss vss sky130_fd_pr__nfet_01v8 L=0.5u W=1u
M2508 o4 ibias vss vss sky130_fd_pr__nfet_01v8 L=0.5u W=1u
M2509 o4 ibias vss vss sky130_fd_pr__nfet_01v8 L=0.5u W=1u
M2510 o4 ibias vss vss sky130_fd_pr__nfet_01v8 L=0.5u W=1u
M2511 o4 ibias vss vss sky130_fd_pr__nfet_01v8 L=0.5u W=1u
M2512 o5 ibias vss vss sky130_fd_pr__nfet_01v8 L=0.5u W=1u
M2513 o5 ibias vss vss sky130_fd_pr__nfet_01v8 L=0.5u W=1u
M2514 o5 ibias vss vss sky130_fd_pr__nfet_01v8 L=0.5u W=1u
M2515 o5 ibias vss vss sky130_fd_pr__nfet_01v8 L=0.5u W=1u
M2516 o5 ibias vss vss sky130_fd_pr__nfet_01v8 L=0.5u W=1u
M2517 o5 ibias vss vss sky130_fd_pr__nfet_01v8 L=0.5u W=1u
M2518 o5 ibias vss vss sky130_fd_pr__nfet_01v8 L=0.5u W=1u
M2519 o5 ibias vss vss sky130_fd_pr__nfet_01v8 L=0.5u W=1u
M2520 o5 ibias vss vss sky130_fd_pr__nfet_01v8 L=0.5u W=1u
M2521 o5 ibias vss vss sky130_fd_pr__nfet_01v8 L=0.5u W=1u
M2522 o5 ibias vss vss sky130_fd_pr__nfet_01v8 L=0.5u W=1u
M2523 o5 ibias vss vss sky130_fd_pr__nfet_01v8 L=0.5u W=1u
M2524 o5 ibias vss vss sky130_fd_pr__nfet_01v8 L=0.5u W=1u
M2525 o5 ibias vss vss sky130_fd_pr__nfet_01v8 L=0.5u W=1u
M2526 o5 ibias vss vss sky130_fd_pr__nfet_01v8 L=0.5u W=1u
M2527 o5 ibias vss vss sky130_fd_pr__nfet_01v8 L=0.5u W=1u
M2528 o5 ibias vss vss sky130_fd_pr__nfet_01v8 L=0.5u W=1u
M2529 o5 ibias vss vss sky130_fd_pr__nfet_01v8 L=0.5u W=1u
M2530 o5 ibias vss vss sky130_fd_pr__nfet_01v8 L=0.5u W=1u
M2531 o5 ibias vss vss sky130_fd_pr__nfet_01v8 L=0.5u W=1u
M2532 o5 ibias vss vss sky130_fd_pr__nfet_01v8 L=0.5u W=1u
M2533 o5 ibias vss vss sky130_fd_pr__nfet_01v8 L=0.5u W=1u
M2534 o5 ibias vss vss sky130_fd_pr__nfet_01v8 L=0.5u W=1u
M2535 o5 ibias vss vss sky130_fd_pr__nfet_01v8 L=0.5u W=1u
M2536 o5 ibias vss vss sky130_fd_pr__nfet_01v8 L=0.5u W=1u
M2537 o5 ibias vss vss sky130_fd_pr__nfet_01v8 L=0.5u W=1u
M2538 o5 ibias vss vss sky130_fd_pr__nfet_01v8 L=0.5u W=1u
M2539 o5 ibias vss vss sky130_fd_pr__nfet_01v8 L=0.5u W=1u
M2540 o5 ibias vss vss sky130_fd_pr__nfet_01v8 L=0.5u W=1u
M2541 o5 ibias vss vss sky130_fd_pr__nfet_01v8 L=0.5u W=1u
M2542 o5 ibias vss vss sky130_fd_pr__nfet_01v8 L=0.5u W=1u
M2543 o5 ibias vss vss sky130_fd_pr__nfet_01v8 L=0.5u W=1u
M2544 o5 ibias vss vss sky130_fd_pr__nfet_01v8 L=0.5u W=1u
M2545 o5 ibias vss vss sky130_fd_pr__nfet_01v8 L=0.5u W=1u
M2546 o5 ibias vss vss sky130_fd_pr__nfet_01v8 L=0.5u W=1u
M2547 o5 ibias vss vss sky130_fd_pr__nfet_01v8 L=0.5u W=1u
M2548 o5 ibias vss vss sky130_fd_pr__nfet_01v8 L=0.5u W=1u
M2549 o5 ibias vss vss sky130_fd_pr__nfet_01v8 L=0.5u W=1u
M2550 o5 ibias vss vss sky130_fd_pr__nfet_01v8 L=0.5u W=1u
M2551 o5 ibias vss vss sky130_fd_pr__nfet_01v8 L=0.5u W=1u
M2552 o5 ibias vss vss sky130_fd_pr__nfet_01v8 L=0.5u W=1u
M2553 o5 ibias vss vss sky130_fd_pr__nfet_01v8 L=0.5u W=1u
M2554 o5 ibias vss vss sky130_fd_pr__nfet_01v8 L=0.5u W=1u
M2555 o5 ibias vss vss sky130_fd_pr__nfet_01v8 L=0.5u W=1u
M2556 o5 ibias vss vss sky130_fd_pr__nfet_01v8 L=0.5u W=1u
M2557 o5 ibias vss vss sky130_fd_pr__nfet_01v8 L=0.5u W=1u
M2558 o5 ibias vss vss sky130_fd_pr__nfet_01v8 L=0.5u W=1u
M2559 o5 ibias vss vss sky130_fd_pr__nfet_01v8 L=0.5u W=1u
M2560 o5 ibias vss vss sky130_fd_pr__nfet_01v8 L=0.5u W=1u
M2561 o5 ibias vss vss sky130_fd_pr__nfet_01v8 L=0.5u W=1u
M2562 o5 ibias vss vss sky130_fd_pr__nfet_01v8 L=0.5u W=1u
M2563 o5 ibias vss vss sky130_fd_pr__nfet_01v8 L=0.5u W=1u
M2564 o5 ibias vss vss sky130_fd_pr__nfet_01v8 L=0.5u W=1u
M2565 o5 ibias vss vss sky130_fd_pr__nfet_01v8 L=0.5u W=1u
M2566 o5 ibias vss vss sky130_fd_pr__nfet_01v8 L=0.5u W=1u
M2567 o5 ibias vss vss sky130_fd_pr__nfet_01v8 L=0.5u W=1u
M2568 o5 ibias vss vss sky130_fd_pr__nfet_01v8 L=0.5u W=1u
M2569 o5 ibias vss vss sky130_fd_pr__nfet_01v8 L=0.5u W=1u
M2570 o5 ibias vss vss sky130_fd_pr__nfet_01v8 L=0.5u W=1u
M2571 o5 ibias vss vss sky130_fd_pr__nfet_01v8 L=0.5u W=1u
M2572 o5 ibias vss vss sky130_fd_pr__nfet_01v8 L=0.5u W=1u
M2573 o5 ibias vss vss sky130_fd_pr__nfet_01v8 L=0.5u W=1u
M2574 o5 ibias vss vss sky130_fd_pr__nfet_01v8 L=0.5u W=1u
M2575 o5 ibias vss vss sky130_fd_pr__nfet_01v8 L=0.5u W=1u
M2576 o5 ibias vss vss sky130_fd_pr__nfet_01v8 L=0.5u W=1u
M2577 o5 ibias vss vss sky130_fd_pr__nfet_01v8 L=0.5u W=1u
M2578 o5 ibias vss vss sky130_fd_pr__nfet_01v8 L=0.5u W=1u
M2579 o5 ibias vss vss sky130_fd_pr__nfet_01v8 L=0.5u W=1u
M2580 o5 ibias vss vss sky130_fd_pr__nfet_01v8 L=0.5u W=1u
M2581 o5 ibias vss vss sky130_fd_pr__nfet_01v8 L=0.5u W=1u
M2582 o5 ibias vss vss sky130_fd_pr__nfet_01v8 L=0.5u W=1u
M2583 o5 ibias vss vss sky130_fd_pr__nfet_01v8 L=0.5u W=1u
M2584 o5 ibias vss vss sky130_fd_pr__nfet_01v8 L=0.5u W=1u
M2585 o5 ibias vss vss sky130_fd_pr__nfet_01v8 L=0.5u W=1u
M2586 o5 ibias vss vss sky130_fd_pr__nfet_01v8 L=0.5u W=1u
M2587 o5 ibias vss vss sky130_fd_pr__nfet_01v8 L=0.5u W=1u
M2588 o5 ibias vss vss sky130_fd_pr__nfet_01v8 L=0.5u W=1u
M2589 o5 ibias vss vss sky130_fd_pr__nfet_01v8 L=0.5u W=1u
M2590 o5 ibias vss vss sky130_fd_pr__nfet_01v8 L=0.5u W=1u
M2591 o5 ibias vss vss sky130_fd_pr__nfet_01v8 L=0.5u W=1u
M2592 o5 ibias vss vss sky130_fd_pr__nfet_01v8 L=0.5u W=1u
M2593 o5 ibias vss vss sky130_fd_pr__nfet_01v8 L=0.5u W=1u
M2594 o5 ibias vss vss sky130_fd_pr__nfet_01v8 L=0.5u W=1u
M2595 o5 ibias vss vss sky130_fd_pr__nfet_01v8 L=0.5u W=1u
M2596 o5 ibias vss vss sky130_fd_pr__nfet_01v8 L=0.5u W=1u
M2597 o5 ibias vss vss sky130_fd_pr__nfet_01v8 L=0.5u W=1u
M2598 o5 ibias vss vss sky130_fd_pr__nfet_01v8 L=0.5u W=1u
M2599 o5 ibias vss vss sky130_fd_pr__nfet_01v8 L=0.5u W=1u
M2600 o5 ibias vss vss sky130_fd_pr__nfet_01v8 L=0.5u W=1u
M2601 o5 ibias vss vss sky130_fd_pr__nfet_01v8 L=0.5u W=1u
M2602 o5 ibias vss vss sky130_fd_pr__nfet_01v8 L=0.5u W=1u
M2603 o5 ibias vss vss sky130_fd_pr__nfet_01v8 L=0.5u W=1u
M2604 o5 ibias vss vss sky130_fd_pr__nfet_01v8 L=0.5u W=1u
M2605 o5 ibias vss vss sky130_fd_pr__nfet_01v8 L=0.5u W=1u
M2606 o5 ibias vss vss sky130_fd_pr__nfet_01v8 L=0.5u W=1u
M2607 o5 ibias vss vss sky130_fd_pr__nfet_01v8 L=0.5u W=1u
M2608 o5 ibias vss vss sky130_fd_pr__nfet_01v8 L=0.5u W=1u
M2609 o5 ibias vss vss sky130_fd_pr__nfet_01v8 L=0.5u W=1u
M2610 o5 ibias vss vss sky130_fd_pr__nfet_01v8 L=0.5u W=1u
M2611 o5 ibias vss vss sky130_fd_pr__nfet_01v8 L=0.5u W=1u
M2612 o5 ibias vss vss sky130_fd_pr__nfet_01v8 L=0.5u W=1u
M2613 o5 ibias vss vss sky130_fd_pr__nfet_01v8 L=0.5u W=1u
M2614 o5 ibias vss vss sky130_fd_pr__nfet_01v8 L=0.5u W=1u
M2615 o5 ibias vss vss sky130_fd_pr__nfet_01v8 L=0.5u W=1u
M2616 o5 ibias vss vss sky130_fd_pr__nfet_01v8 L=0.5u W=1u
M2617 o5 ibias vss vss sky130_fd_pr__nfet_01v8 L=0.5u W=1u
M2618 o5 ibias vss vss sky130_fd_pr__nfet_01v8 L=0.5u W=1u
M2619 o5 ibias vss vss sky130_fd_pr__nfet_01v8 L=0.5u W=1u
M2620 o5 ibias vss vss sky130_fd_pr__nfet_01v8 L=0.5u W=1u
M2621 o5 ibias vss vss sky130_fd_pr__nfet_01v8 L=0.5u W=1u
M2622 o5 ibias vss vss sky130_fd_pr__nfet_01v8 L=0.5u W=1u
M2623 o5 ibias vss vss sky130_fd_pr__nfet_01v8 L=0.5u W=1u
M2624 o5 ibias vss vss sky130_fd_pr__nfet_01v8 L=0.5u W=1u
M2625 o5 ibias vss vss sky130_fd_pr__nfet_01v8 L=0.5u W=1u
M2626 o5 ibias vss vss sky130_fd_pr__nfet_01v8 L=0.5u W=1u
M2627 o5 ibias vss vss sky130_fd_pr__nfet_01v8 L=0.5u W=1u
M2628 o5 ibias vss vss sky130_fd_pr__nfet_01v8 L=0.5u W=1u
M2629 o5 ibias vss vss sky130_fd_pr__nfet_01v8 L=0.5u W=1u
M2630 o5 ibias vss vss sky130_fd_pr__nfet_01v8 L=0.5u W=1u
M2631 o5 ibias vss vss sky130_fd_pr__nfet_01v8 L=0.5u W=1u
M2632 o5 ibias vss vss sky130_fd_pr__nfet_01v8 L=0.5u W=1u
M2633 o5 ibias vss vss sky130_fd_pr__nfet_01v8 L=0.5u W=1u
M2634 o5 ibias vss vss sky130_fd_pr__nfet_01v8 L=0.5u W=1u
M2635 o5 ibias vss vss sky130_fd_pr__nfet_01v8 L=0.5u W=1u
M2636 o5 ibias vss vss sky130_fd_pr__nfet_01v8 L=0.5u W=1u
M2637 o5 ibias vss vss sky130_fd_pr__nfet_01v8 L=0.5u W=1u
M2638 o5 ibias vss vss sky130_fd_pr__nfet_01v8 L=0.5u W=1u
M2639 o5 ibias vss vss sky130_fd_pr__nfet_01v8 L=0.5u W=1u
M2640 o5 ibias vss vss sky130_fd_pr__nfet_01v8 L=0.5u W=1u
M2641 o5 ibias vss vss sky130_fd_pr__nfet_01v8 L=0.5u W=1u
M2642 o5 ibias vss vss sky130_fd_pr__nfet_01v8 L=0.5u W=1u
M2643 o5 ibias vss vss sky130_fd_pr__nfet_01v8 L=0.5u W=1u
M2644 o5 ibias vss vss sky130_fd_pr__nfet_01v8 L=0.5u W=1u
M2645 o5 ibias vss vss sky130_fd_pr__nfet_01v8 L=0.5u W=1u
M2646 o5 ibias vss vss sky130_fd_pr__nfet_01v8 L=0.5u W=1u
M2647 o5 ibias vss vss sky130_fd_pr__nfet_01v8 L=0.5u W=1u
M2648 o5 ibias vss vss sky130_fd_pr__nfet_01v8 L=0.5u W=1u
M2649 o5 ibias vss vss sky130_fd_pr__nfet_01v8 L=0.5u W=1u
M2650 o5 ibias vss vss sky130_fd_pr__nfet_01v8 L=0.5u W=1u
M2651 o5 ibias vss vss sky130_fd_pr__nfet_01v8 L=0.5u W=1u
M2652 o5 ibias vss vss sky130_fd_pr__nfet_01v8 L=0.5u W=1u
M2653 o5 ibias vss vss sky130_fd_pr__nfet_01v8 L=0.5u W=1u
M2654 o5 ibias vss vss sky130_fd_pr__nfet_01v8 L=0.5u W=1u
M2655 o5 ibias vss vss sky130_fd_pr__nfet_01v8 L=0.5u W=1u
M2656 o5 ibias vss vss sky130_fd_pr__nfet_01v8 L=0.5u W=1u
M2657 o5 ibias vss vss sky130_fd_pr__nfet_01v8 L=0.5u W=1u
M2658 o5 ibias vss vss sky130_fd_pr__nfet_01v8 L=0.5u W=1u
M2659 o5 ibias vss vss sky130_fd_pr__nfet_01v8 L=0.5u W=1u
M2660 o5 ibias vss vss sky130_fd_pr__nfet_01v8 L=0.5u W=1u
M2661 o5 ibias vss vss sky130_fd_pr__nfet_01v8 L=0.5u W=1u
M2662 o5 ibias vss vss sky130_fd_pr__nfet_01v8 L=0.5u W=1u
M2663 o5 ibias vss vss sky130_fd_pr__nfet_01v8 L=0.5u W=1u
M2664 o5 ibias vss vss sky130_fd_pr__nfet_01v8 L=0.5u W=1u
M2665 o5 ibias vss vss sky130_fd_pr__nfet_01v8 L=0.5u W=1u
M2666 o5 ibias vss vss sky130_fd_pr__nfet_01v8 L=0.5u W=1u
M2667 o5 ibias vss vss sky130_fd_pr__nfet_01v8 L=0.5u W=1u
M2668 o5 ibias vss vss sky130_fd_pr__nfet_01v8 L=0.5u W=1u
M2669 o5 ibias vss vss sky130_fd_pr__nfet_01v8 L=0.5u W=1u
M2670 o5 ibias vss vss sky130_fd_pr__nfet_01v8 L=0.5u W=1u
M2671 o5 ibias vss vss sky130_fd_pr__nfet_01v8 L=0.5u W=1u
M2672 o5 ibias vss vss sky130_fd_pr__nfet_01v8 L=0.5u W=1u
M2673 o5 ibias vss vss sky130_fd_pr__nfet_01v8 L=0.5u W=1u
M2674 o5 ibias vss vss sky130_fd_pr__nfet_01v8 L=0.5u W=1u
M2675 o5 ibias vss vss sky130_fd_pr__nfet_01v8 L=0.5u W=1u
M2676 o5 ibias vss vss sky130_fd_pr__nfet_01v8 L=0.5u W=1u
M2677 o5 ibias vss vss sky130_fd_pr__nfet_01v8 L=0.5u W=1u
M2678 o5 ibias vss vss sky130_fd_pr__nfet_01v8 L=0.5u W=1u
M2679 o5 ibias vss vss sky130_fd_pr__nfet_01v8 L=0.5u W=1u
M2680 o5 ibias vss vss sky130_fd_pr__nfet_01v8 L=0.5u W=1u
M2681 o5 ibias vss vss sky130_fd_pr__nfet_01v8 L=0.5u W=1u
M2682 o5 ibias vss vss sky130_fd_pr__nfet_01v8 L=0.5u W=1u
M2683 o5 ibias vss vss sky130_fd_pr__nfet_01v8 L=0.5u W=1u
M2684 o5 ibias vss vss sky130_fd_pr__nfet_01v8 L=0.5u W=1u
M2685 o5 ibias vss vss sky130_fd_pr__nfet_01v8 L=0.5u W=1u
M2686 o5 ibias vss vss sky130_fd_pr__nfet_01v8 L=0.5u W=1u
M2687 o5 ibias vss vss sky130_fd_pr__nfet_01v8 L=0.5u W=1u
M2688 o5 ibias vss vss sky130_fd_pr__nfet_01v8 L=0.5u W=1u
M2689 o5 ibias vss vss sky130_fd_pr__nfet_01v8 L=0.5u W=1u
M2690 o5 ibias vss vss sky130_fd_pr__nfet_01v8 L=0.5u W=1u
M2691 o5 ibias vss vss sky130_fd_pr__nfet_01v8 L=0.5u W=1u
M2692 o5 ibias vss vss sky130_fd_pr__nfet_01v8 L=0.5u W=1u
M2693 o5 ibias vss vss sky130_fd_pr__nfet_01v8 L=0.5u W=1u
M2694 o5 ibias vss vss sky130_fd_pr__nfet_01v8 L=0.5u W=1u
M2695 o5 ibias vss vss sky130_fd_pr__nfet_01v8 L=0.5u W=1u
M2696 o5 ibias vss vss sky130_fd_pr__nfet_01v8 L=0.5u W=1u
M2697 o5 ibias vss vss sky130_fd_pr__nfet_01v8 L=0.5u W=1u
M2698 o5 ibias vss vss sky130_fd_pr__nfet_01v8 L=0.5u W=1u
M2699 o5 ibias vss vss sky130_fd_pr__nfet_01v8 L=0.5u W=1u
M2700 o5 ibias vss vss sky130_fd_pr__nfet_01v8 L=0.5u W=1u
M2701 o5 ibias vss vss sky130_fd_pr__nfet_01v8 L=0.5u W=1u
M2702 o5 ibias vss vss sky130_fd_pr__nfet_01v8 L=0.5u W=1u
M2703 o5 ibias vss vss sky130_fd_pr__nfet_01v8 L=0.5u W=1u
M2704 o5 ibias vss vss sky130_fd_pr__nfet_01v8 L=0.5u W=1u
M2705 o5 ibias vss vss sky130_fd_pr__nfet_01v8 L=0.5u W=1u
M2706 o5 ibias vss vss sky130_fd_pr__nfet_01v8 L=0.5u W=1u
M2707 o5 ibias vss vss sky130_fd_pr__nfet_01v8 L=0.5u W=1u
M2708 o5 ibias vss vss sky130_fd_pr__nfet_01v8 L=0.5u W=1u
M2709 o5 ibias vss vss sky130_fd_pr__nfet_01v8 L=0.5u W=1u
M2710 o5 ibias vss vss sky130_fd_pr__nfet_01v8 L=0.5u W=1u
M2711 o5 ibias vss vss sky130_fd_pr__nfet_01v8 L=0.5u W=1u
M2712 o5 ibias vss vss sky130_fd_pr__nfet_01v8 L=0.5u W=1u
M2713 o5 ibias vss vss sky130_fd_pr__nfet_01v8 L=0.5u W=1u
M2714 o5 ibias vss vss sky130_fd_pr__nfet_01v8 L=0.5u W=1u
M2715 o5 ibias vss vss sky130_fd_pr__nfet_01v8 L=0.5u W=1u
M2716 o5 ibias vss vss sky130_fd_pr__nfet_01v8 L=0.5u W=1u
M2717 o5 ibias vss vss sky130_fd_pr__nfet_01v8 L=0.5u W=1u
M2718 o5 ibias vss vss sky130_fd_pr__nfet_01v8 L=0.5u W=1u
M2719 o5 ibias vss vss sky130_fd_pr__nfet_01v8 L=0.5u W=1u
M2720 o5 ibias vss vss sky130_fd_pr__nfet_01v8 L=0.5u W=1u
M2721 o5 ibias vss vss sky130_fd_pr__nfet_01v8 L=0.5u W=1u
M2722 o5 ibias vss vss sky130_fd_pr__nfet_01v8 L=0.5u W=1u
M2723 o5 ibias vss vss sky130_fd_pr__nfet_01v8 L=0.5u W=1u
M2724 o5 ibias vss vss sky130_fd_pr__nfet_01v8 L=0.5u W=1u
M2725 o5 ibias vss vss sky130_fd_pr__nfet_01v8 L=0.5u W=1u
M2726 o5 ibias vss vss sky130_fd_pr__nfet_01v8 L=0.5u W=1u
M2727 o5 ibias vss vss sky130_fd_pr__nfet_01v8 L=0.5u W=1u
M2728 o5 ibias vss vss sky130_fd_pr__nfet_01v8 L=0.5u W=1u
M2729 o5 ibias vss vss sky130_fd_pr__nfet_01v8 L=0.5u W=1u
M2730 o5 ibias vss vss sky130_fd_pr__nfet_01v8 L=0.5u W=1u
M2731 o5 ibias vss vss sky130_fd_pr__nfet_01v8 L=0.5u W=1u
M2732 o5 ibias vss vss sky130_fd_pr__nfet_01v8 L=0.5u W=1u
M2733 o5 ibias vss vss sky130_fd_pr__nfet_01v8 L=0.5u W=1u
M2734 o5 ibias vss vss sky130_fd_pr__nfet_01v8 L=0.5u W=1u
M2735 o5 ibias vss vss sky130_fd_pr__nfet_01v8 L=0.5u W=1u
M2736 o5 ibias vss vss sky130_fd_pr__nfet_01v8 L=0.5u W=1u
M2737 o5 ibias vss vss sky130_fd_pr__nfet_01v8 L=0.5u W=1u
M2738 o5 ibias vss vss sky130_fd_pr__nfet_01v8 L=0.5u W=1u
M2739 o5 ibias vss vss sky130_fd_pr__nfet_01v8 L=0.5u W=1u
M2740 o5 ibias vss vss sky130_fd_pr__nfet_01v8 L=0.5u W=1u
M2741 o5 ibias vss vss sky130_fd_pr__nfet_01v8 L=0.5u W=1u
M2742 o5 ibias vss vss sky130_fd_pr__nfet_01v8 L=0.5u W=1u
M2743 o5 ibias vss vss sky130_fd_pr__nfet_01v8 L=0.5u W=1u
M2744 o5 ibias vss vss sky130_fd_pr__nfet_01v8 L=0.5u W=1u
M2745 o5 ibias vss vss sky130_fd_pr__nfet_01v8 L=0.5u W=1u
M2746 o5 ibias vss vss sky130_fd_pr__nfet_01v8 L=0.5u W=1u
M2747 o5 ibias vss vss sky130_fd_pr__nfet_01v8 L=0.5u W=1u
M2748 o5 ibias vss vss sky130_fd_pr__nfet_01v8 L=0.5u W=1u
M2749 o5 ibias vss vss sky130_fd_pr__nfet_01v8 L=0.5u W=1u
M2750 o5 ibias vss vss sky130_fd_pr__nfet_01v8 L=0.5u W=1u
M2751 o5 ibias vss vss sky130_fd_pr__nfet_01v8 L=0.5u W=1u
M2752 o5 ibias vss vss sky130_fd_pr__nfet_01v8 L=0.5u W=1u
M2753 o5 ibias vss vss sky130_fd_pr__nfet_01v8 L=0.5u W=1u
M2754 o5 ibias vss vss sky130_fd_pr__nfet_01v8 L=0.5u W=1u
M2755 o5 ibias vss vss sky130_fd_pr__nfet_01v8 L=0.5u W=1u
M2756 o5 ibias vss vss sky130_fd_pr__nfet_01v8 L=0.5u W=1u
M2757 o5 ibias vss vss sky130_fd_pr__nfet_01v8 L=0.5u W=1u
M2758 o5 ibias vss vss sky130_fd_pr__nfet_01v8 L=0.5u W=1u
M2759 o5 ibias vss vss sky130_fd_pr__nfet_01v8 L=0.5u W=1u
M2760 o5 ibias vss vss sky130_fd_pr__nfet_01v8 L=0.5u W=1u
M2761 o5 ibias vss vss sky130_fd_pr__nfet_01v8 L=0.5u W=1u
M2762 o5 ibias vss vss sky130_fd_pr__nfet_01v8 L=0.5u W=1u
M2763 o5 ibias vss vss sky130_fd_pr__nfet_01v8 L=0.5u W=1u
M2764 o5 ibias vss vss sky130_fd_pr__nfet_01v8 L=0.5u W=1u
M2765 o5 ibias vss vss sky130_fd_pr__nfet_01v8 L=0.5u W=1u
M2766 o5 ibias vss vss sky130_fd_pr__nfet_01v8 L=0.5u W=1u
M2767 o5 ibias vss vss sky130_fd_pr__nfet_01v8 L=0.5u W=1u
M2768 o5 ibias vss vss sky130_fd_pr__nfet_01v8 L=0.5u W=1u
M2769 o5 ibias vss vss sky130_fd_pr__nfet_01v8 L=0.5u W=1u
M2770 o5 ibias vss vss sky130_fd_pr__nfet_01v8 L=0.5u W=1u
M2771 o5 ibias vss vss sky130_fd_pr__nfet_01v8 L=0.5u W=1u
M2772 o5 ibias vss vss sky130_fd_pr__nfet_01v8 L=0.5u W=1u
M2773 o5 ibias vss vss sky130_fd_pr__nfet_01v8 L=0.5u W=1u
M2774 o5 ibias vss vss sky130_fd_pr__nfet_01v8 L=0.5u W=1u
M2775 o5 ibias vss vss sky130_fd_pr__nfet_01v8 L=0.5u W=1u
M2776 o5 ibias vss vss sky130_fd_pr__nfet_01v8 L=0.5u W=1u
M2777 o5 ibias vss vss sky130_fd_pr__nfet_01v8 L=0.5u W=1u
M2778 o5 ibias vss vss sky130_fd_pr__nfet_01v8 L=0.5u W=1u
M2779 o5 ibias vss vss sky130_fd_pr__nfet_01v8 L=0.5u W=1u
M2780 o5 ibias vss vss sky130_fd_pr__nfet_01v8 L=0.5u W=1u
M2781 o5 ibias vss vss sky130_fd_pr__nfet_01v8 L=0.5u W=1u
M2782 o5 ibias vss vss sky130_fd_pr__nfet_01v8 L=0.5u W=1u
M2783 o5 ibias vss vss sky130_fd_pr__nfet_01v8 L=0.5u W=1u
M2784 o5 ibias vss vss sky130_fd_pr__nfet_01v8 L=0.5u W=1u
M2785 o5 ibias vss vss sky130_fd_pr__nfet_01v8 L=0.5u W=1u
M2786 o5 ibias vss vss sky130_fd_pr__nfet_01v8 L=0.5u W=1u
M2787 o5 ibias vss vss sky130_fd_pr__nfet_01v8 L=0.5u W=1u
M2788 o5 ibias vss vss sky130_fd_pr__nfet_01v8 L=0.5u W=1u
M2789 o5 ibias vss vss sky130_fd_pr__nfet_01v8 L=0.5u W=1u
M2790 o5 ibias vss vss sky130_fd_pr__nfet_01v8 L=0.5u W=1u
M2791 o5 ibias vss vss sky130_fd_pr__nfet_01v8 L=0.5u W=1u
M2792 o5 ibias vss vss sky130_fd_pr__nfet_01v8 L=0.5u W=1u
M2793 o5 ibias vss vss sky130_fd_pr__nfet_01v8 L=0.5u W=1u
M2794 o5 ibias vss vss sky130_fd_pr__nfet_01v8 L=0.5u W=1u
M2795 o5 ibias vss vss sky130_fd_pr__nfet_01v8 L=0.5u W=1u
M2796 o5 ibias vss vss sky130_fd_pr__nfet_01v8 L=0.5u W=1u
M2797 o5 ibias vss vss sky130_fd_pr__nfet_01v8 L=0.5u W=1u
M2798 o5 ibias vss vss sky130_fd_pr__nfet_01v8 L=0.5u W=1u
M2799 o5 ibias vss vss sky130_fd_pr__nfet_01v8 L=0.5u W=1u
M2800 o5 ibias vss vss sky130_fd_pr__nfet_01v8 L=0.5u W=1u
M2801 o5 ibias vss vss sky130_fd_pr__nfet_01v8 L=0.5u W=1u
M2802 o5 ibias vss vss sky130_fd_pr__nfet_01v8 L=0.5u W=1u
M2803 o5 ibias vss vss sky130_fd_pr__nfet_01v8 L=0.5u W=1u
M2804 o5 ibias vss vss sky130_fd_pr__nfet_01v8 L=0.5u W=1u
M2805 o5 ibias vss vss sky130_fd_pr__nfet_01v8 L=0.5u W=1u
M2806 o5 ibias vss vss sky130_fd_pr__nfet_01v8 L=0.5u W=1u
M2807 o5 ibias vss vss sky130_fd_pr__nfet_01v8 L=0.5u W=1u
M2808 o5 ibias vss vss sky130_fd_pr__nfet_01v8 L=0.5u W=1u
M2809 o5 ibias vss vss sky130_fd_pr__nfet_01v8 L=0.5u W=1u
M2810 o5 ibias vss vss sky130_fd_pr__nfet_01v8 L=0.5u W=1u
M2811 o5 ibias vss vss sky130_fd_pr__nfet_01v8 L=0.5u W=1u
M2812 o5 ibias vss vss sky130_fd_pr__nfet_01v8 L=0.5u W=1u
M2813 o5 ibias vss vss sky130_fd_pr__nfet_01v8 L=0.5u W=1u
M2814 o5 ibias vss vss sky130_fd_pr__nfet_01v8 L=0.5u W=1u
M2815 o5 ibias vss vss sky130_fd_pr__nfet_01v8 L=0.5u W=1u
M2816 o5 ibias vss vss sky130_fd_pr__nfet_01v8 L=0.5u W=1u
M2817 o5 ibias vss vss sky130_fd_pr__nfet_01v8 L=0.5u W=1u
M2818 o5 ibias vss vss sky130_fd_pr__nfet_01v8 L=0.5u W=1u
M2819 o5 ibias vss vss sky130_fd_pr__nfet_01v8 L=0.5u W=1u
M2820 o5 ibias vss vss sky130_fd_pr__nfet_01v8 L=0.5u W=1u
M2821 o5 ibias vss vss sky130_fd_pr__nfet_01v8 L=0.5u W=1u
M2822 o5 ibias vss vss sky130_fd_pr__nfet_01v8 L=0.5u W=1u
M2823 o5 ibias vss vss sky130_fd_pr__nfet_01v8 L=0.5u W=1u
M2824 o5 ibias vss vss sky130_fd_pr__nfet_01v8 L=0.5u W=1u
M2825 o5 ibias vss vss sky130_fd_pr__nfet_01v8 L=0.5u W=1u
M2826 o5 ibias vss vss sky130_fd_pr__nfet_01v8 L=0.5u W=1u
M2827 o5 ibias vss vss sky130_fd_pr__nfet_01v8 L=0.5u W=1u
M2828 o5 ibias vss vss sky130_fd_pr__nfet_01v8 L=0.5u W=1u
M2829 o5 ibias vss vss sky130_fd_pr__nfet_01v8 L=0.5u W=1u
M2830 o5 ibias vss vss sky130_fd_pr__nfet_01v8 L=0.5u W=1u
M2831 o5 ibias vss vss sky130_fd_pr__nfet_01v8 L=0.5u W=1u
M2832 o5 ibias vss vss sky130_fd_pr__nfet_01v8 L=0.5u W=1u
M2833 o5 ibias vss vss sky130_fd_pr__nfet_01v8 L=0.5u W=1u
M2834 o5 ibias vss vss sky130_fd_pr__nfet_01v8 L=0.5u W=1u
M2835 o5 ibias vss vss sky130_fd_pr__nfet_01v8 L=0.5u W=1u
M2836 o5 ibias vss vss sky130_fd_pr__nfet_01v8 L=0.5u W=1u
M2837 o5 ibias vss vss sky130_fd_pr__nfet_01v8 L=0.5u W=1u
M2838 o5 ibias vss vss sky130_fd_pr__nfet_01v8 L=0.5u W=1u
M2839 o5 ibias vss vss sky130_fd_pr__nfet_01v8 L=0.5u W=1u
M2840 o5 ibias vss vss sky130_fd_pr__nfet_01v8 L=0.5u W=1u
M2841 o5 ibias vss vss sky130_fd_pr__nfet_01v8 L=0.5u W=1u
M2842 o5 ibias vss vss sky130_fd_pr__nfet_01v8 L=0.5u W=1u
M2843 o5 ibias vss vss sky130_fd_pr__nfet_01v8 L=0.5u W=1u
M2844 o5 ibias vss vss sky130_fd_pr__nfet_01v8 L=0.5u W=1u
M2845 o5 ibias vss vss sky130_fd_pr__nfet_01v8 L=0.5u W=1u
M2846 o5 ibias vss vss sky130_fd_pr__nfet_01v8 L=0.5u W=1u
M2847 o5 ibias vss vss sky130_fd_pr__nfet_01v8 L=0.5u W=1u
M2848 o5 ibias vss vss sky130_fd_pr__nfet_01v8 L=0.5u W=1u
M2849 o5 ibias vss vss sky130_fd_pr__nfet_01v8 L=0.5u W=1u
M2850 o5 ibias vss vss sky130_fd_pr__nfet_01v8 L=0.5u W=1u
M2851 o5 ibias vss vss sky130_fd_pr__nfet_01v8 L=0.5u W=1u
M2852 o5 ibias vss vss sky130_fd_pr__nfet_01v8 L=0.5u W=1u
M2853 o5 ibias vss vss sky130_fd_pr__nfet_01v8 L=0.5u W=1u
M2854 o5 ibias vss vss sky130_fd_pr__nfet_01v8 L=0.5u W=1u
M2855 o5 ibias vss vss sky130_fd_pr__nfet_01v8 L=0.5u W=1u
M2856 o5 ibias vss vss sky130_fd_pr__nfet_01v8 L=0.5u W=1u
M2857 o5 ibias vss vss sky130_fd_pr__nfet_01v8 L=0.5u W=1u
M2858 o5 ibias vss vss sky130_fd_pr__nfet_01v8 L=0.5u W=1u
M2859 o5 ibias vss vss sky130_fd_pr__nfet_01v8 L=0.5u W=1u
M2860 o5 ibias vss vss sky130_fd_pr__nfet_01v8 L=0.5u W=1u
M2861 o5 ibias vss vss sky130_fd_pr__nfet_01v8 L=0.5u W=1u
M2862 o5 ibias vss vss sky130_fd_pr__nfet_01v8 L=0.5u W=1u
M2863 o5 ibias vss vss sky130_fd_pr__nfet_01v8 L=0.5u W=1u
M2864 o5 ibias vss vss sky130_fd_pr__nfet_01v8 L=0.5u W=1u
M2865 o5 ibias vss vss sky130_fd_pr__nfet_01v8 L=0.5u W=1u
M2866 o5 ibias vss vss sky130_fd_pr__nfet_01v8 L=0.5u W=1u
M2867 o5 ibias vss vss sky130_fd_pr__nfet_01v8 L=0.5u W=1u
M2868 o5 ibias vss vss sky130_fd_pr__nfet_01v8 L=0.5u W=1u
M2869 o5 ibias vss vss sky130_fd_pr__nfet_01v8 L=0.5u W=1u
M2870 o5 ibias vss vss sky130_fd_pr__nfet_01v8 L=0.5u W=1u
M2871 o5 ibias vss vss sky130_fd_pr__nfet_01v8 L=0.5u W=1u
M2872 o5 ibias vss vss sky130_fd_pr__nfet_01v8 L=0.5u W=1u
M2873 o5 ibias vss vss sky130_fd_pr__nfet_01v8 L=0.5u W=1u
M2874 o5 ibias vss vss sky130_fd_pr__nfet_01v8 L=0.5u W=1u
M2875 o5 ibias vss vss sky130_fd_pr__nfet_01v8 L=0.5u W=1u
M2876 o5 ibias vss vss sky130_fd_pr__nfet_01v8 L=0.5u W=1u
M2877 o5 ibias vss vss sky130_fd_pr__nfet_01v8 L=0.5u W=1u
M2878 o5 ibias vss vss sky130_fd_pr__nfet_01v8 L=0.5u W=1u
M2879 o5 ibias vss vss sky130_fd_pr__nfet_01v8 L=0.5u W=1u
M2880 o5 ibias vss vss sky130_fd_pr__nfet_01v8 L=0.5u W=1u
M2881 o5 ibias vss vss sky130_fd_pr__nfet_01v8 L=0.5u W=1u
M2882 o5 ibias vss vss sky130_fd_pr__nfet_01v8 L=0.5u W=1u
M2883 o5 ibias vss vss sky130_fd_pr__nfet_01v8 L=0.5u W=1u
M2884 o5 ibias vss vss sky130_fd_pr__nfet_01v8 L=0.5u W=1u
M2885 o5 ibias vss vss sky130_fd_pr__nfet_01v8 L=0.5u W=1u
M2886 o5 ibias vss vss sky130_fd_pr__nfet_01v8 L=0.5u W=1u
M2887 o5 ibias vss vss sky130_fd_pr__nfet_01v8 L=0.5u W=1u
M2888 o5 ibias vss vss sky130_fd_pr__nfet_01v8 L=0.5u W=1u
M2889 o5 ibias vss vss sky130_fd_pr__nfet_01v8 L=0.5u W=1u
M2890 o5 ibias vss vss sky130_fd_pr__nfet_01v8 L=0.5u W=1u
M2891 o5 ibias vss vss sky130_fd_pr__nfet_01v8 L=0.5u W=1u
M2892 o5 ibias vss vss sky130_fd_pr__nfet_01v8 L=0.5u W=1u
M2893 o5 ibias vss vss sky130_fd_pr__nfet_01v8 L=0.5u W=1u
M2894 o5 ibias vss vss sky130_fd_pr__nfet_01v8 L=0.5u W=1u
M2895 o5 ibias vss vss sky130_fd_pr__nfet_01v8 L=0.5u W=1u
M2896 o5 ibias vss vss sky130_fd_pr__nfet_01v8 L=0.5u W=1u
M2897 o5 ibias vss vss sky130_fd_pr__nfet_01v8 L=0.5u W=1u
M2898 o5 ibias vss vss sky130_fd_pr__nfet_01v8 L=0.5u W=1u
M2899 o5 ibias vss vss sky130_fd_pr__nfet_01v8 L=0.5u W=1u
M2900 o5 ibias vss vss sky130_fd_pr__nfet_01v8 L=0.5u W=1u
M2901 o5 ibias vss vss sky130_fd_pr__nfet_01v8 L=0.5u W=1u
M2902 o5 ibias vss vss sky130_fd_pr__nfet_01v8 L=0.5u W=1u
M2903 o5 ibias vss vss sky130_fd_pr__nfet_01v8 L=0.5u W=1u
M2904 o5 ibias vss vss sky130_fd_pr__nfet_01v8 L=0.5u W=1u
M2905 o5 ibias vss vss sky130_fd_pr__nfet_01v8 L=0.5u W=1u
M2906 o5 ibias vss vss sky130_fd_pr__nfet_01v8 L=0.5u W=1u
M2907 o5 ibias vss vss sky130_fd_pr__nfet_01v8 L=0.5u W=1u
M2908 o5 ibias vss vss sky130_fd_pr__nfet_01v8 L=0.5u W=1u
M2909 o5 ibias vss vss sky130_fd_pr__nfet_01v8 L=0.5u W=1u
M2910 o5 ibias vss vss sky130_fd_pr__nfet_01v8 L=0.5u W=1u
M2911 o5 ibias vss vss sky130_fd_pr__nfet_01v8 L=0.5u W=1u
M2912 o5 ibias vss vss sky130_fd_pr__nfet_01v8 L=0.5u W=1u
M2913 o5 ibias vss vss sky130_fd_pr__nfet_01v8 L=0.5u W=1u
M2914 o5 ibias vss vss sky130_fd_pr__nfet_01v8 L=0.5u W=1u
M2915 o5 ibias vss vss sky130_fd_pr__nfet_01v8 L=0.5u W=1u
M2916 o5 ibias vss vss sky130_fd_pr__nfet_01v8 L=0.5u W=1u
M2917 o5 ibias vss vss sky130_fd_pr__nfet_01v8 L=0.5u W=1u
M2918 o5 ibias vss vss sky130_fd_pr__nfet_01v8 L=0.5u W=1u
M2919 o5 ibias vss vss sky130_fd_pr__nfet_01v8 L=0.5u W=1u
M2920 o5 ibias vss vss sky130_fd_pr__nfet_01v8 L=0.5u W=1u
M2921 o5 ibias vss vss sky130_fd_pr__nfet_01v8 L=0.5u W=1u
M2922 o5 ibias vss vss sky130_fd_pr__nfet_01v8 L=0.5u W=1u
M2923 o5 ibias vss vss sky130_fd_pr__nfet_01v8 L=0.5u W=1u
M2924 o5 ibias vss vss sky130_fd_pr__nfet_01v8 L=0.5u W=1u
M2925 o5 ibias vss vss sky130_fd_pr__nfet_01v8 L=0.5u W=1u
M2926 o5 ibias vss vss sky130_fd_pr__nfet_01v8 L=0.5u W=1u
M2927 o5 ibias vss vss sky130_fd_pr__nfet_01v8 L=0.5u W=1u
M2928 o5 ibias vss vss sky130_fd_pr__nfet_01v8 L=0.5u W=1u
M2929 o5 ibias vss vss sky130_fd_pr__nfet_01v8 L=0.5u W=1u
M2930 o5 ibias vss vss sky130_fd_pr__nfet_01v8 L=0.5u W=1u
M2931 o5 ibias vss vss sky130_fd_pr__nfet_01v8 L=0.5u W=1u
M2932 o5 ibias vss vss sky130_fd_pr__nfet_01v8 L=0.5u W=1u
M2933 o5 ibias vss vss sky130_fd_pr__nfet_01v8 L=0.5u W=1u
M2934 o5 ibias vss vss sky130_fd_pr__nfet_01v8 L=0.5u W=1u
M2935 o5 ibias vss vss sky130_fd_pr__nfet_01v8 L=0.5u W=1u
M2936 o5 ibias vss vss sky130_fd_pr__nfet_01v8 L=0.5u W=1u
M2937 o5 ibias vss vss sky130_fd_pr__nfet_01v8 L=0.5u W=1u
M2938 o5 ibias vss vss sky130_fd_pr__nfet_01v8 L=0.5u W=1u
M2939 o5 ibias vss vss sky130_fd_pr__nfet_01v8 L=0.5u W=1u
M2940 o5 ibias vss vss sky130_fd_pr__nfet_01v8 L=0.5u W=1u
M2941 o5 ibias vss vss sky130_fd_pr__nfet_01v8 L=0.5u W=1u
M2942 o5 ibias vss vss sky130_fd_pr__nfet_01v8 L=0.5u W=1u
M2943 o5 ibias vss vss sky130_fd_pr__nfet_01v8 L=0.5u W=1u
M2944 o5 ibias vss vss sky130_fd_pr__nfet_01v8 L=0.5u W=1u
M2945 o5 ibias vss vss sky130_fd_pr__nfet_01v8 L=0.5u W=1u
M2946 o5 ibias vss vss sky130_fd_pr__nfet_01v8 L=0.5u W=1u
M2947 o5 ibias vss vss sky130_fd_pr__nfet_01v8 L=0.5u W=1u
M2948 o5 ibias vss vss sky130_fd_pr__nfet_01v8 L=0.5u W=1u
M2949 o5 ibias vss vss sky130_fd_pr__nfet_01v8 L=0.5u W=1u
M2950 o5 ibias vss vss sky130_fd_pr__nfet_01v8 L=0.5u W=1u
M2951 o5 ibias vss vss sky130_fd_pr__nfet_01v8 L=0.5u W=1u
M2952 o5 ibias vss vss sky130_fd_pr__nfet_01v8 L=0.5u W=1u
M2953 o5 ibias vss vss sky130_fd_pr__nfet_01v8 L=0.5u W=1u
M2954 o5 ibias vss vss sky130_fd_pr__nfet_01v8 L=0.5u W=1u
M2955 o5 ibias vss vss sky130_fd_pr__nfet_01v8 L=0.5u W=1u
M2956 o5 ibias vss vss sky130_fd_pr__nfet_01v8 L=0.5u W=1u
M2957 o5 ibias vss vss sky130_fd_pr__nfet_01v8 L=0.5u W=1u
M2958 o5 ibias vss vss sky130_fd_pr__nfet_01v8 L=0.5u W=1u
M2959 o5 ibias vss vss sky130_fd_pr__nfet_01v8 L=0.5u W=1u
M2960 o5 ibias vss vss sky130_fd_pr__nfet_01v8 L=0.5u W=1u
M2961 o5 ibias vss vss sky130_fd_pr__nfet_01v8 L=0.5u W=1u
M2962 o5 ibias vss vss sky130_fd_pr__nfet_01v8 L=0.5u W=1u
M2963 o5 ibias vss vss sky130_fd_pr__nfet_01v8 L=0.5u W=1u
M2964 o5 ibias vss vss sky130_fd_pr__nfet_01v8 L=0.5u W=1u
M2965 o5 ibias vss vss sky130_fd_pr__nfet_01v8 L=0.5u W=1u
M2966 o5 ibias vss vss sky130_fd_pr__nfet_01v8 L=0.5u W=1u
M2967 o5 ibias vss vss sky130_fd_pr__nfet_01v8 L=0.5u W=1u
M2968 o5 ibias vss vss sky130_fd_pr__nfet_01v8 L=0.5u W=1u
M2969 o5 ibias vss vss sky130_fd_pr__nfet_01v8 L=0.5u W=1u
M2970 o5 ibias vss vss sky130_fd_pr__nfet_01v8 L=0.5u W=1u
M2971 o5 ibias vss vss sky130_fd_pr__nfet_01v8 L=0.5u W=1u
M2972 o5 ibias vss vss sky130_fd_pr__nfet_01v8 L=0.5u W=1u
M2973 o5 ibias vss vss sky130_fd_pr__nfet_01v8 L=0.5u W=1u
M2974 o5 ibias vss vss sky130_fd_pr__nfet_01v8 L=0.5u W=1u
M2975 o5 ibias vss vss sky130_fd_pr__nfet_01v8 L=0.5u W=1u
M2976 o5 ibias vss vss sky130_fd_pr__nfet_01v8 L=0.5u W=1u
M2977 o5 ibias vss vss sky130_fd_pr__nfet_01v8 L=0.5u W=1u
M2978 o5 ibias vss vss sky130_fd_pr__nfet_01v8 L=0.5u W=1u
M2979 o5 ibias vss vss sky130_fd_pr__nfet_01v8 L=0.5u W=1u
M2980 o5 ibias vss vss sky130_fd_pr__nfet_01v8 L=0.5u W=1u
M2981 o5 ibias vss vss sky130_fd_pr__nfet_01v8 L=0.5u W=1u
M2982 o5 ibias vss vss sky130_fd_pr__nfet_01v8 L=0.5u W=1u
M2983 o5 ibias vss vss sky130_fd_pr__nfet_01v8 L=0.5u W=1u
M2984 o5 ibias vss vss sky130_fd_pr__nfet_01v8 L=0.5u W=1u
M2985 o5 ibias vss vss sky130_fd_pr__nfet_01v8 L=0.5u W=1u
M2986 o5 ibias vss vss sky130_fd_pr__nfet_01v8 L=0.5u W=1u
M2987 o5 ibias vss vss sky130_fd_pr__nfet_01v8 L=0.5u W=1u
M2988 o5 ibias vss vss sky130_fd_pr__nfet_01v8 L=0.5u W=1u
M2989 o5 ibias vss vss sky130_fd_pr__nfet_01v8 L=0.5u W=1u
M2990 o5 ibias vss vss sky130_fd_pr__nfet_01v8 L=0.5u W=1u
M2991 o5 ibias vss vss sky130_fd_pr__nfet_01v8 L=0.5u W=1u
M2992 o5 ibias vss vss sky130_fd_pr__nfet_01v8 L=0.5u W=1u
M2993 o5 ibias vss vss sky130_fd_pr__nfet_01v8 L=0.5u W=1u
M2994 o5 ibias vss vss sky130_fd_pr__nfet_01v8 L=0.5u W=1u
M2995 o5 ibias vss vss sky130_fd_pr__nfet_01v8 L=0.5u W=1u
M2996 o5 ibias vss vss sky130_fd_pr__nfet_01v8 L=0.5u W=1u
M2997 o5 ibias vss vss sky130_fd_pr__nfet_01v8 L=0.5u W=1u
M2998 o5 ibias vss vss sky130_fd_pr__nfet_01v8 L=0.5u W=1u
M2999 o5 ibias vss vss sky130_fd_pr__nfet_01v8 L=0.5u W=1u
M3000 o5 ibias vss vss sky130_fd_pr__nfet_01v8 L=0.5u W=1u
M3001 o5 ibias vss vss sky130_fd_pr__nfet_01v8 L=0.5u W=1u
M3002 o5 ibias vss vss sky130_fd_pr__nfet_01v8 L=0.5u W=1u
M3003 o5 ibias vss vss sky130_fd_pr__nfet_01v8 L=0.5u W=1u
M3004 o5 ibias vss vss sky130_fd_pr__nfet_01v8 L=0.5u W=1u
M3005 o5 ibias vss vss sky130_fd_pr__nfet_01v8 L=0.5u W=1u
M3006 o5 ibias vss vss sky130_fd_pr__nfet_01v8 L=0.5u W=1u
M3007 o5 ibias vss vss sky130_fd_pr__nfet_01v8 L=0.5u W=1u
M3008 o5 ibias vss vss sky130_fd_pr__nfet_01v8 L=0.5u W=1u
M3009 o5 ibias vss vss sky130_fd_pr__nfet_01v8 L=0.5u W=1u
M3010 o5 ibias vss vss sky130_fd_pr__nfet_01v8 L=0.5u W=1u
M3011 o5 ibias vss vss sky130_fd_pr__nfet_01v8 L=0.5u W=1u
M3012 o5 ibias vss vss sky130_fd_pr__nfet_01v8 L=0.5u W=1u
M3013 o5 ibias vss vss sky130_fd_pr__nfet_01v8 L=0.5u W=1u
M3014 o5 ibias vss vss sky130_fd_pr__nfet_01v8 L=0.5u W=1u
M3015 o5 ibias vss vss sky130_fd_pr__nfet_01v8 L=0.5u W=1u
M3016 o5 ibias vss vss sky130_fd_pr__nfet_01v8 L=0.5u W=1u
M3017 o5 ibias vss vss sky130_fd_pr__nfet_01v8 L=0.5u W=1u
M3018 o5 ibias vss vss sky130_fd_pr__nfet_01v8 L=0.5u W=1u
M3019 o5 ibias vss vss sky130_fd_pr__nfet_01v8 L=0.5u W=1u
M3020 o5 ibias vss vss sky130_fd_pr__nfet_01v8 L=0.5u W=1u
M3021 o5 ibias vss vss sky130_fd_pr__nfet_01v8 L=0.5u W=1u
M3022 o5 ibias vss vss sky130_fd_pr__nfet_01v8 L=0.5u W=1u
M3023 o5 ibias vss vss sky130_fd_pr__nfet_01v8 L=0.5u W=1u
M3024 o5 ibias vss vss sky130_fd_pr__nfet_01v8 L=0.5u W=1u
M3025 o5 ibias vss vss sky130_fd_pr__nfet_01v8 L=0.5u W=1u
M3026 o5 ibias vss vss sky130_fd_pr__nfet_01v8 L=0.5u W=1u
M3027 o5 ibias vss vss sky130_fd_pr__nfet_01v8 L=0.5u W=1u
M3028 o5 ibias vss vss sky130_fd_pr__nfet_01v8 L=0.5u W=1u
M3029 o5 ibias vss vss sky130_fd_pr__nfet_01v8 L=0.5u W=1u
M3030 o5 ibias vss vss sky130_fd_pr__nfet_01v8 L=0.5u W=1u
M3031 o5 ibias vss vss sky130_fd_pr__nfet_01v8 L=0.5u W=1u
M3032 o5 ibias vss vss sky130_fd_pr__nfet_01v8 L=0.5u W=1u
M3033 o5 ibias vss vss sky130_fd_pr__nfet_01v8 L=0.5u W=1u
M3034 o5 ibias vss vss sky130_fd_pr__nfet_01v8 L=0.5u W=1u
M3035 o5 ibias vss vss sky130_fd_pr__nfet_01v8 L=0.5u W=1u
M3036 o5 ibias vss vss sky130_fd_pr__nfet_01v8 L=0.5u W=1u
M3037 o5 ibias vss vss sky130_fd_pr__nfet_01v8 L=0.5u W=1u
M3038 o5 ibias vss vss sky130_fd_pr__nfet_01v8 L=0.5u W=1u
M3039 o5 ibias vss vss sky130_fd_pr__nfet_01v8 L=0.5u W=1u
M3040 o5 ibias vss vss sky130_fd_pr__nfet_01v8 L=0.5u W=1u
M3041 o5 ibias vss vss sky130_fd_pr__nfet_01v8 L=0.5u W=1u
M3042 o5 ibias vss vss sky130_fd_pr__nfet_01v8 L=0.5u W=1u
M3043 o5 ibias vss vss sky130_fd_pr__nfet_01v8 L=0.5u W=1u
M3044 o5 ibias vss vss sky130_fd_pr__nfet_01v8 L=0.5u W=1u
M3045 o5 ibias vss vss sky130_fd_pr__nfet_01v8 L=0.5u W=1u
M3046 o5 ibias vss vss sky130_fd_pr__nfet_01v8 L=0.5u W=1u
M3047 o5 ibias vss vss sky130_fd_pr__nfet_01v8 L=0.5u W=1u
M3048 o5 ibias vss vss sky130_fd_pr__nfet_01v8 L=0.5u W=1u
M3049 o5 ibias vss vss sky130_fd_pr__nfet_01v8 L=0.5u W=1u
M3050 o5 ibias vss vss sky130_fd_pr__nfet_01v8 L=0.5u W=1u
M3051 o5 ibias vss vss sky130_fd_pr__nfet_01v8 L=0.5u W=1u
M3052 o5 ibias vss vss sky130_fd_pr__nfet_01v8 L=0.5u W=1u
M3053 o5 ibias vss vss sky130_fd_pr__nfet_01v8 L=0.5u W=1u
M3054 o5 ibias vss vss sky130_fd_pr__nfet_01v8 L=0.5u W=1u
M3055 o5 ibias vss vss sky130_fd_pr__nfet_01v8 L=0.5u W=1u
M3056 o5 ibias vss vss sky130_fd_pr__nfet_01v8 L=0.5u W=1u
M3057 o5 ibias vss vss sky130_fd_pr__nfet_01v8 L=0.5u W=1u
M3058 o5 ibias vss vss sky130_fd_pr__nfet_01v8 L=0.5u W=1u
M3059 o5 ibias vss vss sky130_fd_pr__nfet_01v8 L=0.5u W=1u
M3060 o5 ibias vss vss sky130_fd_pr__nfet_01v8 L=0.5u W=1u
M3061 o5 ibias vss vss sky130_fd_pr__nfet_01v8 L=0.5u W=1u
M3062 o5 ibias vss vss sky130_fd_pr__nfet_01v8 L=0.5u W=1u
M3063 o5 ibias vss vss sky130_fd_pr__nfet_01v8 L=0.5u W=1u
M3064 o5 ibias vss vss sky130_fd_pr__nfet_01v8 L=0.5u W=1u
M3065 o5 ibias vss vss sky130_fd_pr__nfet_01v8 L=0.5u W=1u
M3066 o5 ibias vss vss sky130_fd_pr__nfet_01v8 L=0.5u W=1u
M3067 o5 ibias vss vss sky130_fd_pr__nfet_01v8 L=0.5u W=1u
M3068 o5 ibias vss vss sky130_fd_pr__nfet_01v8 L=0.5u W=1u
M3069 o5 ibias vss vss sky130_fd_pr__nfet_01v8 L=0.5u W=1u
M3070 o5 ibias vss vss sky130_fd_pr__nfet_01v8 L=0.5u W=1u
M3071 o5 ibias vss vss sky130_fd_pr__nfet_01v8 L=0.5u W=1u
M3072 o5 ibias vss vss sky130_fd_pr__nfet_01v8 L=0.5u W=1u
M3073 o5 ibias vss vss sky130_fd_pr__nfet_01v8 L=0.5u W=1u
M3074 o5 ibias vss vss sky130_fd_pr__nfet_01v8 L=0.5u W=1u
M3075 o5 ibias vss vss sky130_fd_pr__nfet_01v8 L=0.5u W=1u
M3076 o5 ibias vss vss sky130_fd_pr__nfet_01v8 L=0.5u W=1u
M3077 o5 ibias vss vss sky130_fd_pr__nfet_01v8 L=0.5u W=1u
M3078 o5 ibias vss vss sky130_fd_pr__nfet_01v8 L=0.5u W=1u
M3079 o5 ibias vss vss sky130_fd_pr__nfet_01v8 L=0.5u W=1u
M3080 o5 ibias vss vss sky130_fd_pr__nfet_01v8 L=0.5u W=1u
M3081 o5 ibias vss vss sky130_fd_pr__nfet_01v8 L=0.5u W=1u
M3082 o5 ibias vss vss sky130_fd_pr__nfet_01v8 L=0.5u W=1u
M3083 o5 ibias vss vss sky130_fd_pr__nfet_01v8 L=0.5u W=1u
M3084 o5 ibias vss vss sky130_fd_pr__nfet_01v8 L=0.5u W=1u
M3085 o5 ibias vss vss sky130_fd_pr__nfet_01v8 L=0.5u W=1u
M3086 o5 ibias vss vss sky130_fd_pr__nfet_01v8 L=0.5u W=1u
M3087 o5 ibias vss vss sky130_fd_pr__nfet_01v8 L=0.5u W=1u
M3088 o5 ibias vss vss sky130_fd_pr__nfet_01v8 L=0.5u W=1u
M3089 o5 ibias vss vss sky130_fd_pr__nfet_01v8 L=0.5u W=1u
M3090 o5 ibias vss vss sky130_fd_pr__nfet_01v8 L=0.5u W=1u
M3091 o5 ibias vss vss sky130_fd_pr__nfet_01v8 L=0.5u W=1u
M3092 o5 ibias vss vss sky130_fd_pr__nfet_01v8 L=0.5u W=1u
M3093 o5 ibias vss vss sky130_fd_pr__nfet_01v8 L=0.5u W=1u
M3094 o5 ibias vss vss sky130_fd_pr__nfet_01v8 L=0.5u W=1u
M3095 o5 ibias vss vss sky130_fd_pr__nfet_01v8 L=0.5u W=1u
M3096 o5 ibias vss vss sky130_fd_pr__nfet_01v8 L=0.5u W=1u
M3097 o5 ibias vss vss sky130_fd_pr__nfet_01v8 L=0.5u W=1u
M3098 o5 ibias vss vss sky130_fd_pr__nfet_01v8 L=0.5u W=1u
M3099 o5 ibias vss vss sky130_fd_pr__nfet_01v8 L=0.5u W=1u
M3100 o5 ibias vss vss sky130_fd_pr__nfet_01v8 L=0.5u W=1u
M3101 o5 ibias vss vss sky130_fd_pr__nfet_01v8 L=0.5u W=1u
M3102 o5 ibias vss vss sky130_fd_pr__nfet_01v8 L=0.5u W=1u
M3103 o5 ibias vss vss sky130_fd_pr__nfet_01v8 L=0.5u W=1u
M3104 o5 ibias vss vss sky130_fd_pr__nfet_01v8 L=0.5u W=1u
M3105 o5 ibias vss vss sky130_fd_pr__nfet_01v8 L=0.5u W=1u
M3106 o5 ibias vss vss sky130_fd_pr__nfet_01v8 L=0.5u W=1u
M3107 o5 ibias vss vss sky130_fd_pr__nfet_01v8 L=0.5u W=1u
M3108 o5 ibias vss vss sky130_fd_pr__nfet_01v8 L=0.5u W=1u
M3109 o5 ibias vss vss sky130_fd_pr__nfet_01v8 L=0.5u W=1u
M3110 o5 ibias vss vss sky130_fd_pr__nfet_01v8 L=0.5u W=1u
M3111 o5 ibias vss vss sky130_fd_pr__nfet_01v8 L=0.5u W=1u
M3112 o5 ibias vss vss sky130_fd_pr__nfet_01v8 L=0.5u W=1u
M3113 o5 ibias vss vss sky130_fd_pr__nfet_01v8 L=0.5u W=1u
M3114 o5 ibias vss vss sky130_fd_pr__nfet_01v8 L=0.5u W=1u
M3115 o5 ibias vss vss sky130_fd_pr__nfet_01v8 L=0.5u W=1u
M3116 o5 ibias vss vss sky130_fd_pr__nfet_01v8 L=0.5u W=1u
M3117 o5 ibias vss vss sky130_fd_pr__nfet_01v8 L=0.5u W=1u
M3118 o5 ibias vss vss sky130_fd_pr__nfet_01v8 L=0.5u W=1u
M3119 o5 ibias vss vss sky130_fd_pr__nfet_01v8 L=0.5u W=1u
M3120 o5 ibias vss vss sky130_fd_pr__nfet_01v8 L=0.5u W=1u
M3121 o5 ibias vss vss sky130_fd_pr__nfet_01v8 L=0.5u W=1u
M3122 o5 ibias vss vss sky130_fd_pr__nfet_01v8 L=0.5u W=1u
M3123 o5 ibias vss vss sky130_fd_pr__nfet_01v8 L=0.5u W=1u
M3124 o5 ibias vss vss sky130_fd_pr__nfet_01v8 L=0.5u W=1u
M3125 o5 ibias vss vss sky130_fd_pr__nfet_01v8 L=0.5u W=1u
M3126 o5 ibias vss vss sky130_fd_pr__nfet_01v8 L=0.5u W=1u
M3127 o5 ibias vss vss sky130_fd_pr__nfet_01v8 L=0.5u W=1u
M3128 o5 ibias vss vss sky130_fd_pr__nfet_01v8 L=0.5u W=1u
M3129 o5 ibias vss vss sky130_fd_pr__nfet_01v8 L=0.5u W=1u
M3130 o5 ibias vss vss sky130_fd_pr__nfet_01v8 L=0.5u W=1u
M3131 o5 ibias vss vss sky130_fd_pr__nfet_01v8 L=0.5u W=1u
M3132 o5 ibias vss vss sky130_fd_pr__nfet_01v8 L=0.5u W=1u
M3133 o5 ibias vss vss sky130_fd_pr__nfet_01v8 L=0.5u W=1u
M3134 o5 ibias vss vss sky130_fd_pr__nfet_01v8 L=0.5u W=1u
M3135 o5 ibias vss vss sky130_fd_pr__nfet_01v8 L=0.5u W=1u
M3136 o5 ibias vss vss sky130_fd_pr__nfet_01v8 L=0.5u W=1u
M3137 o5 ibias vss vss sky130_fd_pr__nfet_01v8 L=0.5u W=1u
M3138 o5 ibias vss vss sky130_fd_pr__nfet_01v8 L=0.5u W=1u
M3139 o5 ibias vss vss sky130_fd_pr__nfet_01v8 L=0.5u W=1u
M3140 o5 ibias vss vss sky130_fd_pr__nfet_01v8 L=0.5u W=1u
M3141 o5 ibias vss vss sky130_fd_pr__nfet_01v8 L=0.5u W=1u
M3142 o5 ibias vss vss sky130_fd_pr__nfet_01v8 L=0.5u W=1u
M3143 o5 ibias vss vss sky130_fd_pr__nfet_01v8 L=0.5u W=1u
M3144 o5 ibias vss vss sky130_fd_pr__nfet_01v8 L=0.5u W=1u
M3145 o5 ibias vss vss sky130_fd_pr__nfet_01v8 L=0.5u W=1u
M3146 o5 ibias vss vss sky130_fd_pr__nfet_01v8 L=0.5u W=1u
M3147 o5 ibias vss vss sky130_fd_pr__nfet_01v8 L=0.5u W=1u
M3148 o5 ibias vss vss sky130_fd_pr__nfet_01v8 L=0.5u W=1u
M3149 o5 ibias vss vss sky130_fd_pr__nfet_01v8 L=0.5u W=1u
M3150 o5 ibias vss vss sky130_fd_pr__nfet_01v8 L=0.5u W=1u
M3151 o5 ibias vss vss sky130_fd_pr__nfet_01v8 L=0.5u W=1u
M3152 o5 ibias vss vss sky130_fd_pr__nfet_01v8 L=0.5u W=1u
M3153 o5 ibias vss vss sky130_fd_pr__nfet_01v8 L=0.5u W=1u
M3154 o5 ibias vss vss sky130_fd_pr__nfet_01v8 L=0.5u W=1u
M3155 o5 ibias vss vss sky130_fd_pr__nfet_01v8 L=0.5u W=1u
M3156 o5 ibias vss vss sky130_fd_pr__nfet_01v8 L=0.5u W=1u
M3157 o5 ibias vss vss sky130_fd_pr__nfet_01v8 L=0.5u W=1u
M3158 o5 ibias vss vss sky130_fd_pr__nfet_01v8 L=0.5u W=1u
M3159 o5 ibias vss vss sky130_fd_pr__nfet_01v8 L=0.5u W=1u
M3160 o5 ibias vss vss sky130_fd_pr__nfet_01v8 L=0.5u W=1u
M3161 o5 ibias vss vss sky130_fd_pr__nfet_01v8 L=0.5u W=1u
M3162 o5 ibias vss vss sky130_fd_pr__nfet_01v8 L=0.5u W=1u
M3163 o5 ibias vss vss sky130_fd_pr__nfet_01v8 L=0.5u W=1u
M3164 o5 ibias vss vss sky130_fd_pr__nfet_01v8 L=0.5u W=1u
M3165 o5 ibias vss vss sky130_fd_pr__nfet_01v8 L=0.5u W=1u
M3166 o5 ibias vss vss sky130_fd_pr__nfet_01v8 L=0.5u W=1u
M3167 o5 ibias vss vss sky130_fd_pr__nfet_01v8 L=0.5u W=1u
M3168 o5 ibias vss vss sky130_fd_pr__nfet_01v8 L=0.5u W=1u
M3169 o5 ibias vss vss sky130_fd_pr__nfet_01v8 L=0.5u W=1u
M3170 o5 ibias vss vss sky130_fd_pr__nfet_01v8 L=0.5u W=1u
M3171 o5 ibias vss vss sky130_fd_pr__nfet_01v8 L=0.5u W=1u
M3172 o5 ibias vss vss sky130_fd_pr__nfet_01v8 L=0.5u W=1u
M3173 o5 ibias vss vss sky130_fd_pr__nfet_01v8 L=0.5u W=1u
M3174 o5 ibias vss vss sky130_fd_pr__nfet_01v8 L=0.5u W=1u
M3175 o5 ibias vss vss sky130_fd_pr__nfet_01v8 L=0.5u W=1u
M3176 o5 ibias vss vss sky130_fd_pr__nfet_01v8 L=0.5u W=1u
M3177 o5 ibias vss vss sky130_fd_pr__nfet_01v8 L=0.5u W=1u
M3178 o5 ibias vss vss sky130_fd_pr__nfet_01v8 L=0.5u W=1u
M3179 o5 ibias vss vss sky130_fd_pr__nfet_01v8 L=0.5u W=1u
M3180 o5 ibias vss vss sky130_fd_pr__nfet_01v8 L=0.5u W=1u
M3181 o5 ibias vss vss sky130_fd_pr__nfet_01v8 L=0.5u W=1u
M3182 o5 ibias vss vss sky130_fd_pr__nfet_01v8 L=0.5u W=1u
M3183 o5 ibias vss vss sky130_fd_pr__nfet_01v8 L=0.5u W=1u
M3184 o5 ibias vss vss sky130_fd_pr__nfet_01v8 L=0.5u W=1u
M3185 o5 ibias vss vss sky130_fd_pr__nfet_01v8 L=0.5u W=1u
M3186 o5 ibias vss vss sky130_fd_pr__nfet_01v8 L=0.5u W=1u
M3187 o5 ibias vss vss sky130_fd_pr__nfet_01v8 L=0.5u W=1u
M3188 o5 ibias vss vss sky130_fd_pr__nfet_01v8 L=0.5u W=1u
M3189 o5 ibias vss vss sky130_fd_pr__nfet_01v8 L=0.5u W=1u
M3190 o5 ibias vss vss sky130_fd_pr__nfet_01v8 L=0.5u W=1u
M3191 o5 ibias vss vss sky130_fd_pr__nfet_01v8 L=0.5u W=1u
M3192 o5 ibias vss vss sky130_fd_pr__nfet_01v8 L=0.5u W=1u
M3193 o5 ibias vss vss sky130_fd_pr__nfet_01v8 L=0.5u W=1u
M3194 o5 ibias vss vss sky130_fd_pr__nfet_01v8 L=0.5u W=1u
M3195 o5 ibias vss vss sky130_fd_pr__nfet_01v8 L=0.5u W=1u
M3196 o5 ibias vss vss sky130_fd_pr__nfet_01v8 L=0.5u W=1u
M3197 o5 ibias vss vss sky130_fd_pr__nfet_01v8 L=0.5u W=1u
M3198 o5 ibias vss vss sky130_fd_pr__nfet_01v8 L=0.5u W=1u
M3199 o5 ibias vss vss sky130_fd_pr__nfet_01v8 L=0.5u W=1u
M3200 o5 ibias vss vss sky130_fd_pr__nfet_01v8 L=0.5u W=1u
M3201 o5 ibias vss vss sky130_fd_pr__nfet_01v8 L=0.5u W=1u
M3202 o5 ibias vss vss sky130_fd_pr__nfet_01v8 L=0.5u W=1u
M3203 o5 ibias vss vss sky130_fd_pr__nfet_01v8 L=0.5u W=1u
M3204 o5 ibias vss vss sky130_fd_pr__nfet_01v8 L=0.5u W=1u
M3205 o5 ibias vss vss sky130_fd_pr__nfet_01v8 L=0.5u W=1u
M3206 o5 ibias vss vss sky130_fd_pr__nfet_01v8 L=0.5u W=1u
M3207 o5 ibias vss vss sky130_fd_pr__nfet_01v8 L=0.5u W=1u
M3208 o5 ibias vss vss sky130_fd_pr__nfet_01v8 L=0.5u W=1u
M3209 o5 ibias vss vss sky130_fd_pr__nfet_01v8 L=0.5u W=1u
M3210 o5 ibias vss vss sky130_fd_pr__nfet_01v8 L=0.5u W=1u
M3211 o5 ibias vss vss sky130_fd_pr__nfet_01v8 L=0.5u W=1u
M3212 o5 ibias vss vss sky130_fd_pr__nfet_01v8 L=0.5u W=1u
M3213 o5 ibias vss vss sky130_fd_pr__nfet_01v8 L=0.5u W=1u
M3214 o5 ibias vss vss sky130_fd_pr__nfet_01v8 L=0.5u W=1u
M3215 o5 ibias vss vss sky130_fd_pr__nfet_01v8 L=0.5u W=1u
M3216 o5 ibias vss vss sky130_fd_pr__nfet_01v8 L=0.5u W=1u
M3217 o5 ibias vss vss sky130_fd_pr__nfet_01v8 L=0.5u W=1u
M3218 o5 ibias vss vss sky130_fd_pr__nfet_01v8 L=0.5u W=1u
M3219 o5 ibias vss vss sky130_fd_pr__nfet_01v8 L=0.5u W=1u
M3220 o5 ibias vss vss sky130_fd_pr__nfet_01v8 L=0.5u W=1u
M3221 o5 ibias vss vss sky130_fd_pr__nfet_01v8 L=0.5u W=1u
M3222 o5 ibias vss vss sky130_fd_pr__nfet_01v8 L=0.5u W=1u
M3223 o5 ibias vss vss sky130_fd_pr__nfet_01v8 L=0.5u W=1u
M3224 o5 ibias vss vss sky130_fd_pr__nfet_01v8 L=0.5u W=1u
M3225 o5 ibias vss vss sky130_fd_pr__nfet_01v8 L=0.5u W=1u
M3226 o5 ibias vss vss sky130_fd_pr__nfet_01v8 L=0.5u W=1u
M3227 o5 ibias vss vss sky130_fd_pr__nfet_01v8 L=0.5u W=1u
M3228 o5 ibias vss vss sky130_fd_pr__nfet_01v8 L=0.5u W=1u
M3229 o5 ibias vss vss sky130_fd_pr__nfet_01v8 L=0.5u W=1u
M3230 o5 ibias vss vss sky130_fd_pr__nfet_01v8 L=0.5u W=1u
M3231 o5 ibias vss vss sky130_fd_pr__nfet_01v8 L=0.5u W=1u
M3232 o5 ibias vss vss sky130_fd_pr__nfet_01v8 L=0.5u W=1u
M3233 o5 ibias vss vss sky130_fd_pr__nfet_01v8 L=0.5u W=1u
M3234 o5 ibias vss vss sky130_fd_pr__nfet_01v8 L=0.5u W=1u
M3235 o5 ibias vss vss sky130_fd_pr__nfet_01v8 L=0.5u W=1u
M3236 o5 ibias vss vss sky130_fd_pr__nfet_01v8 L=0.5u W=1u
M3237 o5 ibias vss vss sky130_fd_pr__nfet_01v8 L=0.5u W=1u
M3238 o5 ibias vss vss sky130_fd_pr__nfet_01v8 L=0.5u W=1u
M3239 o5 ibias vss vss sky130_fd_pr__nfet_01v8 L=0.5u W=1u
M3240 o5 ibias vss vss sky130_fd_pr__nfet_01v8 L=0.5u W=1u
M3241 o5 ibias vss vss sky130_fd_pr__nfet_01v8 L=0.5u W=1u
M3242 o5 ibias vss vss sky130_fd_pr__nfet_01v8 L=0.5u W=1u
M3243 o5 ibias vss vss sky130_fd_pr__nfet_01v8 L=0.5u W=1u
M3244 o5 ibias vss vss sky130_fd_pr__nfet_01v8 L=0.5u W=1u
M3245 o5 ibias vss vss sky130_fd_pr__nfet_01v8 L=0.5u W=1u
M3246 o5 ibias vss vss sky130_fd_pr__nfet_01v8 L=0.5u W=1u
M3247 o5 ibias vss vss sky130_fd_pr__nfet_01v8 L=0.5u W=1u
M3248 o5 ibias vss vss sky130_fd_pr__nfet_01v8 L=0.5u W=1u
M3249 o5 ibias vss vss sky130_fd_pr__nfet_01v8 L=0.5u W=1u
M3250 o5 ibias vss vss sky130_fd_pr__nfet_01v8 L=0.5u W=1u
M3251 o5 ibias vss vss sky130_fd_pr__nfet_01v8 L=0.5u W=1u
M3252 o5 ibias vss vss sky130_fd_pr__nfet_01v8 L=0.5u W=1u
M3253 o5 ibias vss vss sky130_fd_pr__nfet_01v8 L=0.5u W=1u
M3254 o5 ibias vss vss sky130_fd_pr__nfet_01v8 L=0.5u W=1u
M3255 o5 ibias vss vss sky130_fd_pr__nfet_01v8 L=0.5u W=1u
M3256 o5 ibias vss vss sky130_fd_pr__nfet_01v8 L=0.5u W=1u
M3257 o5 ibias vss vss sky130_fd_pr__nfet_01v8 L=0.5u W=1u
M3258 o5 ibias vss vss sky130_fd_pr__nfet_01v8 L=0.5u W=1u
M3259 o5 ibias vss vss sky130_fd_pr__nfet_01v8 L=0.5u W=1u
M3260 o5 ibias vss vss sky130_fd_pr__nfet_01v8 L=0.5u W=1u
M3261 o5 ibias vss vss sky130_fd_pr__nfet_01v8 L=0.5u W=1u
M3262 o5 ibias vss vss sky130_fd_pr__nfet_01v8 L=0.5u W=1u
M3263 o5 ibias vss vss sky130_fd_pr__nfet_01v8 L=0.5u W=1u
M3264 o5 ibias vss vss sky130_fd_pr__nfet_01v8 L=0.5u W=1u
M3265 o5 ibias vss vss sky130_fd_pr__nfet_01v8 L=0.5u W=1u
M3266 o5 ibias vss vss sky130_fd_pr__nfet_01v8 L=0.5u W=1u
M3267 o5 ibias vss vss sky130_fd_pr__nfet_01v8 L=0.5u W=1u
M3268 o5 ibias vss vss sky130_fd_pr__nfet_01v8 L=0.5u W=1u
M3269 o5 ibias vss vss sky130_fd_pr__nfet_01v8 L=0.5u W=1u
M3270 o5 ibias vss vss sky130_fd_pr__nfet_01v8 L=0.5u W=1u
M3271 o5 ibias vss vss sky130_fd_pr__nfet_01v8 L=0.5u W=1u
M3272 o5 ibias vss vss sky130_fd_pr__nfet_01v8 L=0.5u W=1u
M3273 o5 ibias vss vss sky130_fd_pr__nfet_01v8 L=0.5u W=1u
M3274 o5 ibias vss vss sky130_fd_pr__nfet_01v8 L=0.5u W=1u
M3275 o5 ibias vss vss sky130_fd_pr__nfet_01v8 L=0.5u W=1u
M3276 o5 ibias vss vss sky130_fd_pr__nfet_01v8 L=0.5u W=1u
M3277 o5 ibias vss vss sky130_fd_pr__nfet_01v8 L=0.5u W=1u
M3278 o5 ibias vss vss sky130_fd_pr__nfet_01v8 L=0.5u W=1u
M3279 o5 ibias vss vss sky130_fd_pr__nfet_01v8 L=0.5u W=1u
M3280 o5 ibias vss vss sky130_fd_pr__nfet_01v8 L=0.5u W=1u
M3281 o5 ibias vss vss sky130_fd_pr__nfet_01v8 L=0.5u W=1u
M3282 o5 ibias vss vss sky130_fd_pr__nfet_01v8 L=0.5u W=1u
M3283 o5 ibias vss vss sky130_fd_pr__nfet_01v8 L=0.5u W=1u
M3284 o5 ibias vss vss sky130_fd_pr__nfet_01v8 L=0.5u W=1u
M3285 o5 ibias vss vss sky130_fd_pr__nfet_01v8 L=0.5u W=1u
M3286 o5 ibias vss vss sky130_fd_pr__nfet_01v8 L=0.5u W=1u
M3287 o5 ibias vss vss sky130_fd_pr__nfet_01v8 L=0.5u W=1u
M3288 o5 ibias vss vss sky130_fd_pr__nfet_01v8 L=0.5u W=1u
M3289 o5 ibias vss vss sky130_fd_pr__nfet_01v8 L=0.5u W=1u
M3290 o5 ibias vss vss sky130_fd_pr__nfet_01v8 L=0.5u W=1u
M3291 o5 ibias vss vss sky130_fd_pr__nfet_01v8 L=0.5u W=1u
M3292 o5 ibias vss vss sky130_fd_pr__nfet_01v8 L=0.5u W=1u
M3293 o5 ibias vss vss sky130_fd_pr__nfet_01v8 L=0.5u W=1u
M3294 o5 ibias vss vss sky130_fd_pr__nfet_01v8 L=0.5u W=1u
M3295 o5 ibias vss vss sky130_fd_pr__nfet_01v8 L=0.5u W=1u
M3296 o5 ibias vss vss sky130_fd_pr__nfet_01v8 L=0.5u W=1u
M3297 o5 ibias vss vss sky130_fd_pr__nfet_01v8 L=0.5u W=1u
M3298 o5 ibias vss vss sky130_fd_pr__nfet_01v8 L=0.5u W=1u
M3299 o5 ibias vss vss sky130_fd_pr__nfet_01v8 L=0.5u W=1u
M3300 o5 ibias vss vss sky130_fd_pr__nfet_01v8 L=0.5u W=1u
M3301 o5 ibias vss vss sky130_fd_pr__nfet_01v8 L=0.5u W=1u
M3302 o5 ibias vss vss sky130_fd_pr__nfet_01v8 L=0.5u W=1u
M3303 o5 ibias vss vss sky130_fd_pr__nfet_01v8 L=0.5u W=1u
M3304 o5 ibias vss vss sky130_fd_pr__nfet_01v8 L=0.5u W=1u
M3305 o5 ibias vss vss sky130_fd_pr__nfet_01v8 L=0.5u W=1u
M3306 o5 ibias vss vss sky130_fd_pr__nfet_01v8 L=0.5u W=1u
M3307 o5 ibias vss vss sky130_fd_pr__nfet_01v8 L=0.5u W=1u
M3308 o5 ibias vss vss sky130_fd_pr__nfet_01v8 L=0.5u W=1u
M3309 o5 ibias vss vss sky130_fd_pr__nfet_01v8 L=0.5u W=1u
M3310 o5 ibias vss vss sky130_fd_pr__nfet_01v8 L=0.5u W=1u
M3311 o5 ibias vss vss sky130_fd_pr__nfet_01v8 L=0.5u W=1u
M3312 o5 ibias vss vss sky130_fd_pr__nfet_01v8 L=0.5u W=1u
M3313 o5 ibias vss vss sky130_fd_pr__nfet_01v8 L=0.5u W=1u
M3314 o5 ibias vss vss sky130_fd_pr__nfet_01v8 L=0.5u W=1u
M3315 o5 ibias vss vss sky130_fd_pr__nfet_01v8 L=0.5u W=1u
M3316 o5 ibias vss vss sky130_fd_pr__nfet_01v8 L=0.5u W=1u
M3317 o5 ibias vss vss sky130_fd_pr__nfet_01v8 L=0.5u W=1u
M3318 o5 ibias vss vss sky130_fd_pr__nfet_01v8 L=0.5u W=1u
M3319 o5 ibias vss vss sky130_fd_pr__nfet_01v8 L=0.5u W=1u
M3320 o5 ibias vss vss sky130_fd_pr__nfet_01v8 L=0.5u W=1u
M3321 o5 ibias vss vss sky130_fd_pr__nfet_01v8 L=0.5u W=1u
M3322 o5 ibias vss vss sky130_fd_pr__nfet_01v8 L=0.5u W=1u
M3323 o5 ibias vss vss sky130_fd_pr__nfet_01v8 L=0.5u W=1u
M3324 o5 ibias vss vss sky130_fd_pr__nfet_01v8 L=0.5u W=1u
M3325 o5 ibias vss vss sky130_fd_pr__nfet_01v8 L=0.5u W=1u
M3326 o5 ibias vss vss sky130_fd_pr__nfet_01v8 L=0.5u W=1u
M3327 o5 ibias vss vss sky130_fd_pr__nfet_01v8 L=0.5u W=1u
M3328 o5 ibias vss vss sky130_fd_pr__nfet_01v8 L=0.5u W=1u
M3329 o5 ibias vss vss sky130_fd_pr__nfet_01v8 L=0.5u W=1u
M3330 o5 ibias vss vss sky130_fd_pr__nfet_01v8 L=0.5u W=1u
M3331 o5 ibias vss vss sky130_fd_pr__nfet_01v8 L=0.5u W=1u
M3332 o5 ibias vss vss sky130_fd_pr__nfet_01v8 L=0.5u W=1u
M3333 o5 ibias vss vss sky130_fd_pr__nfet_01v8 L=0.5u W=1u
M3334 o5 ibias vss vss sky130_fd_pr__nfet_01v8 L=0.5u W=1u
M3335 o5 ibias vss vss sky130_fd_pr__nfet_01v8 L=0.5u W=1u
M3336 o5 ibias vss vss sky130_fd_pr__nfet_01v8 L=0.5u W=1u
M3337 o5 ibias vss vss sky130_fd_pr__nfet_01v8 L=0.5u W=1u
M3338 o5 ibias vss vss sky130_fd_pr__nfet_01v8 L=0.5u W=1u
M3339 o5 ibias vss vss sky130_fd_pr__nfet_01v8 L=0.5u W=1u
M3340 o5 ibias vss vss sky130_fd_pr__nfet_01v8 L=0.5u W=1u
M3341 o5 ibias vss vss sky130_fd_pr__nfet_01v8 L=0.5u W=1u
M3342 o5 ibias vss vss sky130_fd_pr__nfet_01v8 L=0.5u W=1u
M3343 o5 ibias vss vss sky130_fd_pr__nfet_01v8 L=0.5u W=1u
M3344 o5 ibias vss vss sky130_fd_pr__nfet_01v8 L=0.5u W=1u
M3345 o5 ibias vss vss sky130_fd_pr__nfet_01v8 L=0.5u W=1u
M3346 o5 ibias vss vss sky130_fd_pr__nfet_01v8 L=0.5u W=1u
M3347 o5 ibias vss vss sky130_fd_pr__nfet_01v8 L=0.5u W=1u
M3348 o5 ibias vss vss sky130_fd_pr__nfet_01v8 L=0.5u W=1u
M3349 o5 ibias vss vss sky130_fd_pr__nfet_01v8 L=0.5u W=1u
M3350 o5 ibias vss vss sky130_fd_pr__nfet_01v8 L=0.5u W=1u
M3351 o5 ibias vss vss sky130_fd_pr__nfet_01v8 L=0.5u W=1u
M3352 o5 ibias vss vss sky130_fd_pr__nfet_01v8 L=0.5u W=1u
M3353 o5 ibias vss vss sky130_fd_pr__nfet_01v8 L=0.5u W=1u
M3354 o5 ibias vss vss sky130_fd_pr__nfet_01v8 L=0.5u W=1u
M3355 o5 ibias vss vss sky130_fd_pr__nfet_01v8 L=0.5u W=1u
M3356 o5 ibias vss vss sky130_fd_pr__nfet_01v8 L=0.5u W=1u
M3357 o5 ibias vss vss sky130_fd_pr__nfet_01v8 L=0.5u W=1u
M3358 o5 ibias vss vss sky130_fd_pr__nfet_01v8 L=0.5u W=1u
M3359 o5 ibias vss vss sky130_fd_pr__nfet_01v8 L=0.5u W=1u
M3360 o5 ibias vss vss sky130_fd_pr__nfet_01v8 L=0.5u W=1u
M3361 o5 ibias vss vss sky130_fd_pr__nfet_01v8 L=0.5u W=1u
M3362 o5 ibias vss vss sky130_fd_pr__nfet_01v8 L=0.5u W=1u
M3363 o5 ibias vss vss sky130_fd_pr__nfet_01v8 L=0.5u W=1u
M3364 o5 ibias vss vss sky130_fd_pr__nfet_01v8 L=0.5u W=1u
M3365 o5 ibias vss vss sky130_fd_pr__nfet_01v8 L=0.5u W=1u
M3366 o5 ibias vss vss sky130_fd_pr__nfet_01v8 L=0.5u W=1u
M3367 o5 ibias vss vss sky130_fd_pr__nfet_01v8 L=0.5u W=1u
M3368 o5 ibias vss vss sky130_fd_pr__nfet_01v8 L=0.5u W=1u
M3369 o5 ibias vss vss sky130_fd_pr__nfet_01v8 L=0.5u W=1u
M3370 o5 ibias vss vss sky130_fd_pr__nfet_01v8 L=0.5u W=1u
M3371 o5 ibias vss vss sky130_fd_pr__nfet_01v8 L=0.5u W=1u
M3372 o5 ibias vss vss sky130_fd_pr__nfet_01v8 L=0.5u W=1u
M3373 o5 ibias vss vss sky130_fd_pr__nfet_01v8 L=0.5u W=1u
M3374 o5 ibias vss vss sky130_fd_pr__nfet_01v8 L=0.5u W=1u
M3375 o5 ibias vss vss sky130_fd_pr__nfet_01v8 L=0.5u W=1u
M3376 o5 ibias vss vss sky130_fd_pr__nfet_01v8 L=0.5u W=1u
M3377 o5 ibias vss vss sky130_fd_pr__nfet_01v8 L=0.5u W=1u
M3378 o5 ibias vss vss sky130_fd_pr__nfet_01v8 L=0.5u W=1u
M3379 o5 ibias vss vss sky130_fd_pr__nfet_01v8 L=0.5u W=1u
M3380 o5 ibias vss vss sky130_fd_pr__nfet_01v8 L=0.5u W=1u
M3381 o5 ibias vss vss sky130_fd_pr__nfet_01v8 L=0.5u W=1u
M3382 o5 ibias vss vss sky130_fd_pr__nfet_01v8 L=0.5u W=1u
M3383 o5 ibias vss vss sky130_fd_pr__nfet_01v8 L=0.5u W=1u
M3384 o5 ibias vss vss sky130_fd_pr__nfet_01v8 L=0.5u W=1u
M3385 o5 ibias vss vss sky130_fd_pr__nfet_01v8 L=0.5u W=1u
M3386 o5 ibias vss vss sky130_fd_pr__nfet_01v8 L=0.5u W=1u
M3387 o5 ibias vss vss sky130_fd_pr__nfet_01v8 L=0.5u W=1u
M3388 o5 ibias vss vss sky130_fd_pr__nfet_01v8 L=0.5u W=1u
M3389 o5 ibias vss vss sky130_fd_pr__nfet_01v8 L=0.5u W=1u
M3390 o5 ibias vss vss sky130_fd_pr__nfet_01v8 L=0.5u W=1u
M3391 o5 ibias vss vss sky130_fd_pr__nfet_01v8 L=0.5u W=1u
M3392 o5 ibias vss vss sky130_fd_pr__nfet_01v8 L=0.5u W=1u
M3393 o5 ibias vss vss sky130_fd_pr__nfet_01v8 L=0.5u W=1u
M3394 o5 ibias vss vss sky130_fd_pr__nfet_01v8 L=0.5u W=1u
M3395 o5 ibias vss vss sky130_fd_pr__nfet_01v8 L=0.5u W=1u
M3396 o5 ibias vss vss sky130_fd_pr__nfet_01v8 L=0.5u W=1u
M3397 o5 ibias vss vss sky130_fd_pr__nfet_01v8 L=0.5u W=1u
M3398 o5 ibias vss vss sky130_fd_pr__nfet_01v8 L=0.5u W=1u
M3399 o5 ibias vss vss sky130_fd_pr__nfet_01v8 L=0.5u W=1u
M3400 o5 ibias vss vss sky130_fd_pr__nfet_01v8 L=0.5u W=1u
M3401 o5 ibias vss vss sky130_fd_pr__nfet_01v8 L=0.5u W=1u
M3402 o5 ibias vss vss sky130_fd_pr__nfet_01v8 L=0.5u W=1u
M3403 o5 ibias vss vss sky130_fd_pr__nfet_01v8 L=0.5u W=1u
M3404 o5 ibias vss vss sky130_fd_pr__nfet_01v8 L=0.5u W=1u
M3405 o5 ibias vss vss sky130_fd_pr__nfet_01v8 L=0.5u W=1u
M3406 o5 ibias vss vss sky130_fd_pr__nfet_01v8 L=0.5u W=1u
M3407 o5 ibias vss vss sky130_fd_pr__nfet_01v8 L=0.5u W=1u
M3408 o5 ibias vss vss sky130_fd_pr__nfet_01v8 L=0.5u W=1u
M3409 o5 ibias vss vss sky130_fd_pr__nfet_01v8 L=0.5u W=1u
M3410 o5 ibias vss vss sky130_fd_pr__nfet_01v8 L=0.5u W=1u
M3411 o5 ibias vss vss sky130_fd_pr__nfet_01v8 L=0.5u W=1u
M3412 o5 ibias vss vss sky130_fd_pr__nfet_01v8 L=0.5u W=1u
M3413 o5 ibias vss vss sky130_fd_pr__nfet_01v8 L=0.5u W=1u
M3414 o5 ibias vss vss sky130_fd_pr__nfet_01v8 L=0.5u W=1u
M3415 o5 ibias vss vss sky130_fd_pr__nfet_01v8 L=0.5u W=1u
M3416 o5 ibias vss vss sky130_fd_pr__nfet_01v8 L=0.5u W=1u
M3417 o5 ibias vss vss sky130_fd_pr__nfet_01v8 L=0.5u W=1u
M3418 o5 ibias vss vss sky130_fd_pr__nfet_01v8 L=0.5u W=1u
M3419 o5 ibias vss vss sky130_fd_pr__nfet_01v8 L=0.5u W=1u
M3420 o5 ibias vss vss sky130_fd_pr__nfet_01v8 L=0.5u W=1u
M3421 o5 ibias vss vss sky130_fd_pr__nfet_01v8 L=0.5u W=1u
M3422 o5 ibias vss vss sky130_fd_pr__nfet_01v8 L=0.5u W=1u
M3423 o5 ibias vss vss sky130_fd_pr__nfet_01v8 L=0.5u W=1u
M3424 o5 ibias vss vss sky130_fd_pr__nfet_01v8 L=0.5u W=1u
M3425 o5 ibias vss vss sky130_fd_pr__nfet_01v8 L=0.5u W=1u
M3426 o5 ibias vss vss sky130_fd_pr__nfet_01v8 L=0.5u W=1u
M3427 o5 ibias vss vss sky130_fd_pr__nfet_01v8 L=0.5u W=1u
M3428 o5 ibias vss vss sky130_fd_pr__nfet_01v8 L=0.5u W=1u
M3429 o5 ibias vss vss sky130_fd_pr__nfet_01v8 L=0.5u W=1u
M3430 o5 ibias vss vss sky130_fd_pr__nfet_01v8 L=0.5u W=1u
M3431 o5 ibias vss vss sky130_fd_pr__nfet_01v8 L=0.5u W=1u
M3432 o5 ibias vss vss sky130_fd_pr__nfet_01v8 L=0.5u W=1u
M3433 o5 ibias vss vss sky130_fd_pr__nfet_01v8 L=0.5u W=1u
M3434 o5 ibias vss vss sky130_fd_pr__nfet_01v8 L=0.5u W=1u
M3435 o5 ibias vss vss sky130_fd_pr__nfet_01v8 L=0.5u W=1u
M3436 o5 ibias vss vss sky130_fd_pr__nfet_01v8 L=0.5u W=1u
M3437 o5 ibias vss vss sky130_fd_pr__nfet_01v8 L=0.5u W=1u
M3438 o5 ibias vss vss sky130_fd_pr__nfet_01v8 L=0.5u W=1u
M3439 o5 ibias vss vss sky130_fd_pr__nfet_01v8 L=0.5u W=1u
M3440 o5 ibias vss vss sky130_fd_pr__nfet_01v8 L=0.5u W=1u
M3441 o5 ibias vss vss sky130_fd_pr__nfet_01v8 L=0.5u W=1u
M3442 o5 ibias vss vss sky130_fd_pr__nfet_01v8 L=0.5u W=1u
M3443 o5 ibias vss vss sky130_fd_pr__nfet_01v8 L=0.5u W=1u
M3444 o5 ibias vss vss sky130_fd_pr__nfet_01v8 L=0.5u W=1u
M3445 o5 ibias vss vss sky130_fd_pr__nfet_01v8 L=0.5u W=1u
M3446 o5 ibias vss vss sky130_fd_pr__nfet_01v8 L=0.5u W=1u
M3447 o5 ibias vss vss sky130_fd_pr__nfet_01v8 L=0.5u W=1u
M3448 o5 ibias vss vss sky130_fd_pr__nfet_01v8 L=0.5u W=1u
M3449 o5 ibias vss vss sky130_fd_pr__nfet_01v8 L=0.5u W=1u
M3450 o5 ibias vss vss sky130_fd_pr__nfet_01v8 L=0.5u W=1u
M3451 o5 ibias vss vss sky130_fd_pr__nfet_01v8 L=0.5u W=1u
M3452 o5 ibias vss vss sky130_fd_pr__nfet_01v8 L=0.5u W=1u
M3453 o5 ibias vss vss sky130_fd_pr__nfet_01v8 L=0.5u W=1u
M3454 o5 ibias vss vss sky130_fd_pr__nfet_01v8 L=0.5u W=1u
M3455 o5 ibias vss vss sky130_fd_pr__nfet_01v8 L=0.5u W=1u
M3456 o5 ibias vss vss sky130_fd_pr__nfet_01v8 L=0.5u W=1u
M3457 o5 ibias vss vss sky130_fd_pr__nfet_01v8 L=0.5u W=1u
M3458 o5 ibias vss vss sky130_fd_pr__nfet_01v8 L=0.5u W=1u
M3459 o5 ibias vss vss sky130_fd_pr__nfet_01v8 L=0.5u W=1u
M3460 o5 ibias vss vss sky130_fd_pr__nfet_01v8 L=0.5u W=1u
M3461 o5 ibias vss vss sky130_fd_pr__nfet_01v8 L=0.5u W=1u
M3462 o5 ibias vss vss sky130_fd_pr__nfet_01v8 L=0.5u W=1u
M3463 o5 ibias vss vss sky130_fd_pr__nfet_01v8 L=0.5u W=1u
M3464 o5 ibias vss vss sky130_fd_pr__nfet_01v8 L=0.5u W=1u
M3465 o5 ibias vss vss sky130_fd_pr__nfet_01v8 L=0.5u W=1u
M3466 o5 ibias vss vss sky130_fd_pr__nfet_01v8 L=0.5u W=1u
M3467 o5 ibias vss vss sky130_fd_pr__nfet_01v8 L=0.5u W=1u
M3468 o5 ibias vss vss sky130_fd_pr__nfet_01v8 L=0.5u W=1u
M3469 o5 ibias vss vss sky130_fd_pr__nfet_01v8 L=0.5u W=1u
M3470 o5 ibias vss vss sky130_fd_pr__nfet_01v8 L=0.5u W=1u
M3471 o5 ibias vss vss sky130_fd_pr__nfet_01v8 L=0.5u W=1u
M3472 o5 ibias vss vss sky130_fd_pr__nfet_01v8 L=0.5u W=1u
M3473 o5 ibias vss vss sky130_fd_pr__nfet_01v8 L=0.5u W=1u
M3474 o5 ibias vss vss sky130_fd_pr__nfet_01v8 L=0.5u W=1u
M3475 o5 ibias vss vss sky130_fd_pr__nfet_01v8 L=0.5u W=1u
M3476 o5 ibias vss vss sky130_fd_pr__nfet_01v8 L=0.5u W=1u
M3477 o5 ibias vss vss sky130_fd_pr__nfet_01v8 L=0.5u W=1u
M3478 o5 ibias vss vss sky130_fd_pr__nfet_01v8 L=0.5u W=1u
M3479 o5 ibias vss vss sky130_fd_pr__nfet_01v8 L=0.5u W=1u
M3480 o5 ibias vss vss sky130_fd_pr__nfet_01v8 L=0.5u W=1u
M3481 o5 ibias vss vss sky130_fd_pr__nfet_01v8 L=0.5u W=1u
M3482 o5 ibias vss vss sky130_fd_pr__nfet_01v8 L=0.5u W=1u
M3483 o5 ibias vss vss sky130_fd_pr__nfet_01v8 L=0.5u W=1u
M3484 o5 ibias vss vss sky130_fd_pr__nfet_01v8 L=0.5u W=1u
M3485 o5 ibias vss vss sky130_fd_pr__nfet_01v8 L=0.5u W=1u
M3486 o5 ibias vss vss sky130_fd_pr__nfet_01v8 L=0.5u W=1u
M3487 o5 ibias vss vss sky130_fd_pr__nfet_01v8 L=0.5u W=1u
M3488 o5 ibias vss vss sky130_fd_pr__nfet_01v8 L=0.5u W=1u
M3489 o5 ibias vss vss sky130_fd_pr__nfet_01v8 L=0.5u W=1u
M3490 o5 ibias vss vss sky130_fd_pr__nfet_01v8 L=0.5u W=1u
M3491 o5 ibias vss vss sky130_fd_pr__nfet_01v8 L=0.5u W=1u
M3492 o5 ibias vss vss sky130_fd_pr__nfet_01v8 L=0.5u W=1u
M3493 o5 ibias vss vss sky130_fd_pr__nfet_01v8 L=0.5u W=1u
M3494 o5 ibias vss vss sky130_fd_pr__nfet_01v8 L=0.5u W=1u
M3495 o5 ibias vss vss sky130_fd_pr__nfet_01v8 L=0.5u W=1u
M3496 o5 ibias vss vss sky130_fd_pr__nfet_01v8 L=0.5u W=1u
M3497 o5 ibias vss vss sky130_fd_pr__nfet_01v8 L=0.5u W=1u
M3498 o5 ibias vss vss sky130_fd_pr__nfet_01v8 L=0.5u W=1u
M3499 o5 ibias vss vss sky130_fd_pr__nfet_01v8 L=0.5u W=1u
M3500 o5 ibias vss vss sky130_fd_pr__nfet_01v8 L=0.5u W=1u
M3501 o5 ibias vss vss sky130_fd_pr__nfet_01v8 L=0.5u W=1u
M3502 o5 ibias vss vss sky130_fd_pr__nfet_01v8 L=0.5u W=1u
M3503 o5 ibias vss vss sky130_fd_pr__nfet_01v8 L=0.5u W=1u
M3504 o5 ibias vss vss sky130_fd_pr__nfet_01v8 L=0.5u W=1u
M3505 o5 ibias vss vss sky130_fd_pr__nfet_01v8 L=0.5u W=1u
M3506 o5 ibias vss vss sky130_fd_pr__nfet_01v8 L=0.5u W=1u
M3507 o5 ibias vss vss sky130_fd_pr__nfet_01v8 L=0.5u W=1u
M3508 o5 ibias vss vss sky130_fd_pr__nfet_01v8 L=0.5u W=1u
M3509 o5 ibias vss vss sky130_fd_pr__nfet_01v8 L=0.5u W=1u
M3510 o5 ibias vss vss sky130_fd_pr__nfet_01v8 L=0.5u W=1u
M3511 o5 ibias vss vss sky130_fd_pr__nfet_01v8 L=0.5u W=1u
M3512 o5 ibias vss vss sky130_fd_pr__nfet_01v8 L=0.5u W=1u
M3513 o5 ibias vss vss sky130_fd_pr__nfet_01v8 L=0.5u W=1u
M3514 o5 ibias vss vss sky130_fd_pr__nfet_01v8 L=0.5u W=1u
M3515 o5 ibias vss vss sky130_fd_pr__nfet_01v8 L=0.5u W=1u
M3516 o5 ibias vss vss sky130_fd_pr__nfet_01v8 L=0.5u W=1u
M3517 o5 ibias vss vss sky130_fd_pr__nfet_01v8 L=0.5u W=1u
M3518 o5 ibias vss vss sky130_fd_pr__nfet_01v8 L=0.5u W=1u
M3519 o5 ibias vss vss sky130_fd_pr__nfet_01v8 L=0.5u W=1u
M3520 o5 ibias vss vss sky130_fd_pr__nfet_01v8 L=0.5u W=1u
M3521 o5 ibias vss vss sky130_fd_pr__nfet_01v8 L=0.5u W=1u
M3522 o5 ibias vss vss sky130_fd_pr__nfet_01v8 L=0.5u W=1u
M3523 o5 ibias vss vss sky130_fd_pr__nfet_01v8 L=0.5u W=1u
M3524 o5 ibias vss vss sky130_fd_pr__nfet_01v8 L=0.5u W=1u
M3525 o5 ibias vss vss sky130_fd_pr__nfet_01v8 L=0.5u W=1u
M3526 o5 ibias vss vss sky130_fd_pr__nfet_01v8 L=0.5u W=1u
M3527 o5 ibias vss vss sky130_fd_pr__nfet_01v8 L=0.5u W=1u
M3528 o5 ibias vss vss sky130_fd_pr__nfet_01v8 L=0.5u W=1u
M3529 o5 ibias vss vss sky130_fd_pr__nfet_01v8 L=0.5u W=1u
M3530 o5 ibias vss vss sky130_fd_pr__nfet_01v8 L=0.5u W=1u
M3531 o5 ibias vss vss sky130_fd_pr__nfet_01v8 L=0.5u W=1u
M3532 o5 ibias vss vss sky130_fd_pr__nfet_01v8 L=0.5u W=1u
M3533 o5 ibias vss vss sky130_fd_pr__nfet_01v8 L=0.5u W=1u
M3534 o5 ibias vss vss sky130_fd_pr__nfet_01v8 L=0.5u W=1u
M3535 o5 ibias vss vss sky130_fd_pr__nfet_01v8 L=0.5u W=1u
M3536 o5 ibias vss vss sky130_fd_pr__nfet_01v8 L=0.5u W=1u
M3537 o5 ibias vss vss sky130_fd_pr__nfet_01v8 L=0.5u W=1u
M3538 o5 ibias vss vss sky130_fd_pr__nfet_01v8 L=0.5u W=1u
M3539 o5 ibias vss vss sky130_fd_pr__nfet_01v8 L=0.5u W=1u
M3540 o5 ibias vss vss sky130_fd_pr__nfet_01v8 L=0.5u W=1u
M3541 o5 ibias vss vss sky130_fd_pr__nfet_01v8 L=0.5u W=1u
M3542 o5 ibias vss vss sky130_fd_pr__nfet_01v8 L=0.5u W=1u
M3543 o5 ibias vss vss sky130_fd_pr__nfet_01v8 L=0.5u W=1u
M3544 o5 ibias vss vss sky130_fd_pr__nfet_01v8 L=0.5u W=1u
M3545 o5 ibias vss vss sky130_fd_pr__nfet_01v8 L=0.5u W=1u
M3546 o5 ibias vss vss sky130_fd_pr__nfet_01v8 L=0.5u W=1u
M3547 o5 ibias vss vss sky130_fd_pr__nfet_01v8 L=0.5u W=1u
M3548 o5 ibias vss vss sky130_fd_pr__nfet_01v8 L=0.5u W=1u
M3549 o5 ibias vss vss sky130_fd_pr__nfet_01v8 L=0.5u W=1u
M3550 o5 ibias vss vss sky130_fd_pr__nfet_01v8 L=0.5u W=1u
M3551 o5 ibias vss vss sky130_fd_pr__nfet_01v8 L=0.5u W=1u
M3552 o5 ibias vss vss sky130_fd_pr__nfet_01v8 L=0.5u W=1u
M3553 o5 ibias vss vss sky130_fd_pr__nfet_01v8 L=0.5u W=1u
M3554 o5 ibias vss vss sky130_fd_pr__nfet_01v8 L=0.5u W=1u
M3555 o5 ibias vss vss sky130_fd_pr__nfet_01v8 L=0.5u W=1u
M3556 o5 ibias vss vss sky130_fd_pr__nfet_01v8 L=0.5u W=1u
M3557 o5 ibias vss vss sky130_fd_pr__nfet_01v8 L=0.5u W=1u
M3558 o5 ibias vss vss sky130_fd_pr__nfet_01v8 L=0.5u W=1u
M3559 o5 ibias vss vss sky130_fd_pr__nfet_01v8 L=0.5u W=1u
M3560 o5 ibias vss vss sky130_fd_pr__nfet_01v8 L=0.5u W=1u
M3561 o5 ibias vss vss sky130_fd_pr__nfet_01v8 L=0.5u W=1u
M3562 o5 ibias vss vss sky130_fd_pr__nfet_01v8 L=0.5u W=1u
M3563 o5 ibias vss vss sky130_fd_pr__nfet_01v8 L=0.5u W=1u
M3564 o5 ibias vss vss sky130_fd_pr__nfet_01v8 L=0.5u W=1u
M3565 o5 ibias vss vss sky130_fd_pr__nfet_01v8 L=0.5u W=1u
M3566 o5 ibias vss vss sky130_fd_pr__nfet_01v8 L=0.5u W=1u
M3567 o5 ibias vss vss sky130_fd_pr__nfet_01v8 L=0.5u W=1u
M3568 o5 ibias vss vss sky130_fd_pr__nfet_01v8 L=0.5u W=1u
M3569 o5 ibias vss vss sky130_fd_pr__nfet_01v8 L=0.5u W=1u
M3570 o5 ibias vss vss sky130_fd_pr__nfet_01v8 L=0.5u W=1u
M3571 o5 ibias vss vss sky130_fd_pr__nfet_01v8 L=0.5u W=1u
M3572 o5 ibias vss vss sky130_fd_pr__nfet_01v8 L=0.5u W=1u
M3573 o5 ibias vss vss sky130_fd_pr__nfet_01v8 L=0.5u W=1u
M3574 o5 ibias vss vss sky130_fd_pr__nfet_01v8 L=0.5u W=1u
M3575 o5 ibias vss vss sky130_fd_pr__nfet_01v8 L=0.5u W=1u
M3576 o5 ibias vss vss sky130_fd_pr__nfet_01v8 L=0.5u W=1u
M3577 o5 ibias vss vss sky130_fd_pr__nfet_01v8 L=0.5u W=1u
M3578 o5 ibias vss vss sky130_fd_pr__nfet_01v8 L=0.5u W=1u
M3579 o5 ibias vss vss sky130_fd_pr__nfet_01v8 L=0.5u W=1u
M3580 o5 ibias vss vss sky130_fd_pr__nfet_01v8 L=0.5u W=1u
M3581 o5 ibias vss vss sky130_fd_pr__nfet_01v8 L=0.5u W=1u
M3582 o5 ibias vss vss sky130_fd_pr__nfet_01v8 L=0.5u W=1u
M3583 o5 ibias vss vss sky130_fd_pr__nfet_01v8 L=0.5u W=1u
M3584 o5 ibias vss vss sky130_fd_pr__nfet_01v8 L=0.5u W=1u
M3585 o5 ibias vss vss sky130_fd_pr__nfet_01v8 L=0.5u W=1u
M3586 o5 ibias vss vss sky130_fd_pr__nfet_01v8 L=0.5u W=1u
M3587 o5 ibias vss vss sky130_fd_pr__nfet_01v8 L=0.5u W=1u
M3588 o5 ibias vss vss sky130_fd_pr__nfet_01v8 L=0.5u W=1u
M3589 o5 ibias vss vss sky130_fd_pr__nfet_01v8 L=0.5u W=1u
M3590 o5 ibias vss vss sky130_fd_pr__nfet_01v8 L=0.5u W=1u
M3591 o5 ibias vss vss sky130_fd_pr__nfet_01v8 L=0.5u W=1u
M3592 o5 ibias vss vss sky130_fd_pr__nfet_01v8 L=0.5u W=1u
M3593 o5 ibias vss vss sky130_fd_pr__nfet_01v8 L=0.5u W=1u
M3594 o5 ibias vss vss sky130_fd_pr__nfet_01v8 L=0.5u W=1u
M3595 o5 ibias vss vss sky130_fd_pr__nfet_01v8 L=0.5u W=1u
M3596 o5 ibias vss vss sky130_fd_pr__nfet_01v8 L=0.5u W=1u
M3597 o5 ibias vss vss sky130_fd_pr__nfet_01v8 L=0.5u W=1u
M3598 o5 ibias vss vss sky130_fd_pr__nfet_01v8 L=0.5u W=1u
M3599 o5 ibias vss vss sky130_fd_pr__nfet_01v8 L=0.5u W=1u
M3600 o5 ibias vss vss sky130_fd_pr__nfet_01v8 L=0.5u W=1u
M3601 o5 ibias vss vss sky130_fd_pr__nfet_01v8 L=0.5u W=1u
M3602 o5 ibias vss vss sky130_fd_pr__nfet_01v8 L=0.5u W=1u
M3603 o5 ibias vss vss sky130_fd_pr__nfet_01v8 L=0.5u W=1u
M3604 o5 ibias vss vss sky130_fd_pr__nfet_01v8 L=0.5u W=1u
M3605 o5 ibias vss vss sky130_fd_pr__nfet_01v8 L=0.5u W=1u
M3606 o5 ibias vss vss sky130_fd_pr__nfet_01v8 L=0.5u W=1u
M3607 o5 ibias vss vss sky130_fd_pr__nfet_01v8 L=0.5u W=1u
M3608 o5 ibias vss vss sky130_fd_pr__nfet_01v8 L=0.5u W=1u
M3609 o5 ibias vss vss sky130_fd_pr__nfet_01v8 L=0.5u W=1u
M3610 o5 ibias vss vss sky130_fd_pr__nfet_01v8 L=0.5u W=1u
M3611 o5 ibias vss vss sky130_fd_pr__nfet_01v8 L=0.5u W=1u
M3612 o5 ibias vss vss sky130_fd_pr__nfet_01v8 L=0.5u W=1u
M3613 o5 ibias vss vss sky130_fd_pr__nfet_01v8 L=0.5u W=1u
M3614 o5 ibias vss vss sky130_fd_pr__nfet_01v8 L=0.5u W=1u
M3615 o5 ibias vss vss sky130_fd_pr__nfet_01v8 L=0.5u W=1u
M3616 o5 ibias vss vss sky130_fd_pr__nfet_01v8 L=0.5u W=1u
M3617 o5 ibias vss vss sky130_fd_pr__nfet_01v8 L=0.5u W=1u
M3618 o5 ibias vss vss sky130_fd_pr__nfet_01v8 L=0.5u W=1u
M3619 o5 ibias vss vss sky130_fd_pr__nfet_01v8 L=0.5u W=1u
M3620 o5 ibias vss vss sky130_fd_pr__nfet_01v8 L=0.5u W=1u
M3621 o5 ibias vss vss sky130_fd_pr__nfet_01v8 L=0.5u W=1u
M3622 o5 ibias vss vss sky130_fd_pr__nfet_01v8 L=0.5u W=1u
M3623 o5 ibias vss vss sky130_fd_pr__nfet_01v8 L=0.5u W=1u
M3624 o5 ibias vss vss sky130_fd_pr__nfet_01v8 L=0.5u W=1u
M3625 o5 ibias vss vss sky130_fd_pr__nfet_01v8 L=0.5u W=1u
M3626 o5 ibias vss vss sky130_fd_pr__nfet_01v8 L=0.5u W=1u
M3627 o5 ibias vss vss sky130_fd_pr__nfet_01v8 L=0.5u W=1u
M3628 o5 ibias vss vss sky130_fd_pr__nfet_01v8 L=0.5u W=1u
M3629 o5 ibias vss vss sky130_fd_pr__nfet_01v8 L=0.5u W=1u
M3630 o5 ibias vss vss sky130_fd_pr__nfet_01v8 L=0.5u W=1u
M3631 o5 ibias vss vss sky130_fd_pr__nfet_01v8 L=0.5u W=1u
M3632 o5 ibias vss vss sky130_fd_pr__nfet_01v8 L=0.5u W=1u
M3633 o5 ibias vss vss sky130_fd_pr__nfet_01v8 L=0.5u W=1u
M3634 o5 ibias vss vss sky130_fd_pr__nfet_01v8 L=0.5u W=1u
M3635 o5 ibias vss vss sky130_fd_pr__nfet_01v8 L=0.5u W=1u
M3636 o5 ibias vss vss sky130_fd_pr__nfet_01v8 L=0.5u W=1u
M3637 o5 ibias vss vss sky130_fd_pr__nfet_01v8 L=0.5u W=1u
M3638 o5 ibias vss vss sky130_fd_pr__nfet_01v8 L=0.5u W=1u
M3639 o5 ibias vss vss sky130_fd_pr__nfet_01v8 L=0.5u W=1u
M3640 o5 ibias vss vss sky130_fd_pr__nfet_01v8 L=0.5u W=1u
M3641 o5 ibias vss vss sky130_fd_pr__nfet_01v8 L=0.5u W=1u
M3642 o5 ibias vss vss sky130_fd_pr__nfet_01v8 L=0.5u W=1u
M3643 o5 ibias vss vss sky130_fd_pr__nfet_01v8 L=0.5u W=1u
M3644 o5 ibias vss vss sky130_fd_pr__nfet_01v8 L=0.5u W=1u
M3645 o5 ibias vss vss sky130_fd_pr__nfet_01v8 L=0.5u W=1u
M3646 o5 ibias vss vss sky130_fd_pr__nfet_01v8 L=0.5u W=1u
M3647 o5 ibias vss vss sky130_fd_pr__nfet_01v8 L=0.5u W=1u
M3648 o5 ibias vss vss sky130_fd_pr__nfet_01v8 L=0.5u W=1u
M3649 o5 ibias vss vss sky130_fd_pr__nfet_01v8 L=0.5u W=1u
M3650 o5 ibias vss vss sky130_fd_pr__nfet_01v8 L=0.5u W=1u
M3651 o5 ibias vss vss sky130_fd_pr__nfet_01v8 L=0.5u W=1u
M3652 o5 ibias vss vss sky130_fd_pr__nfet_01v8 L=0.5u W=1u
M3653 o5 ibias vss vss sky130_fd_pr__nfet_01v8 L=0.5u W=1u
M3654 o5 ibias vss vss sky130_fd_pr__nfet_01v8 L=0.5u W=1u
M3655 o5 ibias vss vss sky130_fd_pr__nfet_01v8 L=0.5u W=1u
M3656 o5 ibias vss vss sky130_fd_pr__nfet_01v8 L=0.5u W=1u
M3657 o5 ibias vss vss sky130_fd_pr__nfet_01v8 L=0.5u W=1u
M3658 o5 ibias vss vss sky130_fd_pr__nfet_01v8 L=0.5u W=1u
M3659 o5 ibias vss vss sky130_fd_pr__nfet_01v8 L=0.5u W=1u
M3660 o5 ibias vss vss sky130_fd_pr__nfet_01v8 L=0.5u W=1u
M3661 o5 ibias vss vss sky130_fd_pr__nfet_01v8 L=0.5u W=1u
M3662 o5 ibias vss vss sky130_fd_pr__nfet_01v8 L=0.5u W=1u
M3663 o5 ibias vss vss sky130_fd_pr__nfet_01v8 L=0.5u W=1u
M3664 o5 ibias vss vss sky130_fd_pr__nfet_01v8 L=0.5u W=1u
M3665 o5 ibias vss vss sky130_fd_pr__nfet_01v8 L=0.5u W=1u
M3666 o5 ibias vss vss sky130_fd_pr__nfet_01v8 L=0.5u W=1u
M3667 o5 ibias vss vss sky130_fd_pr__nfet_01v8 L=0.5u W=1u
M3668 o5 ibias vss vss sky130_fd_pr__nfet_01v8 L=0.5u W=1u
M3669 o5 ibias vss vss sky130_fd_pr__nfet_01v8 L=0.5u W=1u
M3670 o5 ibias vss vss sky130_fd_pr__nfet_01v8 L=0.5u W=1u
M3671 o5 ibias vss vss sky130_fd_pr__nfet_01v8 L=0.5u W=1u
M3672 o5 ibias vss vss sky130_fd_pr__nfet_01v8 L=0.5u W=1u
M3673 o5 ibias vss vss sky130_fd_pr__nfet_01v8 L=0.5u W=1u
M3674 o5 ibias vss vss sky130_fd_pr__nfet_01v8 L=0.5u W=1u
M3675 o5 ibias vss vss sky130_fd_pr__nfet_01v8 L=0.5u W=1u
M3676 o5 ibias vss vss sky130_fd_pr__nfet_01v8 L=0.5u W=1u
M3677 o5 ibias vss vss sky130_fd_pr__nfet_01v8 L=0.5u W=1u
M3678 o5 ibias vss vss sky130_fd_pr__nfet_01v8 L=0.5u W=1u
M3679 o5 ibias vss vss sky130_fd_pr__nfet_01v8 L=0.5u W=1u
M3680 o5 ibias vss vss sky130_fd_pr__nfet_01v8 L=0.5u W=1u
M3681 o5 ibias vss vss sky130_fd_pr__nfet_01v8 L=0.5u W=1u
M3682 o5 ibias vss vss sky130_fd_pr__nfet_01v8 L=0.5u W=1u
M3683 o5 ibias vss vss sky130_fd_pr__nfet_01v8 L=0.5u W=1u
M3684 o5 ibias vss vss sky130_fd_pr__nfet_01v8 L=0.5u W=1u
M3685 o5 ibias vss vss sky130_fd_pr__nfet_01v8 L=0.5u W=1u
M3686 o5 ibias vss vss sky130_fd_pr__nfet_01v8 L=0.5u W=1u
M3687 o5 ibias vss vss sky130_fd_pr__nfet_01v8 L=0.5u W=1u
M3688 o5 ibias vss vss sky130_fd_pr__nfet_01v8 L=0.5u W=1u
M3689 o5 ibias vss vss sky130_fd_pr__nfet_01v8 L=0.5u W=1u
M3690 o5 ibias vss vss sky130_fd_pr__nfet_01v8 L=0.5u W=1u
M3691 o5 ibias vss vss sky130_fd_pr__nfet_01v8 L=0.5u W=1u
M3692 o5 ibias vss vss sky130_fd_pr__nfet_01v8 L=0.5u W=1u
M3693 o5 ibias vss vss sky130_fd_pr__nfet_01v8 L=0.5u W=1u
M3694 o5 ibias vss vss sky130_fd_pr__nfet_01v8 L=0.5u W=1u
M3695 o5 ibias vss vss sky130_fd_pr__nfet_01v8 L=0.5u W=1u
M3696 o5 ibias vss vss sky130_fd_pr__nfet_01v8 L=0.5u W=1u
M3697 o5 ibias vss vss sky130_fd_pr__nfet_01v8 L=0.5u W=1u
M3698 o5 ibias vss vss sky130_fd_pr__nfet_01v8 L=0.5u W=1u
M3699 o5 ibias vss vss sky130_fd_pr__nfet_01v8 L=0.5u W=1u
M3700 o5 ibias vss vss sky130_fd_pr__nfet_01v8 L=0.5u W=1u
M3701 o5 ibias vss vss sky130_fd_pr__nfet_01v8 L=0.5u W=1u
M3702 o5 ibias vss vss sky130_fd_pr__nfet_01v8 L=0.5u W=1u
M3703 o5 ibias vss vss sky130_fd_pr__nfet_01v8 L=0.5u W=1u
M3704 o5 ibias vss vss sky130_fd_pr__nfet_01v8 L=0.5u W=1u
M3705 o5 ibias vss vss sky130_fd_pr__nfet_01v8 L=0.5u W=1u
M3706 o5 ibias vss vss sky130_fd_pr__nfet_01v8 L=0.5u W=1u
M3707 o5 ibias vss vss sky130_fd_pr__nfet_01v8 L=0.5u W=1u
M3708 o5 ibias vss vss sky130_fd_pr__nfet_01v8 L=0.5u W=1u
M3709 o5 ibias vss vss sky130_fd_pr__nfet_01v8 L=0.5u W=1u
M3710 o5 ibias vss vss sky130_fd_pr__nfet_01v8 L=0.5u W=1u
M3711 o5 ibias vss vss sky130_fd_pr__nfet_01v8 L=0.5u W=1u
M3712 o5 ibias vss vss sky130_fd_pr__nfet_01v8 L=0.5u W=1u
M3713 o5 ibias vss vss sky130_fd_pr__nfet_01v8 L=0.5u W=1u
M3714 o5 ibias vss vss sky130_fd_pr__nfet_01v8 L=0.5u W=1u
M3715 o5 ibias vss vss sky130_fd_pr__nfet_01v8 L=0.5u W=1u
M3716 o5 ibias vss vss sky130_fd_pr__nfet_01v8 L=0.5u W=1u
M3717 o5 ibias vss vss sky130_fd_pr__nfet_01v8 L=0.5u W=1u
M3718 o5 ibias vss vss sky130_fd_pr__nfet_01v8 L=0.5u W=1u
M3719 o5 ibias vss vss sky130_fd_pr__nfet_01v8 L=0.5u W=1u
M3720 o5 ibias vss vss sky130_fd_pr__nfet_01v8 L=0.5u W=1u
M3721 o5 ibias vss vss sky130_fd_pr__nfet_01v8 L=0.5u W=1u
M3722 o5 ibias vss vss sky130_fd_pr__nfet_01v8 L=0.5u W=1u
M3723 o5 ibias vss vss sky130_fd_pr__nfet_01v8 L=0.5u W=1u
M3724 o5 ibias vss vss sky130_fd_pr__nfet_01v8 L=0.5u W=1u
M3725 o5 ibias vss vss sky130_fd_pr__nfet_01v8 L=0.5u W=1u
M3726 o5 ibias vss vss sky130_fd_pr__nfet_01v8 L=0.5u W=1u
M3727 o5 ibias vss vss sky130_fd_pr__nfet_01v8 L=0.5u W=1u
M3728 o5 ibias vss vss sky130_fd_pr__nfet_01v8 L=0.5u W=1u
M3729 o5 ibias vss vss sky130_fd_pr__nfet_01v8 L=0.5u W=1u
M3730 o5 ibias vss vss sky130_fd_pr__nfet_01v8 L=0.5u W=1u
M3731 o5 ibias vss vss sky130_fd_pr__nfet_01v8 L=0.5u W=1u
M3732 o5 ibias vss vss sky130_fd_pr__nfet_01v8 L=0.5u W=1u
M3733 o5 ibias vss vss sky130_fd_pr__nfet_01v8 L=0.5u W=1u
M3734 o5 ibias vss vss sky130_fd_pr__nfet_01v8 L=0.5u W=1u
M3735 o5 ibias vss vss sky130_fd_pr__nfet_01v8 L=0.5u W=1u
M3736 o5 ibias vss vss sky130_fd_pr__nfet_01v8 L=0.5u W=1u
M3737 o5 ibias vss vss sky130_fd_pr__nfet_01v8 L=0.5u W=1u
M3738 o5 ibias vss vss sky130_fd_pr__nfet_01v8 L=0.5u W=1u
M3739 o5 ibias vss vss sky130_fd_pr__nfet_01v8 L=0.5u W=1u
M3740 o5 ibias vss vss sky130_fd_pr__nfet_01v8 L=0.5u W=1u
M3741 o5 ibias vss vss sky130_fd_pr__nfet_01v8 L=0.5u W=1u
M3742 o5 ibias vss vss sky130_fd_pr__nfet_01v8 L=0.5u W=1u
M3743 o5 ibias vss vss sky130_fd_pr__nfet_01v8 L=0.5u W=1u
M3744 o5 ibias vss vss sky130_fd_pr__nfet_01v8 L=0.5u W=1u
M3745 o5 ibias vss vss sky130_fd_pr__nfet_01v8 L=0.5u W=1u
M3746 o5 ibias vss vss sky130_fd_pr__nfet_01v8 L=0.5u W=1u
M3747 o5 ibias vss vss sky130_fd_pr__nfet_01v8 L=0.5u W=1u
M3748 o5 ibias vss vss sky130_fd_pr__nfet_01v8 L=0.5u W=1u
M3749 o5 ibias vss vss sky130_fd_pr__nfet_01v8 L=0.5u W=1u
M3750 o5 ibias vss vss sky130_fd_pr__nfet_01v8 L=0.5u W=1u
M3751 o5 ibias vss vss sky130_fd_pr__nfet_01v8 L=0.5u W=1u
M3752 o5 ibias vss vss sky130_fd_pr__nfet_01v8 L=0.5u W=1u
M3753 o5 ibias vss vss sky130_fd_pr__nfet_01v8 L=0.5u W=1u
M3754 o5 ibias vss vss sky130_fd_pr__nfet_01v8 L=0.5u W=1u
M3755 o5 ibias vss vss sky130_fd_pr__nfet_01v8 L=0.5u W=1u
M3756 o5 ibias vss vss sky130_fd_pr__nfet_01v8 L=0.5u W=1u
M3757 o5 ibias vss vss sky130_fd_pr__nfet_01v8 L=0.5u W=1u
M3758 o5 ibias vss vss sky130_fd_pr__nfet_01v8 L=0.5u W=1u
M3759 o5 ibias vss vss sky130_fd_pr__nfet_01v8 L=0.5u W=1u
M3760 o5 ibias vss vss sky130_fd_pr__nfet_01v8 L=0.5u W=1u
M3761 o5 ibias vss vss sky130_fd_pr__nfet_01v8 L=0.5u W=1u
M3762 o5 ibias vss vss sky130_fd_pr__nfet_01v8 L=0.5u W=1u
M3763 o5 ibias vss vss sky130_fd_pr__nfet_01v8 L=0.5u W=1u
M3764 o5 ibias vss vss sky130_fd_pr__nfet_01v8 L=0.5u W=1u
M3765 o5 ibias vss vss sky130_fd_pr__nfet_01v8 L=0.5u W=1u
M3766 o5 ibias vss vss sky130_fd_pr__nfet_01v8 L=0.5u W=1u
M3767 o5 ibias vss vss sky130_fd_pr__nfet_01v8 L=0.5u W=1u
M3768 o5 ibias vss vss sky130_fd_pr__nfet_01v8 L=0.5u W=1u
M3769 o5 ibias vss vss sky130_fd_pr__nfet_01v8 L=0.5u W=1u
M3770 o5 ibias vss vss sky130_fd_pr__nfet_01v8 L=0.5u W=1u
M3771 o5 ibias vss vss sky130_fd_pr__nfet_01v8 L=0.5u W=1u
M3772 o5 ibias vss vss sky130_fd_pr__nfet_01v8 L=0.5u W=1u
M3773 o5 ibias vss vss sky130_fd_pr__nfet_01v8 L=0.5u W=1u
M3774 o5 ibias vss vss sky130_fd_pr__nfet_01v8 L=0.5u W=1u
M3775 o5 ibias vss vss sky130_fd_pr__nfet_01v8 L=0.5u W=1u
M3776 o5 ibias vss vss sky130_fd_pr__nfet_01v8 L=0.5u W=1u
M3777 o5 ibias vss vss sky130_fd_pr__nfet_01v8 L=0.5u W=1u
M3778 o5 ibias vss vss sky130_fd_pr__nfet_01v8 L=0.5u W=1u
M3779 o5 ibias vss vss sky130_fd_pr__nfet_01v8 L=0.5u W=1u
M3780 o5 ibias vss vss sky130_fd_pr__nfet_01v8 L=0.5u W=1u
M3781 o5 ibias vss vss sky130_fd_pr__nfet_01v8 L=0.5u W=1u
M3782 o5 ibias vss vss sky130_fd_pr__nfet_01v8 L=0.5u W=1u
M3783 o5 ibias vss vss sky130_fd_pr__nfet_01v8 L=0.5u W=1u
M3784 o5 ibias vss vss sky130_fd_pr__nfet_01v8 L=0.5u W=1u
M3785 o5 ibias vss vss sky130_fd_pr__nfet_01v8 L=0.5u W=1u
M3786 o5 ibias vss vss sky130_fd_pr__nfet_01v8 L=0.5u W=1u
M3787 o5 ibias vss vss sky130_fd_pr__nfet_01v8 L=0.5u W=1u
M3788 o5 ibias vss vss sky130_fd_pr__nfet_01v8 L=0.5u W=1u
M3789 o5 ibias vss vss sky130_fd_pr__nfet_01v8 L=0.5u W=1u
M3790 o5 ibias vss vss sky130_fd_pr__nfet_01v8 L=0.5u W=1u
M3791 o5 ibias vss vss sky130_fd_pr__nfet_01v8 L=0.5u W=1u
M3792 o5 ibias vss vss sky130_fd_pr__nfet_01v8 L=0.5u W=1u
M3793 o5 ibias vss vss sky130_fd_pr__nfet_01v8 L=0.5u W=1u
M3794 o5 ibias vss vss sky130_fd_pr__nfet_01v8 L=0.5u W=1u
M3795 o5 ibias vss vss sky130_fd_pr__nfet_01v8 L=0.5u W=1u
M3796 o5 ibias vss vss sky130_fd_pr__nfet_01v8 L=0.5u W=1u
M3797 o5 ibias vss vss sky130_fd_pr__nfet_01v8 L=0.5u W=1u
M3798 o5 ibias vss vss sky130_fd_pr__nfet_01v8 L=0.5u W=1u
M3799 o5 ibias vss vss sky130_fd_pr__nfet_01v8 L=0.5u W=1u
M3800 o5 ibias vss vss sky130_fd_pr__nfet_01v8 L=0.5u W=1u
M3801 o5 ibias vss vss sky130_fd_pr__nfet_01v8 L=0.5u W=1u
M3802 o5 ibias vss vss sky130_fd_pr__nfet_01v8 L=0.5u W=1u
M3803 o5 ibias vss vss sky130_fd_pr__nfet_01v8 L=0.5u W=1u
M3804 o5 ibias vss vss sky130_fd_pr__nfet_01v8 L=0.5u W=1u
M3805 o5 ibias vss vss sky130_fd_pr__nfet_01v8 L=0.5u W=1u
M3806 o5 ibias vss vss sky130_fd_pr__nfet_01v8 L=0.5u W=1u
M3807 o5 ibias vss vss sky130_fd_pr__nfet_01v8 L=0.5u W=1u
M3808 o5 ibias vss vss sky130_fd_pr__nfet_01v8 L=0.5u W=1u
M3809 o5 ibias vss vss sky130_fd_pr__nfet_01v8 L=0.5u W=1u
M3810 o5 ibias vss vss sky130_fd_pr__nfet_01v8 L=0.5u W=1u
M3811 o5 ibias vss vss sky130_fd_pr__nfet_01v8 L=0.5u W=1u
M3812 o5 ibias vss vss sky130_fd_pr__nfet_01v8 L=0.5u W=1u
M3813 o5 ibias vss vss sky130_fd_pr__nfet_01v8 L=0.5u W=1u
M3814 o5 ibias vss vss sky130_fd_pr__nfet_01v8 L=0.5u W=1u
M3815 o5 ibias vss vss sky130_fd_pr__nfet_01v8 L=0.5u W=1u
M3816 o5 ibias vss vss sky130_fd_pr__nfet_01v8 L=0.5u W=1u
M3817 o5 ibias vss vss sky130_fd_pr__nfet_01v8 L=0.5u W=1u
M3818 o5 ibias vss vss sky130_fd_pr__nfet_01v8 L=0.5u W=1u
M3819 o5 ibias vss vss sky130_fd_pr__nfet_01v8 L=0.5u W=1u
M3820 o5 ibias vss vss sky130_fd_pr__nfet_01v8 L=0.5u W=1u
M3821 o5 ibias vss vss sky130_fd_pr__nfet_01v8 L=0.5u W=1u
M3822 o5 ibias vss vss sky130_fd_pr__nfet_01v8 L=0.5u W=1u
M3823 o5 ibias vss vss sky130_fd_pr__nfet_01v8 L=0.5u W=1u
M3824 o5 ibias vss vss sky130_fd_pr__nfet_01v8 L=0.5u W=1u
M3825 o5 ibias vss vss sky130_fd_pr__nfet_01v8 L=0.5u W=1u
M3826 o5 ibias vss vss sky130_fd_pr__nfet_01v8 L=0.5u W=1u
M3827 o5 ibias vss vss sky130_fd_pr__nfet_01v8 L=0.5u W=1u
M3828 o5 ibias vss vss sky130_fd_pr__nfet_01v8 L=0.5u W=1u
M3829 o5 ibias vss vss sky130_fd_pr__nfet_01v8 L=0.5u W=1u
M3830 o5 ibias vss vss sky130_fd_pr__nfet_01v8 L=0.5u W=1u
M3831 o5 ibias vss vss sky130_fd_pr__nfet_01v8 L=0.5u W=1u
M3832 o5 ibias vss vss sky130_fd_pr__nfet_01v8 L=0.5u W=1u
M3833 o5 ibias vss vss sky130_fd_pr__nfet_01v8 L=0.5u W=1u
M3834 o5 ibias vss vss sky130_fd_pr__nfet_01v8 L=0.5u W=1u
M3835 o5 ibias vss vss sky130_fd_pr__nfet_01v8 L=0.5u W=1u
M3836 o5 ibias vss vss sky130_fd_pr__nfet_01v8 L=0.5u W=1u
M3837 o5 ibias vss vss sky130_fd_pr__nfet_01v8 L=0.5u W=1u
M3838 o5 ibias vss vss sky130_fd_pr__nfet_01v8 L=0.5u W=1u
M3839 o5 ibias vss vss sky130_fd_pr__nfet_01v8 L=0.5u W=1u
M3840 o5 ibias vss vss sky130_fd_pr__nfet_01v8 L=0.5u W=1u
M3841 o5 ibias vss vss sky130_fd_pr__nfet_01v8 L=0.5u W=1u
M3842 o5 ibias vss vss sky130_fd_pr__nfet_01v8 L=0.5u W=1u
M3843 o5 ibias vss vss sky130_fd_pr__nfet_01v8 L=0.5u W=1u
M3844 o5 ibias vss vss sky130_fd_pr__nfet_01v8 L=0.5u W=1u
M3845 o5 ibias vss vss sky130_fd_pr__nfet_01v8 L=0.5u W=1u
M3846 o5 ibias vss vss sky130_fd_pr__nfet_01v8 L=0.5u W=1u
M3847 o5 ibias vss vss sky130_fd_pr__nfet_01v8 L=0.5u W=1u
M3848 o5 ibias vss vss sky130_fd_pr__nfet_01v8 L=0.5u W=1u
M3849 o5 ibias vss vss sky130_fd_pr__nfet_01v8 L=0.5u W=1u
M3850 o5 ibias vss vss sky130_fd_pr__nfet_01v8 L=0.5u W=1u
M3851 o5 ibias vss vss sky130_fd_pr__nfet_01v8 L=0.5u W=1u
M3852 o5 ibias vss vss sky130_fd_pr__nfet_01v8 L=0.5u W=1u
M3853 o5 ibias vss vss sky130_fd_pr__nfet_01v8 L=0.5u W=1u
M3854 o5 ibias vss vss sky130_fd_pr__nfet_01v8 L=0.5u W=1u
M3855 o5 ibias vss vss sky130_fd_pr__nfet_01v8 L=0.5u W=1u
M3856 o5 ibias vss vss sky130_fd_pr__nfet_01v8 L=0.5u W=1u
M3857 o5 ibias vss vss sky130_fd_pr__nfet_01v8 L=0.5u W=1u
M3858 o5 ibias vss vss sky130_fd_pr__nfet_01v8 L=0.5u W=1u
M3859 o5 ibias vss vss sky130_fd_pr__nfet_01v8 L=0.5u W=1u
M3860 o5 ibias vss vss sky130_fd_pr__nfet_01v8 L=0.5u W=1u
M3861 o5 ibias vss vss sky130_fd_pr__nfet_01v8 L=0.5u W=1u
M3862 o5 ibias vss vss sky130_fd_pr__nfet_01v8 L=0.5u W=1u
M3863 o5 ibias vss vss sky130_fd_pr__nfet_01v8 L=0.5u W=1u
M3864 o5 ibias vss vss sky130_fd_pr__nfet_01v8 L=0.5u W=1u
M3865 o5 ibias vss vss sky130_fd_pr__nfet_01v8 L=0.5u W=1u
M3866 o5 ibias vss vss sky130_fd_pr__nfet_01v8 L=0.5u W=1u
M3867 o5 ibias vss vss sky130_fd_pr__nfet_01v8 L=0.5u W=1u
M3868 o5 ibias vss vss sky130_fd_pr__nfet_01v8 L=0.5u W=1u
M3869 o5 ibias vss vss sky130_fd_pr__nfet_01v8 L=0.5u W=1u
M3870 o5 ibias vss vss sky130_fd_pr__nfet_01v8 L=0.5u W=1u
M3871 o5 ibias vss vss sky130_fd_pr__nfet_01v8 L=0.5u W=1u
M3872 o5 ibias vss vss sky130_fd_pr__nfet_01v8 L=0.5u W=1u
M3873 o5 ibias vss vss sky130_fd_pr__nfet_01v8 L=0.5u W=1u
M3874 o5 ibias vss vss sky130_fd_pr__nfet_01v8 L=0.5u W=1u
M3875 o5 ibias vss vss sky130_fd_pr__nfet_01v8 L=0.5u W=1u
M3876 o5 ibias vss vss sky130_fd_pr__nfet_01v8 L=0.5u W=1u
M3877 o5 ibias vss vss sky130_fd_pr__nfet_01v8 L=0.5u W=1u
M3878 o5 ibias vss vss sky130_fd_pr__nfet_01v8 L=0.5u W=1u
M3879 o5 ibias vss vss sky130_fd_pr__nfet_01v8 L=0.5u W=1u
M3880 o5 ibias vss vss sky130_fd_pr__nfet_01v8 L=0.5u W=1u
M3881 o5 ibias vss vss sky130_fd_pr__nfet_01v8 L=0.5u W=1u
M3882 o5 ibias vss vss sky130_fd_pr__nfet_01v8 L=0.5u W=1u
M3883 o5 ibias vss vss sky130_fd_pr__nfet_01v8 L=0.5u W=1u
M3884 o5 ibias vss vss sky130_fd_pr__nfet_01v8 L=0.5u W=1u
M3885 o5 ibias vss vss sky130_fd_pr__nfet_01v8 L=0.5u W=1u
M3886 o5 ibias vss vss sky130_fd_pr__nfet_01v8 L=0.5u W=1u
M3887 o5 ibias vss vss sky130_fd_pr__nfet_01v8 L=0.5u W=1u
M3888 o5 ibias vss vss sky130_fd_pr__nfet_01v8 L=0.5u W=1u
M3889 o5 ibias vss vss sky130_fd_pr__nfet_01v8 L=0.5u W=1u
M3890 o5 ibias vss vss sky130_fd_pr__nfet_01v8 L=0.5u W=1u
M3891 o5 ibias vss vss sky130_fd_pr__nfet_01v8 L=0.5u W=1u
M3892 o5 ibias vss vss sky130_fd_pr__nfet_01v8 L=0.5u W=1u
M3893 o5 ibias vss vss sky130_fd_pr__nfet_01v8 L=0.5u W=1u
M3894 o5 ibias vss vss sky130_fd_pr__nfet_01v8 L=0.5u W=1u
M3895 o5 ibias vss vss sky130_fd_pr__nfet_01v8 L=0.5u W=1u
M3896 o5 ibias vss vss sky130_fd_pr__nfet_01v8 L=0.5u W=1u
M3897 o5 ibias vss vss sky130_fd_pr__nfet_01v8 L=0.5u W=1u
M3898 o5 ibias vss vss sky130_fd_pr__nfet_01v8 L=0.5u W=1u
M3899 o5 ibias vss vss sky130_fd_pr__nfet_01v8 L=0.5u W=1u
M3900 o5 ibias vss vss sky130_fd_pr__nfet_01v8 L=0.5u W=1u
M3901 o5 ibias vss vss sky130_fd_pr__nfet_01v8 L=0.5u W=1u
M3902 o5 ibias vss vss sky130_fd_pr__nfet_01v8 L=0.5u W=1u
M3903 o5 ibias vss vss sky130_fd_pr__nfet_01v8 L=0.5u W=1u
M3904 o5 ibias vss vss sky130_fd_pr__nfet_01v8 L=0.5u W=1u
M3905 o5 ibias vss vss sky130_fd_pr__nfet_01v8 L=0.5u W=1u
M3906 o5 ibias vss vss sky130_fd_pr__nfet_01v8 L=0.5u W=1u
M3907 o5 ibias vss vss sky130_fd_pr__nfet_01v8 L=0.5u W=1u
M3908 o5 ibias vss vss sky130_fd_pr__nfet_01v8 L=0.5u W=1u
M3909 o5 ibias vss vss sky130_fd_pr__nfet_01v8 L=0.5u W=1u
M3910 o5 ibias vss vss sky130_fd_pr__nfet_01v8 L=0.5u W=1u
M3911 o5 ibias vss vss sky130_fd_pr__nfet_01v8 L=0.5u W=1u
M3912 o5 ibias vss vss sky130_fd_pr__nfet_01v8 L=0.5u W=1u
M3913 o5 ibias vss vss sky130_fd_pr__nfet_01v8 L=0.5u W=1u
M3914 o5 ibias vss vss sky130_fd_pr__nfet_01v8 L=0.5u W=1u
M3915 o5 ibias vss vss sky130_fd_pr__nfet_01v8 L=0.5u W=1u
M3916 o5 ibias vss vss sky130_fd_pr__nfet_01v8 L=0.5u W=1u
M3917 o5 ibias vss vss sky130_fd_pr__nfet_01v8 L=0.5u W=1u
M3918 o5 ibias vss vss sky130_fd_pr__nfet_01v8 L=0.5u W=1u
M3919 o5 ibias vss vss sky130_fd_pr__nfet_01v8 L=0.5u W=1u
M3920 o5 ibias vss vss sky130_fd_pr__nfet_01v8 L=0.5u W=1u
M3921 o5 ibias vss vss sky130_fd_pr__nfet_01v8 L=0.5u W=1u
M3922 o5 ibias vss vss sky130_fd_pr__nfet_01v8 L=0.5u W=1u
M3923 o5 ibias vss vss sky130_fd_pr__nfet_01v8 L=0.5u W=1u
M3924 o5 ibias vss vss sky130_fd_pr__nfet_01v8 L=0.5u W=1u
M3925 o5 ibias vss vss sky130_fd_pr__nfet_01v8 L=0.5u W=1u
M3926 o5 ibias vss vss sky130_fd_pr__nfet_01v8 L=0.5u W=1u
M3927 o5 ibias vss vss sky130_fd_pr__nfet_01v8 L=0.5u W=1u
M3928 o5 ibias vss vss sky130_fd_pr__nfet_01v8 L=0.5u W=1u
M3929 o5 ibias vss vss sky130_fd_pr__nfet_01v8 L=0.5u W=1u
M3930 o5 ibias vss vss sky130_fd_pr__nfet_01v8 L=0.5u W=1u
M3931 o5 ibias vss vss sky130_fd_pr__nfet_01v8 L=0.5u W=1u
M3932 o5 ibias vss vss sky130_fd_pr__nfet_01v8 L=0.5u W=1u
M3933 o5 ibias vss vss sky130_fd_pr__nfet_01v8 L=0.5u W=1u
M3934 o5 ibias vss vss sky130_fd_pr__nfet_01v8 L=0.5u W=1u
M3935 o5 ibias vss vss sky130_fd_pr__nfet_01v8 L=0.5u W=1u
M3936 o5 ibias vss vss sky130_fd_pr__nfet_01v8 L=0.5u W=1u
M3937 o5 ibias vss vss sky130_fd_pr__nfet_01v8 L=0.5u W=1u
M3938 o5 ibias vss vss sky130_fd_pr__nfet_01v8 L=0.5u W=1u
M3939 o5 ibias vss vss sky130_fd_pr__nfet_01v8 L=0.5u W=1u
M3940 o5 ibias vss vss sky130_fd_pr__nfet_01v8 L=0.5u W=1u
M3941 o5 ibias vss vss sky130_fd_pr__nfet_01v8 L=0.5u W=1u
M3942 o5 ibias vss vss sky130_fd_pr__nfet_01v8 L=0.5u W=1u
M3943 o5 ibias vss vss sky130_fd_pr__nfet_01v8 L=0.5u W=1u
M3944 o5 ibias vss vss sky130_fd_pr__nfet_01v8 L=0.5u W=1u
M3945 o5 ibias vss vss sky130_fd_pr__nfet_01v8 L=0.5u W=1u
M3946 o5 ibias vss vss sky130_fd_pr__nfet_01v8 L=0.5u W=1u
M3947 o5 ibias vss vss sky130_fd_pr__nfet_01v8 L=0.5u W=1u
M3948 o5 ibias vss vss sky130_fd_pr__nfet_01v8 L=0.5u W=1u
M3949 o5 ibias vss vss sky130_fd_pr__nfet_01v8 L=0.5u W=1u
M3950 o5 ibias vss vss sky130_fd_pr__nfet_01v8 L=0.5u W=1u
M3951 o5 ibias vss vss sky130_fd_pr__nfet_01v8 L=0.5u W=1u
M3952 o5 ibias vss vss sky130_fd_pr__nfet_01v8 L=0.5u W=1u
M3953 o5 ibias vss vss sky130_fd_pr__nfet_01v8 L=0.5u W=1u
M3954 o5 ibias vss vss sky130_fd_pr__nfet_01v8 L=0.5u W=1u
M3955 o5 ibias vss vss sky130_fd_pr__nfet_01v8 L=0.5u W=1u
M3956 o5 ibias vss vss sky130_fd_pr__nfet_01v8 L=0.5u W=1u
M3957 o5 ibias vss vss sky130_fd_pr__nfet_01v8 L=0.5u W=1u
M3958 o5 ibias vss vss sky130_fd_pr__nfet_01v8 L=0.5u W=1u
M3959 o5 ibias vss vss sky130_fd_pr__nfet_01v8 L=0.5u W=1u
M3960 o5 ibias vss vss sky130_fd_pr__nfet_01v8 L=0.5u W=1u
M3961 o5 ibias vss vss sky130_fd_pr__nfet_01v8 L=0.5u W=1u
M3962 o5 ibias vss vss sky130_fd_pr__nfet_01v8 L=0.5u W=1u
M3963 o5 ibias vss vss sky130_fd_pr__nfet_01v8 L=0.5u W=1u
M3964 o5 ibias vss vss sky130_fd_pr__nfet_01v8 L=0.5u W=1u
M3965 o5 ibias vss vss sky130_fd_pr__nfet_01v8 L=0.5u W=1u
M3966 o5 ibias vss vss sky130_fd_pr__nfet_01v8 L=0.5u W=1u
M3967 o5 ibias vss vss sky130_fd_pr__nfet_01v8 L=0.5u W=1u
M3968 o5 ibias vss vss sky130_fd_pr__nfet_01v8 L=0.5u W=1u
M3969 o5 ibias vss vss sky130_fd_pr__nfet_01v8 L=0.5u W=1u
M3970 o5 ibias vss vss sky130_fd_pr__nfet_01v8 L=0.5u W=1u
M3971 o5 ibias vss vss sky130_fd_pr__nfet_01v8 L=0.5u W=1u
M3972 o5 ibias vss vss sky130_fd_pr__nfet_01v8 L=0.5u W=1u
M3973 o5 ibias vss vss sky130_fd_pr__nfet_01v8 L=0.5u W=1u
M3974 o5 ibias vss vss sky130_fd_pr__nfet_01v8 L=0.5u W=1u
M3975 o5 ibias vss vss sky130_fd_pr__nfet_01v8 L=0.5u W=1u
M3976 o5 ibias vss vss sky130_fd_pr__nfet_01v8 L=0.5u W=1u
M3977 o5 ibias vss vss sky130_fd_pr__nfet_01v8 L=0.5u W=1u
M3978 o5 ibias vss vss sky130_fd_pr__nfet_01v8 L=0.5u W=1u
M3979 o5 ibias vss vss sky130_fd_pr__nfet_01v8 L=0.5u W=1u
M3980 o5 ibias vss vss sky130_fd_pr__nfet_01v8 L=0.5u W=1u
M3981 o5 ibias vss vss sky130_fd_pr__nfet_01v8 L=0.5u W=1u
M3982 o5 ibias vss vss sky130_fd_pr__nfet_01v8 L=0.5u W=1u
M3983 o5 ibias vss vss sky130_fd_pr__nfet_01v8 L=0.5u W=1u
M3984 o5 ibias vss vss sky130_fd_pr__nfet_01v8 L=0.5u W=1u
M3985 o5 ibias vss vss sky130_fd_pr__nfet_01v8 L=0.5u W=1u
M3986 o5 ibias vss vss sky130_fd_pr__nfet_01v8 L=0.5u W=1u
M3987 o5 ibias vss vss sky130_fd_pr__nfet_01v8 L=0.5u W=1u
M3988 o5 ibias vss vss sky130_fd_pr__nfet_01v8 L=0.5u W=1u
M3989 o5 ibias vss vss sky130_fd_pr__nfet_01v8 L=0.5u W=1u
M3990 o5 ibias vss vss sky130_fd_pr__nfet_01v8 L=0.5u W=1u
M3991 o5 ibias vss vss sky130_fd_pr__nfet_01v8 L=0.5u W=1u
M3992 o5 ibias vss vss sky130_fd_pr__nfet_01v8 L=0.5u W=1u
M3993 o5 ibias vss vss sky130_fd_pr__nfet_01v8 L=0.5u W=1u
M3994 o5 ibias vss vss sky130_fd_pr__nfet_01v8 L=0.5u W=1u
M3995 o5 ibias vss vss sky130_fd_pr__nfet_01v8 L=0.5u W=1u
M3996 o5 ibias vss vss sky130_fd_pr__nfet_01v8 L=0.5u W=1u
M3997 o5 ibias vss vss sky130_fd_pr__nfet_01v8 L=0.5u W=1u
M3998 o5 ibias vss vss sky130_fd_pr__nfet_01v8 L=0.5u W=1u
M3999 o5 ibias vss vss sky130_fd_pr__nfet_01v8 L=0.5u W=1u
M4000 o5 ibias vss vss sky130_fd_pr__nfet_01v8 L=0.5u W=1u
M4001 o5 ibias vss vss sky130_fd_pr__nfet_01v8 L=0.5u W=1u
M4002 o5 ibias vss vss sky130_fd_pr__nfet_01v8 L=0.5u W=1u
M4003 o5 ibias vss vss sky130_fd_pr__nfet_01v8 L=0.5u W=1u
M4004 o5 ibias vss vss sky130_fd_pr__nfet_01v8 L=0.5u W=1u
M4005 o5 ibias vss vss sky130_fd_pr__nfet_01v8 L=0.5u W=1u
M4006 o5 ibias vss vss sky130_fd_pr__nfet_01v8 L=0.5u W=1u
M4007 o5 ibias vss vss sky130_fd_pr__nfet_01v8 L=0.5u W=1u
M4008 o5 ibias vss vss sky130_fd_pr__nfet_01v8 L=0.5u W=1u
M4009 o5 ibias vss vss sky130_fd_pr__nfet_01v8 L=0.5u W=1u
M4010 o5 ibias vss vss sky130_fd_pr__nfet_01v8 L=0.5u W=1u
M4011 o5 ibias vss vss sky130_fd_pr__nfet_01v8 L=0.5u W=1u
M4012 o5 ibias vss vss sky130_fd_pr__nfet_01v8 L=0.5u W=1u
M4013 o5 ibias vss vss sky130_fd_pr__nfet_01v8 L=0.5u W=1u
M4014 o5 ibias vss vss sky130_fd_pr__nfet_01v8 L=0.5u W=1u
M4015 o5 ibias vss vss sky130_fd_pr__nfet_01v8 L=0.5u W=1u
M4016 o5 ibias vss vss sky130_fd_pr__nfet_01v8 L=0.5u W=1u
M4017 o5 ibias vss vss sky130_fd_pr__nfet_01v8 L=0.5u W=1u
M4018 o5 ibias vss vss sky130_fd_pr__nfet_01v8 L=0.5u W=1u
M4019 o5 ibias vss vss sky130_fd_pr__nfet_01v8 L=0.5u W=1u
M4020 o5 ibias vss vss sky130_fd_pr__nfet_01v8 L=0.5u W=1u
M4021 o5 ibias vss vss sky130_fd_pr__nfet_01v8 L=0.5u W=1u
M4022 o5 ibias vss vss sky130_fd_pr__nfet_01v8 L=0.5u W=1u
M4023 o5 ibias vss vss sky130_fd_pr__nfet_01v8 L=0.5u W=1u
M4024 o5 ibias vss vss sky130_fd_pr__nfet_01v8 L=0.5u W=1u
M4025 o5 ibias vss vss sky130_fd_pr__nfet_01v8 L=0.5u W=1u
M4026 o5 ibias vss vss sky130_fd_pr__nfet_01v8 L=0.5u W=1u
M4027 o5 ibias vss vss sky130_fd_pr__nfet_01v8 L=0.5u W=1u
M4028 o5 ibias vss vss sky130_fd_pr__nfet_01v8 L=0.5u W=1u
M4029 o5 ibias vss vss sky130_fd_pr__nfet_01v8 L=0.5u W=1u
M4030 o5 ibias vss vss sky130_fd_pr__nfet_01v8 L=0.5u W=1u
M4031 o5 ibias vss vss sky130_fd_pr__nfet_01v8 L=0.5u W=1u
M4032 o5 ibias vss vss sky130_fd_pr__nfet_01v8 L=0.5u W=1u
M4033 o5 ibias vss vss sky130_fd_pr__nfet_01v8 L=0.5u W=1u
M4034 o5 ibias vss vss sky130_fd_pr__nfet_01v8 L=0.5u W=1u
M4035 o5 ibias vss vss sky130_fd_pr__nfet_01v8 L=0.5u W=1u
M4036 o5 ibias vss vss sky130_fd_pr__nfet_01v8 L=0.5u W=1u
M4037 o5 ibias vss vss sky130_fd_pr__nfet_01v8 L=0.5u W=1u
M4038 o5 ibias vss vss sky130_fd_pr__nfet_01v8 L=0.5u W=1u
M4039 o5 ibias vss vss sky130_fd_pr__nfet_01v8 L=0.5u W=1u
M4040 o5 ibias vss vss sky130_fd_pr__nfet_01v8 L=0.5u W=1u
M4041 o5 ibias vss vss sky130_fd_pr__nfet_01v8 L=0.5u W=1u
M4042 o5 ibias vss vss sky130_fd_pr__nfet_01v8 L=0.5u W=1u
M4043 o5 ibias vss vss sky130_fd_pr__nfet_01v8 L=0.5u W=1u
M4044 o5 ibias vss vss sky130_fd_pr__nfet_01v8 L=0.5u W=1u
M4045 o5 ibias vss vss sky130_fd_pr__nfet_01v8 L=0.5u W=1u
M4046 o5 ibias vss vss sky130_fd_pr__nfet_01v8 L=0.5u W=1u
M4047 o5 ibias vss vss sky130_fd_pr__nfet_01v8 L=0.5u W=1u
M4048 o5 ibias vss vss sky130_fd_pr__nfet_01v8 L=0.5u W=1u
M4049 o5 ibias vss vss sky130_fd_pr__nfet_01v8 L=0.5u W=1u
M4050 o5 ibias vss vss sky130_fd_pr__nfet_01v8 L=0.5u W=1u
M4051 o5 ibias vss vss sky130_fd_pr__nfet_01v8 L=0.5u W=1u
M4052 o5 ibias vss vss sky130_fd_pr__nfet_01v8 L=0.5u W=1u
M4053 o5 ibias vss vss sky130_fd_pr__nfet_01v8 L=0.5u W=1u
M4054 o5 ibias vss vss sky130_fd_pr__nfet_01v8 L=0.5u W=1u
M4055 o5 ibias vss vss sky130_fd_pr__nfet_01v8 L=0.5u W=1u
M4056 o5 ibias vss vss sky130_fd_pr__nfet_01v8 L=0.5u W=1u
M4057 o5 ibias vss vss sky130_fd_pr__nfet_01v8 L=0.5u W=1u
M4058 o5 ibias vss vss sky130_fd_pr__nfet_01v8 L=0.5u W=1u
M4059 o5 ibias vss vss sky130_fd_pr__nfet_01v8 L=0.5u W=1u
M4060 o5 ibias vss vss sky130_fd_pr__nfet_01v8 L=0.5u W=1u
M4061 o5 ibias vss vss sky130_fd_pr__nfet_01v8 L=0.5u W=1u
M4062 o5 ibias vss vss sky130_fd_pr__nfet_01v8 L=0.5u W=1u
M4063 o5 ibias vss vss sky130_fd_pr__nfet_01v8 L=0.5u W=1u
M4064 o5 ibias vss vss sky130_fd_pr__nfet_01v8 L=0.5u W=1u
M4065 o5 ibias vss vss sky130_fd_pr__nfet_01v8 L=0.5u W=1u
M4066 o5 ibias vss vss sky130_fd_pr__nfet_01v8 L=0.5u W=1u
M4067 o5 ibias vss vss sky130_fd_pr__nfet_01v8 L=0.5u W=1u
M4068 o5 ibias vss vss sky130_fd_pr__nfet_01v8 L=0.5u W=1u
M4069 o5 ibias vss vss sky130_fd_pr__nfet_01v8 L=0.5u W=1u
M4070 o5 ibias vss vss sky130_fd_pr__nfet_01v8 L=0.5u W=1u
M4071 o5 ibias vss vss sky130_fd_pr__nfet_01v8 L=0.5u W=1u
M4072 o5 ibias vss vss sky130_fd_pr__nfet_01v8 L=0.5u W=1u
M4073 o5 ibias vss vss sky130_fd_pr__nfet_01v8 L=0.5u W=1u
M4074 o5 ibias vss vss sky130_fd_pr__nfet_01v8 L=0.5u W=1u
M4075 o5 ibias vss vss sky130_fd_pr__nfet_01v8 L=0.5u W=1u
M4076 o5 ibias vss vss sky130_fd_pr__nfet_01v8 L=0.5u W=1u
M4077 o5 ibias vss vss sky130_fd_pr__nfet_01v8 L=0.5u W=1u
M4078 o5 ibias vss vss sky130_fd_pr__nfet_01v8 L=0.5u W=1u
M4079 o5 ibias vss vss sky130_fd_pr__nfet_01v8 L=0.5u W=1u
M4080 o5 ibias vss vss sky130_fd_pr__nfet_01v8 L=0.5u W=1u
M4081 o5 ibias vss vss sky130_fd_pr__nfet_01v8 L=0.5u W=1u
M4082 o5 ibias vss vss sky130_fd_pr__nfet_01v8 L=0.5u W=1u
M4083 o5 ibias vss vss sky130_fd_pr__nfet_01v8 L=0.5u W=1u
M4084 o5 ibias vss vss sky130_fd_pr__nfet_01v8 L=0.5u W=1u
M4085 o5 ibias vss vss sky130_fd_pr__nfet_01v8 L=0.5u W=1u
M4086 o5 ibias vss vss sky130_fd_pr__nfet_01v8 L=0.5u W=1u
M4087 o5 ibias vss vss sky130_fd_pr__nfet_01v8 L=0.5u W=1u
M4088 o5 ibias vss vss sky130_fd_pr__nfet_01v8 L=0.5u W=1u
M4089 o5 ibias vss vss sky130_fd_pr__nfet_01v8 L=0.5u W=1u
M4090 o5 ibias vss vss sky130_fd_pr__nfet_01v8 L=0.5u W=1u
M4091 o5 ibias vss vss sky130_fd_pr__nfet_01v8 L=0.5u W=1u
M4092 o5 ibias vss vss sky130_fd_pr__nfet_01v8 L=0.5u W=1u
M4093 o5 ibias vss vss sky130_fd_pr__nfet_01v8 L=0.5u W=1u
M4094 o5 ibias vss vss sky130_fd_pr__nfet_01v8 L=0.5u W=1u
M4095 o5 ibias vss vss sky130_fd_pr__nfet_01v8 L=0.5u W=1u
M4096 o5 ibias vss vss sky130_fd_pr__nfet_01v8 L=0.5u W=1u
M4097 o5 ibias vss vss sky130_fd_pr__nfet_01v8 L=0.5u W=1u
M4098 o5 ibias vss vss sky130_fd_pr__nfet_01v8 L=0.5u W=1u
M4099 o5 ibias vss vss sky130_fd_pr__nfet_01v8 L=0.5u W=1u
M4100 o5 ibias vss vss sky130_fd_pr__nfet_01v8 L=0.5u W=1u
M4101 o5 ibias vss vss sky130_fd_pr__nfet_01v8 L=0.5u W=1u
M4102 o5 ibias vss vss sky130_fd_pr__nfet_01v8 L=0.5u W=1u
M4103 o5 ibias vss vss sky130_fd_pr__nfet_01v8 L=0.5u W=1u
M4104 o5 ibias vss vss sky130_fd_pr__nfet_01v8 L=0.5u W=1u
M4105 o5 ibias vss vss sky130_fd_pr__nfet_01v8 L=0.5u W=1u
M4106 o5 ibias vss vss sky130_fd_pr__nfet_01v8 L=0.5u W=1u
M4107 o5 ibias vss vss sky130_fd_pr__nfet_01v8 L=0.5u W=1u
M4108 o5 ibias vss vss sky130_fd_pr__nfet_01v8 L=0.5u W=1u
M4109 o5 ibias vss vss sky130_fd_pr__nfet_01v8 L=0.5u W=1u
M4110 o5 ibias vss vss sky130_fd_pr__nfet_01v8 L=0.5u W=1u
M4111 o5 ibias vss vss sky130_fd_pr__nfet_01v8 L=0.5u W=1u
M4112 o5 ibias vss vss sky130_fd_pr__nfet_01v8 L=0.5u W=1u
M4113 o5 ibias vss vss sky130_fd_pr__nfet_01v8 L=0.5u W=1u
M4114 o5 ibias vss vss sky130_fd_pr__nfet_01v8 L=0.5u W=1u
M4115 o5 ibias vss vss sky130_fd_pr__nfet_01v8 L=0.5u W=1u
M4116 o5 ibias vss vss sky130_fd_pr__nfet_01v8 L=0.5u W=1u
M4117 o5 ibias vss vss sky130_fd_pr__nfet_01v8 L=0.5u W=1u
M4118 o5 ibias vss vss sky130_fd_pr__nfet_01v8 L=0.5u W=1u
M4119 o5 ibias vss vss sky130_fd_pr__nfet_01v8 L=0.5u W=1u
M4120 o5 ibias vss vss sky130_fd_pr__nfet_01v8 L=0.5u W=1u
M4121 o5 ibias vss vss sky130_fd_pr__nfet_01v8 L=0.5u W=1u
M4122 o5 ibias vss vss sky130_fd_pr__nfet_01v8 L=0.5u W=1u
M4123 o5 ibias vss vss sky130_fd_pr__nfet_01v8 L=0.5u W=1u
M4124 o5 ibias vss vss sky130_fd_pr__nfet_01v8 L=0.5u W=1u
M4125 o5 ibias vss vss sky130_fd_pr__nfet_01v8 L=0.5u W=1u
M4126 o5 ibias vss vss sky130_fd_pr__nfet_01v8 L=0.5u W=1u
M4127 o5 ibias vss vss sky130_fd_pr__nfet_01v8 L=0.5u W=1u
M4128 o5 ibias vss vss sky130_fd_pr__nfet_01v8 L=0.5u W=1u
M4129 o5 ibias vss vss sky130_fd_pr__nfet_01v8 L=0.5u W=1u
M4130 o5 ibias vss vss sky130_fd_pr__nfet_01v8 L=0.5u W=1u
M4131 o5 ibias vss vss sky130_fd_pr__nfet_01v8 L=0.5u W=1u
M4132 o5 ibias vss vss sky130_fd_pr__nfet_01v8 L=0.5u W=1u
M4133 o5 ibias vss vss sky130_fd_pr__nfet_01v8 L=0.5u W=1u
M4134 o5 ibias vss vss sky130_fd_pr__nfet_01v8 L=0.5u W=1u
M4135 o5 ibias vss vss sky130_fd_pr__nfet_01v8 L=0.5u W=1u
M4136 o5 ibias vss vss sky130_fd_pr__nfet_01v8 L=0.5u W=1u
M4137 o5 ibias vss vss sky130_fd_pr__nfet_01v8 L=0.5u W=1u
M4138 o5 ibias vss vss sky130_fd_pr__nfet_01v8 L=0.5u W=1u
M4139 o5 ibias vss vss sky130_fd_pr__nfet_01v8 L=0.5u W=1u
M4140 o5 ibias vss vss sky130_fd_pr__nfet_01v8 L=0.5u W=1u
M4141 o5 ibias vss vss sky130_fd_pr__nfet_01v8 L=0.5u W=1u
M4142 o5 ibias vss vss sky130_fd_pr__nfet_01v8 L=0.5u W=1u
M4143 o5 ibias vss vss sky130_fd_pr__nfet_01v8 L=0.5u W=1u
M4144 o5 ibias vss vss sky130_fd_pr__nfet_01v8 L=0.5u W=1u
M4145 o5 ibias vss vss sky130_fd_pr__nfet_01v8 L=0.5u W=1u
M4146 o5 ibias vss vss sky130_fd_pr__nfet_01v8 L=0.5u W=1u
M4147 o5 ibias vss vss sky130_fd_pr__nfet_01v8 L=0.5u W=1u
M4148 o5 ibias vss vss sky130_fd_pr__nfet_01v8 L=0.5u W=1u
M4149 o5 ibias vss vss sky130_fd_pr__nfet_01v8 L=0.5u W=1u
M4150 o5 ibias vss vss sky130_fd_pr__nfet_01v8 L=0.5u W=1u
M4151 o5 ibias vss vss sky130_fd_pr__nfet_01v8 L=0.5u W=1u
M4152 o5 ibias vss vss sky130_fd_pr__nfet_01v8 L=0.5u W=1u
M4153 o5 ibias vss vss sky130_fd_pr__nfet_01v8 L=0.5u W=1u
M4154 o5 ibias vss vss sky130_fd_pr__nfet_01v8 L=0.5u W=1u
M4155 o5 ibias vss vss sky130_fd_pr__nfet_01v8 L=0.5u W=1u
M4156 o5 ibias vss vss sky130_fd_pr__nfet_01v8 L=0.5u W=1u
M4157 o5 ibias vss vss sky130_fd_pr__nfet_01v8 L=0.5u W=1u
M4158 o5 ibias vss vss sky130_fd_pr__nfet_01v8 L=0.5u W=1u
M4159 o5 ibias vss vss sky130_fd_pr__nfet_01v8 L=0.5u W=1u
M4160 o5 ibias vss vss sky130_fd_pr__nfet_01v8 L=0.5u W=1u
M4161 o5 ibias vss vss sky130_fd_pr__nfet_01v8 L=0.5u W=1u
M4162 o5 ibias vss vss sky130_fd_pr__nfet_01v8 L=0.5u W=1u
M4163 o5 ibias vss vss sky130_fd_pr__nfet_01v8 L=0.5u W=1u
M4164 o5 ibias vss vss sky130_fd_pr__nfet_01v8 L=0.5u W=1u
M4165 o5 ibias vss vss sky130_fd_pr__nfet_01v8 L=0.5u W=1u
M4166 o5 ibias vss vss sky130_fd_pr__nfet_01v8 L=0.5u W=1u
M4167 o5 ibias vss vss sky130_fd_pr__nfet_01v8 L=0.5u W=1u
M4168 o5 ibias vss vss sky130_fd_pr__nfet_01v8 L=0.5u W=1u
M4169 o5 ibias vss vss sky130_fd_pr__nfet_01v8 L=0.5u W=1u
M4170 o5 ibias vss vss sky130_fd_pr__nfet_01v8 L=0.5u W=1u
M4171 o5 ibias vss vss sky130_fd_pr__nfet_01v8 L=0.5u W=1u
M4172 o5 ibias vss vss sky130_fd_pr__nfet_01v8 L=0.5u W=1u
M4173 o5 ibias vss vss sky130_fd_pr__nfet_01v8 L=0.5u W=1u
M4174 o5 ibias vss vss sky130_fd_pr__nfet_01v8 L=0.5u W=1u
M4175 o5 ibias vss vss sky130_fd_pr__nfet_01v8 L=0.5u W=1u
M4176 o5 ibias vss vss sky130_fd_pr__nfet_01v8 L=0.5u W=1u
M4177 o5 ibias vss vss sky130_fd_pr__nfet_01v8 L=0.5u W=1u
M4178 o5 ibias vss vss sky130_fd_pr__nfet_01v8 L=0.5u W=1u
M4179 o5 ibias vss vss sky130_fd_pr__nfet_01v8 L=0.5u W=1u
M4180 o5 ibias vss vss sky130_fd_pr__nfet_01v8 L=0.5u W=1u
M4181 o5 ibias vss vss sky130_fd_pr__nfet_01v8 L=0.5u W=1u
M4182 o5 ibias vss vss sky130_fd_pr__nfet_01v8 L=0.5u W=1u
M4183 o5 ibias vss vss sky130_fd_pr__nfet_01v8 L=0.5u W=1u
M4184 o5 ibias vss vss sky130_fd_pr__nfet_01v8 L=0.5u W=1u
M4185 o5 ibias vss vss sky130_fd_pr__nfet_01v8 L=0.5u W=1u
M4186 o5 ibias vss vss sky130_fd_pr__nfet_01v8 L=0.5u W=1u
M4187 o5 ibias vss vss sky130_fd_pr__nfet_01v8 L=0.5u W=1u
M4188 o5 ibias vss vss sky130_fd_pr__nfet_01v8 L=0.5u W=1u
M4189 o5 ibias vss vss sky130_fd_pr__nfet_01v8 L=0.5u W=1u
M4190 o5 ibias vss vss sky130_fd_pr__nfet_01v8 L=0.5u W=1u
M4191 o5 ibias vss vss sky130_fd_pr__nfet_01v8 L=0.5u W=1u
M4192 o5 ibias vss vss sky130_fd_pr__nfet_01v8 L=0.5u W=1u
M4193 o5 ibias vss vss sky130_fd_pr__nfet_01v8 L=0.5u W=1u
M4194 o5 ibias vss vss sky130_fd_pr__nfet_01v8 L=0.5u W=1u
M4195 o5 ibias vss vss sky130_fd_pr__nfet_01v8 L=0.5u W=1u
M4196 o5 ibias vss vss sky130_fd_pr__nfet_01v8 L=0.5u W=1u
M4197 o5 ibias vss vss sky130_fd_pr__nfet_01v8 L=0.5u W=1u
M4198 o5 ibias vss vss sky130_fd_pr__nfet_01v8 L=0.5u W=1u
M4199 o5 ibias vss vss sky130_fd_pr__nfet_01v8 L=0.5u W=1u
M4200 o5 ibias vss vss sky130_fd_pr__nfet_01v8 L=0.5u W=1u
M4201 o5 ibias vss vss sky130_fd_pr__nfet_01v8 L=0.5u W=1u
M4202 o5 ibias vss vss sky130_fd_pr__nfet_01v8 L=0.5u W=1u
M4203 o5 ibias vss vss sky130_fd_pr__nfet_01v8 L=0.5u W=1u
M4204 o5 ibias vss vss sky130_fd_pr__nfet_01v8 L=0.5u W=1u
M4205 o5 ibias vss vss sky130_fd_pr__nfet_01v8 L=0.5u W=1u
M4206 o5 ibias vss vss sky130_fd_pr__nfet_01v8 L=0.5u W=1u
M4207 o5 ibias vss vss sky130_fd_pr__nfet_01v8 L=0.5u W=1u
M4208 o5 ibias vss vss sky130_fd_pr__nfet_01v8 L=0.5u W=1u
M4209 o5 ibias vss vss sky130_fd_pr__nfet_01v8 L=0.5u W=1u
M4210 o5 ibias vss vss sky130_fd_pr__nfet_01v8 L=0.5u W=1u
M4211 o5 ibias vss vss sky130_fd_pr__nfet_01v8 L=0.5u W=1u
M4212 o5 ibias vss vss sky130_fd_pr__nfet_01v8 L=0.5u W=1u
M4213 o5 ibias vss vss sky130_fd_pr__nfet_01v8 L=0.5u W=1u
M4214 o5 ibias vss vss sky130_fd_pr__nfet_01v8 L=0.5u W=1u
M4215 o5 ibias vss vss sky130_fd_pr__nfet_01v8 L=0.5u W=1u
M4216 o5 ibias vss vss sky130_fd_pr__nfet_01v8 L=0.5u W=1u
M4217 o5 ibias vss vss sky130_fd_pr__nfet_01v8 L=0.5u W=1u
M4218 o5 ibias vss vss sky130_fd_pr__nfet_01v8 L=0.5u W=1u
M4219 o5 ibias vss vss sky130_fd_pr__nfet_01v8 L=0.5u W=1u
M4220 o5 ibias vss vss sky130_fd_pr__nfet_01v8 L=0.5u W=1u
M4221 o5 ibias vss vss sky130_fd_pr__nfet_01v8 L=0.5u W=1u
M4222 o5 ibias vss vss sky130_fd_pr__nfet_01v8 L=0.5u W=1u
M4223 o5 ibias vss vss sky130_fd_pr__nfet_01v8 L=0.5u W=1u
M4224 o5 ibias vss vss sky130_fd_pr__nfet_01v8 L=0.5u W=1u
M4225 o5 ibias vss vss sky130_fd_pr__nfet_01v8 L=0.5u W=1u
M4226 o5 ibias vss vss sky130_fd_pr__nfet_01v8 L=0.5u W=1u
M4227 o5 ibias vss vss sky130_fd_pr__nfet_01v8 L=0.5u W=1u
M4228 o5 ibias vss vss sky130_fd_pr__nfet_01v8 L=0.5u W=1u
M4229 o5 ibias vss vss sky130_fd_pr__nfet_01v8 L=0.5u W=1u
M4230 o5 ibias vss vss sky130_fd_pr__nfet_01v8 L=0.5u W=1u
M4231 o5 ibias vss vss sky130_fd_pr__nfet_01v8 L=0.5u W=1u
M4232 o5 ibias vss vss sky130_fd_pr__nfet_01v8 L=0.5u W=1u
M4233 o5 ibias vss vss sky130_fd_pr__nfet_01v8 L=0.5u W=1u
M4234 o5 ibias vss vss sky130_fd_pr__nfet_01v8 L=0.5u W=1u
M4235 o5 ibias vss vss sky130_fd_pr__nfet_01v8 L=0.5u W=1u
M4236 o5 ibias vss vss sky130_fd_pr__nfet_01v8 L=0.5u W=1u
M4237 o5 ibias vss vss sky130_fd_pr__nfet_01v8 L=0.5u W=1u
M4238 o5 ibias vss vss sky130_fd_pr__nfet_01v8 L=0.5u W=1u
M4239 o5 ibias vss vss sky130_fd_pr__nfet_01v8 L=0.5u W=1u
M4240 o5 ibias vss vss sky130_fd_pr__nfet_01v8 L=0.5u W=1u
M4241 o5 ibias vss vss sky130_fd_pr__nfet_01v8 L=0.5u W=1u
M4242 o5 ibias vss vss sky130_fd_pr__nfet_01v8 L=0.5u W=1u
M4243 o5 ibias vss vss sky130_fd_pr__nfet_01v8 L=0.5u W=1u
M4244 o5 ibias vss vss sky130_fd_pr__nfet_01v8 L=0.5u W=1u
M4245 o5 ibias vss vss sky130_fd_pr__nfet_01v8 L=0.5u W=1u
M4246 o5 ibias vss vss sky130_fd_pr__nfet_01v8 L=0.5u W=1u
M4247 o5 ibias vss vss sky130_fd_pr__nfet_01v8 L=0.5u W=1u
M4248 o5 ibias vss vss sky130_fd_pr__nfet_01v8 L=0.5u W=1u
M4249 o5 ibias vss vss sky130_fd_pr__nfet_01v8 L=0.5u W=1u
M4250 o5 ibias vss vss sky130_fd_pr__nfet_01v8 L=0.5u W=1u
M4251 o5 ibias vss vss sky130_fd_pr__nfet_01v8 L=0.5u W=1u
M4252 o5 ibias vss vss sky130_fd_pr__nfet_01v8 L=0.5u W=1u
M4253 o5 ibias vss vss sky130_fd_pr__nfet_01v8 L=0.5u W=1u
M4254 o5 ibias vss vss sky130_fd_pr__nfet_01v8 L=0.5u W=1u
M4255 o5 ibias vss vss sky130_fd_pr__nfet_01v8 L=0.5u W=1u
M4256 o5 ibias vss vss sky130_fd_pr__nfet_01v8 L=0.5u W=1u
M4257 o5 ibias vss vss sky130_fd_pr__nfet_01v8 L=0.5u W=1u
M4258 o5 ibias vss vss sky130_fd_pr__nfet_01v8 L=0.5u W=1u
M4259 o5 ibias vss vss sky130_fd_pr__nfet_01v8 L=0.5u W=1u
M4260 o5 ibias vss vss sky130_fd_pr__nfet_01v8 L=0.5u W=1u
M4261 o5 ibias vss vss sky130_fd_pr__nfet_01v8 L=0.5u W=1u
M4262 o5 ibias vss vss sky130_fd_pr__nfet_01v8 L=0.5u W=1u
M4263 o5 ibias vss vss sky130_fd_pr__nfet_01v8 L=0.5u W=1u
M4264 o5 ibias vss vss sky130_fd_pr__nfet_01v8 L=0.5u W=1u
M4265 o5 ibias vss vss sky130_fd_pr__nfet_01v8 L=0.5u W=1u
M4266 o5 ibias vss vss sky130_fd_pr__nfet_01v8 L=0.5u W=1u
M4267 o5 ibias vss vss sky130_fd_pr__nfet_01v8 L=0.5u W=1u
M4268 o5 ibias vss vss sky130_fd_pr__nfet_01v8 L=0.5u W=1u
M4269 o5 ibias vss vss sky130_fd_pr__nfet_01v8 L=0.5u W=1u
M4270 o5 ibias vss vss sky130_fd_pr__nfet_01v8 L=0.5u W=1u
M4271 o5 ibias vss vss sky130_fd_pr__nfet_01v8 L=0.5u W=1u
M4272 o5 ibias vss vss sky130_fd_pr__nfet_01v8 L=0.5u W=1u
M4273 o5 ibias vss vss sky130_fd_pr__nfet_01v8 L=0.5u W=1u
M4274 o5 ibias vss vss sky130_fd_pr__nfet_01v8 L=0.5u W=1u
M4275 o5 ibias vss vss sky130_fd_pr__nfet_01v8 L=0.5u W=1u
M4276 o5 ibias vss vss sky130_fd_pr__nfet_01v8 L=0.5u W=1u
M4277 o5 ibias vss vss sky130_fd_pr__nfet_01v8 L=0.5u W=1u
M4278 o5 ibias vss vss sky130_fd_pr__nfet_01v8 L=0.5u W=1u
M4279 o5 ibias vss vss sky130_fd_pr__nfet_01v8 L=0.5u W=1u
M4280 o5 ibias vss vss sky130_fd_pr__nfet_01v8 L=0.5u W=1u
M4281 o5 ibias vss vss sky130_fd_pr__nfet_01v8 L=0.5u W=1u
M4282 o5 ibias vss vss sky130_fd_pr__nfet_01v8 L=0.5u W=1u
M4283 o5 ibias vss vss sky130_fd_pr__nfet_01v8 L=0.5u W=1u
M4284 o5 ibias vss vss sky130_fd_pr__nfet_01v8 L=0.5u W=1u
M4285 o5 ibias vss vss sky130_fd_pr__nfet_01v8 L=0.5u W=1u
M4286 o5 ibias vss vss sky130_fd_pr__nfet_01v8 L=0.5u W=1u
M4287 o5 ibias vss vss sky130_fd_pr__nfet_01v8 L=0.5u W=1u
M4288 o5 ibias vss vss sky130_fd_pr__nfet_01v8 L=0.5u W=1u
M4289 o5 ibias vss vss sky130_fd_pr__nfet_01v8 L=0.5u W=1u
M4290 o5 ibias vss vss sky130_fd_pr__nfet_01v8 L=0.5u W=1u
M4291 o5 ibias vss vss sky130_fd_pr__nfet_01v8 L=0.5u W=1u
M4292 o5 ibias vss vss sky130_fd_pr__nfet_01v8 L=0.5u W=1u
M4293 o5 ibias vss vss sky130_fd_pr__nfet_01v8 L=0.5u W=1u
M4294 o5 ibias vss vss sky130_fd_pr__nfet_01v8 L=0.5u W=1u
M4295 o5 ibias vss vss sky130_fd_pr__nfet_01v8 L=0.5u W=1u
M4296 o5 ibias vss vss sky130_fd_pr__nfet_01v8 L=0.5u W=1u
M4297 o5 ibias vss vss sky130_fd_pr__nfet_01v8 L=0.5u W=1u
M4298 o5 ibias vss vss sky130_fd_pr__nfet_01v8 L=0.5u W=1u
M4299 o5 ibias vss vss sky130_fd_pr__nfet_01v8 L=0.5u W=1u
M4300 o5 ibias vss vss sky130_fd_pr__nfet_01v8 L=0.5u W=1u
M4301 o5 ibias vss vss sky130_fd_pr__nfet_01v8 L=0.5u W=1u
M4302 o5 ibias vss vss sky130_fd_pr__nfet_01v8 L=0.5u W=1u
M4303 o5 ibias vss vss sky130_fd_pr__nfet_01v8 L=0.5u W=1u
M4304 o5 ibias vss vss sky130_fd_pr__nfet_01v8 L=0.5u W=1u
M4305 o5 ibias vss vss sky130_fd_pr__nfet_01v8 L=0.5u W=1u
M4306 o5 ibias vss vss sky130_fd_pr__nfet_01v8 L=0.5u W=1u
M4307 o5 ibias vss vss sky130_fd_pr__nfet_01v8 L=0.5u W=1u
M4308 o5 ibias vss vss sky130_fd_pr__nfet_01v8 L=0.5u W=1u
M4309 o5 ibias vss vss sky130_fd_pr__nfet_01v8 L=0.5u W=1u
M4310 o5 ibias vss vss sky130_fd_pr__nfet_01v8 L=0.5u W=1u
M4311 o5 ibias vss vss sky130_fd_pr__nfet_01v8 L=0.5u W=1u
M4312 o5 ibias vss vss sky130_fd_pr__nfet_01v8 L=0.5u W=1u
M4313 o5 ibias vss vss sky130_fd_pr__nfet_01v8 L=0.5u W=1u
M4314 o5 ibias vss vss sky130_fd_pr__nfet_01v8 L=0.5u W=1u
M4315 o5 ibias vss vss sky130_fd_pr__nfet_01v8 L=0.5u W=1u
M4316 o5 ibias vss vss sky130_fd_pr__nfet_01v8 L=0.5u W=1u
M4317 o5 ibias vss vss sky130_fd_pr__nfet_01v8 L=0.5u W=1u
M4318 o5 ibias vss vss sky130_fd_pr__nfet_01v8 L=0.5u W=1u
M4319 o5 ibias vss vss sky130_fd_pr__nfet_01v8 L=0.5u W=1u
M4320 o5 ibias vss vss sky130_fd_pr__nfet_01v8 L=0.5u W=1u
M4321 o5 ibias vss vss sky130_fd_pr__nfet_01v8 L=0.5u W=1u
M4322 o5 ibias vss vss sky130_fd_pr__nfet_01v8 L=0.5u W=1u
M4323 o5 ibias vss vss sky130_fd_pr__nfet_01v8 L=0.5u W=1u
M4324 o5 ibias vss vss sky130_fd_pr__nfet_01v8 L=0.5u W=1u
M4325 o5 ibias vss vss sky130_fd_pr__nfet_01v8 L=0.5u W=1u
M4326 o5 ibias vss vss sky130_fd_pr__nfet_01v8 L=0.5u W=1u
M4327 o5 ibias vss vss sky130_fd_pr__nfet_01v8 L=0.5u W=1u
M4328 o5 ibias vss vss sky130_fd_pr__nfet_01v8 L=0.5u W=1u
M4329 o5 ibias vss vss sky130_fd_pr__nfet_01v8 L=0.5u W=1u
M4330 o5 ibias vss vss sky130_fd_pr__nfet_01v8 L=0.5u W=1u
M4331 o5 ibias vss vss sky130_fd_pr__nfet_01v8 L=0.5u W=1u
M4332 o5 ibias vss vss sky130_fd_pr__nfet_01v8 L=0.5u W=1u
M4333 o5 ibias vss vss sky130_fd_pr__nfet_01v8 L=0.5u W=1u
M4334 o5 ibias vss vss sky130_fd_pr__nfet_01v8 L=0.5u W=1u
M4335 o5 ibias vss vss sky130_fd_pr__nfet_01v8 L=0.5u W=1u
M4336 o5 ibias vss vss sky130_fd_pr__nfet_01v8 L=0.5u W=1u
M4337 o5 ibias vss vss sky130_fd_pr__nfet_01v8 L=0.5u W=1u
M4338 o5 ibias vss vss sky130_fd_pr__nfet_01v8 L=0.5u W=1u
M4339 o5 ibias vss vss sky130_fd_pr__nfet_01v8 L=0.5u W=1u
M4340 o5 ibias vss vss sky130_fd_pr__nfet_01v8 L=0.5u W=1u
M4341 o5 ibias vss vss sky130_fd_pr__nfet_01v8 L=0.5u W=1u
M4342 o5 ibias vss vss sky130_fd_pr__nfet_01v8 L=0.5u W=1u
M4343 o5 ibias vss vss sky130_fd_pr__nfet_01v8 L=0.5u W=1u
M4344 o5 ibias vss vss sky130_fd_pr__nfet_01v8 L=0.5u W=1u
M4345 o5 ibias vss vss sky130_fd_pr__nfet_01v8 L=0.5u W=1u
M4346 o5 ibias vss vss sky130_fd_pr__nfet_01v8 L=0.5u W=1u
M4347 o5 ibias vss vss sky130_fd_pr__nfet_01v8 L=0.5u W=1u
M4348 o5 ibias vss vss sky130_fd_pr__nfet_01v8 L=0.5u W=1u
M4349 o5 ibias vss vss sky130_fd_pr__nfet_01v8 L=0.5u W=1u
M4350 o5 ibias vss vss sky130_fd_pr__nfet_01v8 L=0.5u W=1u
M4351 o5 ibias vss vss sky130_fd_pr__nfet_01v8 L=0.5u W=1u
M4352 o5 ibias vss vss sky130_fd_pr__nfet_01v8 L=0.5u W=1u
M4353 o5 ibias vss vss sky130_fd_pr__nfet_01v8 L=0.5u W=1u
M4354 o5 ibias vss vss sky130_fd_pr__nfet_01v8 L=0.5u W=1u
M4355 o5 ibias vss vss sky130_fd_pr__nfet_01v8 L=0.5u W=1u
M4356 o5 ibias vss vss sky130_fd_pr__nfet_01v8 L=0.5u W=1u
M4357 o5 ibias vss vss sky130_fd_pr__nfet_01v8 L=0.5u W=1u
M4358 o5 ibias vss vss sky130_fd_pr__nfet_01v8 L=0.5u W=1u
M4359 o5 ibias vss vss sky130_fd_pr__nfet_01v8 L=0.5u W=1u
M4360 o5 ibias vss vss sky130_fd_pr__nfet_01v8 L=0.5u W=1u
M4361 o5 ibias vss vss sky130_fd_pr__nfet_01v8 L=0.5u W=1u
M4362 o5 ibias vss vss sky130_fd_pr__nfet_01v8 L=0.5u W=1u
M4363 o5 ibias vss vss sky130_fd_pr__nfet_01v8 L=0.5u W=1u
M4364 o5 ibias vss vss sky130_fd_pr__nfet_01v8 L=0.5u W=1u
M4365 o5 ibias vss vss sky130_fd_pr__nfet_01v8 L=0.5u W=1u
M4366 o5 ibias vss vss sky130_fd_pr__nfet_01v8 L=0.5u W=1u
M4367 o5 ibias vss vss sky130_fd_pr__nfet_01v8 L=0.5u W=1u
M4368 o5 ibias vss vss sky130_fd_pr__nfet_01v8 L=0.5u W=1u
M4369 o5 ibias vss vss sky130_fd_pr__nfet_01v8 L=0.5u W=1u
M4370 o5 ibias vss vss sky130_fd_pr__nfet_01v8 L=0.5u W=1u
M4371 o5 ibias vss vss sky130_fd_pr__nfet_01v8 L=0.5u W=1u
M4372 o5 ibias vss vss sky130_fd_pr__nfet_01v8 L=0.5u W=1u
M4373 o5 ibias vss vss sky130_fd_pr__nfet_01v8 L=0.5u W=1u
M4374 o5 ibias vss vss sky130_fd_pr__nfet_01v8 L=0.5u W=1u
M4375 o5 ibias vss vss sky130_fd_pr__nfet_01v8 L=0.5u W=1u
M4376 o5 ibias vss vss sky130_fd_pr__nfet_01v8 L=0.5u W=1u
M4377 o5 ibias vss vss sky130_fd_pr__nfet_01v8 L=0.5u W=1u
M4378 o5 ibias vss vss sky130_fd_pr__nfet_01v8 L=0.5u W=1u
M4379 o5 ibias vss vss sky130_fd_pr__nfet_01v8 L=0.5u W=1u
M4380 o5 ibias vss vss sky130_fd_pr__nfet_01v8 L=0.5u W=1u
M4381 o5 ibias vss vss sky130_fd_pr__nfet_01v8 L=0.5u W=1u
M4382 o5 ibias vss vss sky130_fd_pr__nfet_01v8 L=0.5u W=1u
M4383 o5 ibias vss vss sky130_fd_pr__nfet_01v8 L=0.5u W=1u
M4384 o5 ibias vss vss sky130_fd_pr__nfet_01v8 L=0.5u W=1u
M4385 o5 ibias vss vss sky130_fd_pr__nfet_01v8 L=0.5u W=1u
M4386 o5 ibias vss vss sky130_fd_pr__nfet_01v8 L=0.5u W=1u
M4387 o5 ibias vss vss sky130_fd_pr__nfet_01v8 L=0.5u W=1u
M4388 o5 ibias vss vss sky130_fd_pr__nfet_01v8 L=0.5u W=1u
M4389 o5 ibias vss vss sky130_fd_pr__nfet_01v8 L=0.5u W=1u
M4390 o5 ibias vss vss sky130_fd_pr__nfet_01v8 L=0.5u W=1u
M4391 o5 ibias vss vss sky130_fd_pr__nfet_01v8 L=0.5u W=1u
M4392 o5 ibias vss vss sky130_fd_pr__nfet_01v8 L=0.5u W=1u
M4393 o5 ibias vss vss sky130_fd_pr__nfet_01v8 L=0.5u W=1u
M4394 o5 ibias vss vss sky130_fd_pr__nfet_01v8 L=0.5u W=1u
M4395 o5 ibias vss vss sky130_fd_pr__nfet_01v8 L=0.5u W=1u
M4396 o5 ibias vss vss sky130_fd_pr__nfet_01v8 L=0.5u W=1u
M4397 o5 ibias vss vss sky130_fd_pr__nfet_01v8 L=0.5u W=1u
M4398 o5 ibias vss vss sky130_fd_pr__nfet_01v8 L=0.5u W=1u
M4399 o5 ibias vss vss sky130_fd_pr__nfet_01v8 L=0.5u W=1u
M4400 o5 ibias vss vss sky130_fd_pr__nfet_01v8 L=0.5u W=1u
M4401 o5 ibias vss vss sky130_fd_pr__nfet_01v8 L=0.5u W=1u
M4402 o5 ibias vss vss sky130_fd_pr__nfet_01v8 L=0.5u W=1u
M4403 o5 ibias vss vss sky130_fd_pr__nfet_01v8 L=0.5u W=1u
M4404 o5 ibias vss vss sky130_fd_pr__nfet_01v8 L=0.5u W=1u
M4405 o5 ibias vss vss sky130_fd_pr__nfet_01v8 L=0.5u W=1u
M4406 o5 ibias vss vss sky130_fd_pr__nfet_01v8 L=0.5u W=1u
M4407 o5 ibias vss vss sky130_fd_pr__nfet_01v8 L=0.5u W=1u
M4408 o5 ibias vss vss sky130_fd_pr__nfet_01v8 L=0.5u W=1u
M4409 o5 ibias vss vss sky130_fd_pr__nfet_01v8 L=0.5u W=1u
M4410 o5 ibias vss vss sky130_fd_pr__nfet_01v8 L=0.5u W=1u
M4411 o5 ibias vss vss sky130_fd_pr__nfet_01v8 L=0.5u W=1u
M4412 o5 ibias vss vss sky130_fd_pr__nfet_01v8 L=0.5u W=1u
M4413 o5 ibias vss vss sky130_fd_pr__nfet_01v8 L=0.5u W=1u
M4414 o5 ibias vss vss sky130_fd_pr__nfet_01v8 L=0.5u W=1u
M4415 o5 ibias vss vss sky130_fd_pr__nfet_01v8 L=0.5u W=1u
M4416 o5 ibias vss vss sky130_fd_pr__nfet_01v8 L=0.5u W=1u
M4417 o5 ibias vss vss sky130_fd_pr__nfet_01v8 L=0.5u W=1u
M4418 o5 ibias vss vss sky130_fd_pr__nfet_01v8 L=0.5u W=1u
M4419 o5 ibias vss vss sky130_fd_pr__nfet_01v8 L=0.5u W=1u
M4420 o5 ibias vss vss sky130_fd_pr__nfet_01v8 L=0.5u W=1u
M4421 o5 ibias vss vss sky130_fd_pr__nfet_01v8 L=0.5u W=1u
M4422 o5 ibias vss vss sky130_fd_pr__nfet_01v8 L=0.5u W=1u
M4423 o5 ibias vss vss sky130_fd_pr__nfet_01v8 L=0.5u W=1u
M4424 o5 ibias vss vss sky130_fd_pr__nfet_01v8 L=0.5u W=1u
M4425 o5 ibias vss vss sky130_fd_pr__nfet_01v8 L=0.5u W=1u
M4426 o5 ibias vss vss sky130_fd_pr__nfet_01v8 L=0.5u W=1u
M4427 o5 ibias vss vss sky130_fd_pr__nfet_01v8 L=0.5u W=1u
M4428 o5 ibias vss vss sky130_fd_pr__nfet_01v8 L=0.5u W=1u
M4429 o5 ibias vss vss sky130_fd_pr__nfet_01v8 L=0.5u W=1u
M4430 o5 ibias vss vss sky130_fd_pr__nfet_01v8 L=0.5u W=1u
M4431 o5 ibias vss vss sky130_fd_pr__nfet_01v8 L=0.5u W=1u
M4432 o5 ibias vss vss sky130_fd_pr__nfet_01v8 L=0.5u W=1u
M4433 o5 ibias vss vss sky130_fd_pr__nfet_01v8 L=0.5u W=1u
M4434 o5 ibias vss vss sky130_fd_pr__nfet_01v8 L=0.5u W=1u
M4435 o5 ibias vss vss sky130_fd_pr__nfet_01v8 L=0.5u W=1u
M4436 o5 ibias vss vss sky130_fd_pr__nfet_01v8 L=0.5u W=1u
M4437 o5 ibias vss vss sky130_fd_pr__nfet_01v8 L=0.5u W=1u
M4438 o5 ibias vss vss sky130_fd_pr__nfet_01v8 L=0.5u W=1u
M4439 o5 ibias vss vss sky130_fd_pr__nfet_01v8 L=0.5u W=1u
M4440 o5 ibias vss vss sky130_fd_pr__nfet_01v8 L=0.5u W=1u
M4441 o5 ibias vss vss sky130_fd_pr__nfet_01v8 L=0.5u W=1u
M4442 o5 ibias vss vss sky130_fd_pr__nfet_01v8 L=0.5u W=1u
M4443 o5 ibias vss vss sky130_fd_pr__nfet_01v8 L=0.5u W=1u
M4444 o5 ibias vss vss sky130_fd_pr__nfet_01v8 L=0.5u W=1u
M4445 o5 ibias vss vss sky130_fd_pr__nfet_01v8 L=0.5u W=1u
M4446 o5 ibias vss vss sky130_fd_pr__nfet_01v8 L=0.5u W=1u
M4447 o5 ibias vss vss sky130_fd_pr__nfet_01v8 L=0.5u W=1u
M4448 o5 ibias vss vss sky130_fd_pr__nfet_01v8 L=0.5u W=1u
M4449 o5 ibias vss vss sky130_fd_pr__nfet_01v8 L=0.5u W=1u
M4450 o5 ibias vss vss sky130_fd_pr__nfet_01v8 L=0.5u W=1u
M4451 o5 ibias vss vss sky130_fd_pr__nfet_01v8 L=0.5u W=1u
M4452 o5 ibias vss vss sky130_fd_pr__nfet_01v8 L=0.5u W=1u
M4453 o5 ibias vss vss sky130_fd_pr__nfet_01v8 L=0.5u W=1u
M4454 o5 ibias vss vss sky130_fd_pr__nfet_01v8 L=0.5u W=1u
M4455 o5 ibias vss vss sky130_fd_pr__nfet_01v8 L=0.5u W=1u
M4456 o5 ibias vss vss sky130_fd_pr__nfet_01v8 L=0.5u W=1u
M4457 o5 ibias vss vss sky130_fd_pr__nfet_01v8 L=0.5u W=1u
M4458 o5 ibias vss vss sky130_fd_pr__nfet_01v8 L=0.5u W=1u
M4459 o5 ibias vss vss sky130_fd_pr__nfet_01v8 L=0.5u W=1u
M4460 o5 ibias vss vss sky130_fd_pr__nfet_01v8 L=0.5u W=1u
M4461 o5 ibias vss vss sky130_fd_pr__nfet_01v8 L=0.5u W=1u
M4462 o5 ibias vss vss sky130_fd_pr__nfet_01v8 L=0.5u W=1u
M4463 o5 ibias vss vss sky130_fd_pr__nfet_01v8 L=0.5u W=1u
M4464 o5 ibias vss vss sky130_fd_pr__nfet_01v8 L=0.5u W=1u
M4465 o5 ibias vss vss sky130_fd_pr__nfet_01v8 L=0.5u W=1u
M4466 o5 ibias vss vss sky130_fd_pr__nfet_01v8 L=0.5u W=1u
M4467 o5 ibias vss vss sky130_fd_pr__nfet_01v8 L=0.5u W=1u
M4468 o5 ibias vss vss sky130_fd_pr__nfet_01v8 L=0.5u W=1u
M4469 o5 ibias vss vss sky130_fd_pr__nfet_01v8 L=0.5u W=1u
M4470 o5 ibias vss vss sky130_fd_pr__nfet_01v8 L=0.5u W=1u
M4471 o5 ibias vss vss sky130_fd_pr__nfet_01v8 L=0.5u W=1u
M4472 o5 ibias vss vss sky130_fd_pr__nfet_01v8 L=0.5u W=1u
M4473 o5 ibias vss vss sky130_fd_pr__nfet_01v8 L=0.5u W=1u
M4474 o5 ibias vss vss sky130_fd_pr__nfet_01v8 L=0.5u W=1u
M4475 o5 ibias vss vss sky130_fd_pr__nfet_01v8 L=0.5u W=1u
M4476 o5 ibias vss vss sky130_fd_pr__nfet_01v8 L=0.5u W=1u
M4477 o5 ibias vss vss sky130_fd_pr__nfet_01v8 L=0.5u W=1u
M4478 o5 ibias vss vss sky130_fd_pr__nfet_01v8 L=0.5u W=1u
M4479 o5 ibias vss vss sky130_fd_pr__nfet_01v8 L=0.5u W=1u
M4480 o5 ibias vss vss sky130_fd_pr__nfet_01v8 L=0.5u W=1u
M4481 o5 ibias vss vss sky130_fd_pr__nfet_01v8 L=0.5u W=1u
M4482 o5 ibias vss vss sky130_fd_pr__nfet_01v8 L=0.5u W=1u
M4483 o5 ibias vss vss sky130_fd_pr__nfet_01v8 L=0.5u W=1u
M4484 o5 ibias vss vss sky130_fd_pr__nfet_01v8 L=0.5u W=1u
M4485 o5 ibias vss vss sky130_fd_pr__nfet_01v8 L=0.5u W=1u
M4486 o5 ibias vss vss sky130_fd_pr__nfet_01v8 L=0.5u W=1u
M4487 o5 ibias vss vss sky130_fd_pr__nfet_01v8 L=0.5u W=1u
M4488 o5 ibias vss vss sky130_fd_pr__nfet_01v8 L=0.5u W=1u
M4489 o5 ibias vss vss sky130_fd_pr__nfet_01v8 L=0.5u W=1u
M4490 o5 ibias vss vss sky130_fd_pr__nfet_01v8 L=0.5u W=1u
M4491 o5 ibias vss vss sky130_fd_pr__nfet_01v8 L=0.5u W=1u
M4492 o5 ibias vss vss sky130_fd_pr__nfet_01v8 L=0.5u W=1u
M4493 o5 ibias vss vss sky130_fd_pr__nfet_01v8 L=0.5u W=1u
M4494 o5 ibias vss vss sky130_fd_pr__nfet_01v8 L=0.5u W=1u
M4495 o5 ibias vss vss sky130_fd_pr__nfet_01v8 L=0.5u W=1u
M4496 o5 ibias vss vss sky130_fd_pr__nfet_01v8 L=0.5u W=1u
M4497 o5 ibias vss vss sky130_fd_pr__nfet_01v8 L=0.5u W=1u
M4498 o5 ibias vss vss sky130_fd_pr__nfet_01v8 L=0.5u W=1u
M4499 o5 ibias vss vss sky130_fd_pr__nfet_01v8 L=0.5u W=1u
M4500 o5 ibias vss vss sky130_fd_pr__nfet_01v8 L=0.5u W=1u
M4501 o5 ibias vss vss sky130_fd_pr__nfet_01v8 L=0.5u W=1u
M4502 o5 ibias vss vss sky130_fd_pr__nfet_01v8 L=0.5u W=1u
M4503 o5 ibias vss vss sky130_fd_pr__nfet_01v8 L=0.5u W=1u
M4504 o5 ibias vss vss sky130_fd_pr__nfet_01v8 L=0.5u W=1u
M4505 o5 ibias vss vss sky130_fd_pr__nfet_01v8 L=0.5u W=1u
M4506 o5 ibias vss vss sky130_fd_pr__nfet_01v8 L=0.5u W=1u
M4507 o5 ibias vss vss sky130_fd_pr__nfet_01v8 L=0.5u W=1u
M4508 o5 ibias vss vss sky130_fd_pr__nfet_01v8 L=0.5u W=1u
M4509 o5 ibias vss vss sky130_fd_pr__nfet_01v8 L=0.5u W=1u
M4510 o5 ibias vss vss sky130_fd_pr__nfet_01v8 L=0.5u W=1u
M4511 o5 ibias vss vss sky130_fd_pr__nfet_01v8 L=0.5u W=1u
M4512 o5 ibias vss vss sky130_fd_pr__nfet_01v8 L=0.5u W=1u
M4513 o5 ibias vss vss sky130_fd_pr__nfet_01v8 L=0.5u W=1u
M4514 o5 ibias vss vss sky130_fd_pr__nfet_01v8 L=0.5u W=1u
M4515 o5 ibias vss vss sky130_fd_pr__nfet_01v8 L=0.5u W=1u
M4516 o5 ibias vss vss sky130_fd_pr__nfet_01v8 L=0.5u W=1u
M4517 o5 ibias vss vss sky130_fd_pr__nfet_01v8 L=0.5u W=1u
M4518 o5 ibias vss vss sky130_fd_pr__nfet_01v8 L=0.5u W=1u
M4519 o5 ibias vss vss sky130_fd_pr__nfet_01v8 L=0.5u W=1u
M4520 o5 ibias vss vss sky130_fd_pr__nfet_01v8 L=0.5u W=1u
M4521 o5 ibias vss vss sky130_fd_pr__nfet_01v8 L=0.5u W=1u
M4522 o5 ibias vss vss sky130_fd_pr__nfet_01v8 L=0.5u W=1u
M4523 o5 ibias vss vss sky130_fd_pr__nfet_01v8 L=0.5u W=1u
M4524 o5 ibias vss vss sky130_fd_pr__nfet_01v8 L=0.5u W=1u
M4525 o5 ibias vss vss sky130_fd_pr__nfet_01v8 L=0.5u W=1u
M4526 o5 ibias vss vss sky130_fd_pr__nfet_01v8 L=0.5u W=1u
M4527 o5 ibias vss vss sky130_fd_pr__nfet_01v8 L=0.5u W=1u
M4528 o5 ibias vss vss sky130_fd_pr__nfet_01v8 L=0.5u W=1u
M4529 o5 ibias vss vss sky130_fd_pr__nfet_01v8 L=0.5u W=1u
M4530 o5 ibias vss vss sky130_fd_pr__nfet_01v8 L=0.5u W=1u
M4531 o5 ibias vss vss sky130_fd_pr__nfet_01v8 L=0.5u W=1u
M4532 o5 ibias vss vss sky130_fd_pr__nfet_01v8 L=0.5u W=1u
M4533 o5 ibias vss vss sky130_fd_pr__nfet_01v8 L=0.5u W=1u
M4534 o5 ibias vss vss sky130_fd_pr__nfet_01v8 L=0.5u W=1u
M4535 o5 ibias vss vss sky130_fd_pr__nfet_01v8 L=0.5u W=1u
M4536 o5 ibias vss vss sky130_fd_pr__nfet_01v8 L=0.5u W=1u
M4537 o5 ibias vss vss sky130_fd_pr__nfet_01v8 L=0.5u W=1u
M4538 o5 ibias vss vss sky130_fd_pr__nfet_01v8 L=0.5u W=1u
M4539 o5 ibias vss vss sky130_fd_pr__nfet_01v8 L=0.5u W=1u
M4540 o5 ibias vss vss sky130_fd_pr__nfet_01v8 L=0.5u W=1u
M4541 o5 ibias vss vss sky130_fd_pr__nfet_01v8 L=0.5u W=1u
M4542 o5 ibias vss vss sky130_fd_pr__nfet_01v8 L=0.5u W=1u
M4543 o5 ibias vss vss sky130_fd_pr__nfet_01v8 L=0.5u W=1u
M4544 o5 ibias vss vss sky130_fd_pr__nfet_01v8 L=0.5u W=1u
M4545 o5 ibias vss vss sky130_fd_pr__nfet_01v8 L=0.5u W=1u
M4546 o5 ibias vss vss sky130_fd_pr__nfet_01v8 L=0.5u W=1u
M4547 o5 ibias vss vss sky130_fd_pr__nfet_01v8 L=0.5u W=1u
M4548 o5 ibias vss vss sky130_fd_pr__nfet_01v8 L=0.5u W=1u
M4549 o5 ibias vss vss sky130_fd_pr__nfet_01v8 L=0.5u W=1u
M4550 o5 ibias vss vss sky130_fd_pr__nfet_01v8 L=0.5u W=1u
M4551 o5 ibias vss vss sky130_fd_pr__nfet_01v8 L=0.5u W=1u
M4552 o5 ibias vss vss sky130_fd_pr__nfet_01v8 L=0.5u W=1u
M4553 o5 ibias vss vss sky130_fd_pr__nfet_01v8 L=0.5u W=1u
M4554 o5 ibias vss vss sky130_fd_pr__nfet_01v8 L=0.5u W=1u
M4555 o5 ibias vss vss sky130_fd_pr__nfet_01v8 L=0.5u W=1u
M4556 o5 ibias vss vss sky130_fd_pr__nfet_01v8 L=0.5u W=1u
M4557 o5 ibias vss vss sky130_fd_pr__nfet_01v8 L=0.5u W=1u
M4558 o5 ibias vss vss sky130_fd_pr__nfet_01v8 L=0.5u W=1u
M4559 o5 ibias vss vss sky130_fd_pr__nfet_01v8 L=0.5u W=1u
M4560 o5 ibias vss vss sky130_fd_pr__nfet_01v8 L=0.5u W=1u
M4561 o5 ibias vss vss sky130_fd_pr__nfet_01v8 L=0.5u W=1u
M4562 o5 ibias vss vss sky130_fd_pr__nfet_01v8 L=0.5u W=1u
M4563 o5 ibias vss vss sky130_fd_pr__nfet_01v8 L=0.5u W=1u
M4564 o5 ibias vss vss sky130_fd_pr__nfet_01v8 L=0.5u W=1u
M4565 o5 ibias vss vss sky130_fd_pr__nfet_01v8 L=0.5u W=1u
M4566 o5 ibias vss vss sky130_fd_pr__nfet_01v8 L=0.5u W=1u
M4567 o5 ibias vss vss sky130_fd_pr__nfet_01v8 L=0.5u W=1u
M4568 o5 ibias vss vss sky130_fd_pr__nfet_01v8 L=0.5u W=1u
M4569 o5 ibias vss vss sky130_fd_pr__nfet_01v8 L=0.5u W=1u
M4570 o5 ibias vss vss sky130_fd_pr__nfet_01v8 L=0.5u W=1u
M4571 o5 ibias vss vss sky130_fd_pr__nfet_01v8 L=0.5u W=1u
M4572 o5 ibias vss vss sky130_fd_pr__nfet_01v8 L=0.5u W=1u
M4573 o5 ibias vss vss sky130_fd_pr__nfet_01v8 L=0.5u W=1u
M4574 o5 ibias vss vss sky130_fd_pr__nfet_01v8 L=0.5u W=1u
M4575 o5 ibias vss vss sky130_fd_pr__nfet_01v8 L=0.5u W=1u
M4576 o5 ibias vss vss sky130_fd_pr__nfet_01v8 L=0.5u W=1u
M4577 o5 ibias vss vss sky130_fd_pr__nfet_01v8 L=0.5u W=1u
M4578 o5 ibias vss vss sky130_fd_pr__nfet_01v8 L=0.5u W=1u
M4579 o5 ibias vss vss sky130_fd_pr__nfet_01v8 L=0.5u W=1u
M4580 o5 ibias vss vss sky130_fd_pr__nfet_01v8 L=0.5u W=1u
M4581 o5 ibias vss vss sky130_fd_pr__nfet_01v8 L=0.5u W=1u
M4582 o5 ibias vss vss sky130_fd_pr__nfet_01v8 L=0.5u W=1u
M4583 o5 ibias vss vss sky130_fd_pr__nfet_01v8 L=0.5u W=1u
M4584 o5 ibias vss vss sky130_fd_pr__nfet_01v8 L=0.5u W=1u
M4585 o5 ibias vss vss sky130_fd_pr__nfet_01v8 L=0.5u W=1u
M4586 o5 ibias vss vss sky130_fd_pr__nfet_01v8 L=0.5u W=1u
M4587 o5 ibias vss vss sky130_fd_pr__nfet_01v8 L=0.5u W=1u
M4588 o5 ibias vss vss sky130_fd_pr__nfet_01v8 L=0.5u W=1u
M4589 o5 ibias vss vss sky130_fd_pr__nfet_01v8 L=0.5u W=1u
M4590 o5 ibias vss vss sky130_fd_pr__nfet_01v8 L=0.5u W=1u
M4591 o5 ibias vss vss sky130_fd_pr__nfet_01v8 L=0.5u W=1u
M4592 o5 ibias vss vss sky130_fd_pr__nfet_01v8 L=0.5u W=1u
M4593 o5 ibias vss vss sky130_fd_pr__nfet_01v8 L=0.5u W=1u
M4594 o5 ibias vss vss sky130_fd_pr__nfet_01v8 L=0.5u W=1u
M4595 o5 ibias vss vss sky130_fd_pr__nfet_01v8 L=0.5u W=1u
M4596 o5 ibias vss vss sky130_fd_pr__nfet_01v8 L=0.5u W=1u
M4597 o5 ibias vss vss sky130_fd_pr__nfet_01v8 L=0.5u W=1u
M4598 o5 ibias vss vss sky130_fd_pr__nfet_01v8 L=0.5u W=1u
M4599 o5 ibias vss vss sky130_fd_pr__nfet_01v8 L=0.5u W=1u
M4600 o5 ibias vss vss sky130_fd_pr__nfet_01v8 L=0.5u W=1u
M4601 o5 ibias vss vss sky130_fd_pr__nfet_01v8 L=0.5u W=1u
M4602 o5 ibias vss vss sky130_fd_pr__nfet_01v8 L=0.5u W=1u
M4603 o5 ibias vss vss sky130_fd_pr__nfet_01v8 L=0.5u W=1u
M4604 o5 ibias vss vss sky130_fd_pr__nfet_01v8 L=0.5u W=1u
M4605 o5 ibias vss vss sky130_fd_pr__nfet_01v8 L=0.5u W=1u
M4606 o5 ibias vss vss sky130_fd_pr__nfet_01v8 L=0.5u W=1u
M4607 o5 ibias vss vss sky130_fd_pr__nfet_01v8 L=0.5u W=1u
M4608 o5 ibias vss vss sky130_fd_pr__nfet_01v8 L=0.5u W=1u
M4609 o5 ibias vss vss sky130_fd_pr__nfet_01v8 L=0.5u W=1u
M4610 o5 ibias vss vss sky130_fd_pr__nfet_01v8 L=0.5u W=1u
M4611 o5 ibias vss vss sky130_fd_pr__nfet_01v8 L=0.5u W=1u
M4612 o5 ibias vss vss sky130_fd_pr__nfet_01v8 L=0.5u W=1u
M4613 o5 ibias vss vss sky130_fd_pr__nfet_01v8 L=0.5u W=1u
M4614 o5 ibias vss vss sky130_fd_pr__nfet_01v8 L=0.5u W=1u
M4615 o5 ibias vss vss sky130_fd_pr__nfet_01v8 L=0.5u W=1u
M4616 o5 ibias vss vss sky130_fd_pr__nfet_01v8 L=0.5u W=1u
M4617 o5 ibias vss vss sky130_fd_pr__nfet_01v8 L=0.5u W=1u
M4618 o5 ibias vss vss sky130_fd_pr__nfet_01v8 L=0.5u W=1u
M4619 o5 ibias vss vss sky130_fd_pr__nfet_01v8 L=0.5u W=1u
M4620 o5 ibias vss vss sky130_fd_pr__nfet_01v8 L=0.5u W=1u
M4621 o5 ibias vss vss sky130_fd_pr__nfet_01v8 L=0.5u W=1u
M4622 o5 ibias vss vss sky130_fd_pr__nfet_01v8 L=0.5u W=1u
M4623 o5 ibias vss vss sky130_fd_pr__nfet_01v8 L=0.5u W=1u
M4624 o5 ibias vss vss sky130_fd_pr__nfet_01v8 L=0.5u W=1u
M4625 o5 ibias vss vss sky130_fd_pr__nfet_01v8 L=0.5u W=1u
M4626 o5 ibias vss vss sky130_fd_pr__nfet_01v8 L=0.5u W=1u
M4627 o5 ibias vss vss sky130_fd_pr__nfet_01v8 L=0.5u W=1u
M4628 o5 ibias vss vss sky130_fd_pr__nfet_01v8 L=0.5u W=1u
M4629 o5 ibias vss vss sky130_fd_pr__nfet_01v8 L=0.5u W=1u
M4630 o5 ibias vss vss sky130_fd_pr__nfet_01v8 L=0.5u W=1u
M4631 o5 ibias vss vss sky130_fd_pr__nfet_01v8 L=0.5u W=1u
M4632 o5 ibias vss vss sky130_fd_pr__nfet_01v8 L=0.5u W=1u
M4633 o5 ibias vss vss sky130_fd_pr__nfet_01v8 L=0.5u W=1u
M4634 o5 ibias vss vss sky130_fd_pr__nfet_01v8 L=0.5u W=1u
M4635 o5 ibias vss vss sky130_fd_pr__nfet_01v8 L=0.5u W=1u
M4636 o5 ibias vss vss sky130_fd_pr__nfet_01v8 L=0.5u W=1u
M4637 o5 ibias vss vss sky130_fd_pr__nfet_01v8 L=0.5u W=1u
M4638 o5 ibias vss vss sky130_fd_pr__nfet_01v8 L=0.5u W=1u
M4639 o5 ibias vss vss sky130_fd_pr__nfet_01v8 L=0.5u W=1u
M4640 o5 ibias vss vss sky130_fd_pr__nfet_01v8 L=0.5u W=1u
M4641 o5 ibias vss vss sky130_fd_pr__nfet_01v8 L=0.5u W=1u
M4642 o5 ibias vss vss sky130_fd_pr__nfet_01v8 L=0.5u W=1u
M4643 o5 ibias vss vss sky130_fd_pr__nfet_01v8 L=0.5u W=1u
M4644 o5 ibias vss vss sky130_fd_pr__nfet_01v8 L=0.5u W=1u
M4645 o5 ibias vss vss sky130_fd_pr__nfet_01v8 L=0.5u W=1u
M4646 o5 ibias vss vss sky130_fd_pr__nfet_01v8 L=0.5u W=1u
M4647 o5 ibias vss vss sky130_fd_pr__nfet_01v8 L=0.5u W=1u
M4648 o5 ibias vss vss sky130_fd_pr__nfet_01v8 L=0.5u W=1u
M4649 o5 ibias vss vss sky130_fd_pr__nfet_01v8 L=0.5u W=1u
M4650 o5 ibias vss vss sky130_fd_pr__nfet_01v8 L=0.5u W=1u
M4651 o5 ibias vss vss sky130_fd_pr__nfet_01v8 L=0.5u W=1u
M4652 o5 ibias vss vss sky130_fd_pr__nfet_01v8 L=0.5u W=1u
M4653 o5 ibias vss vss sky130_fd_pr__nfet_01v8 L=0.5u W=1u
M4654 o5 ibias vss vss sky130_fd_pr__nfet_01v8 L=0.5u W=1u
M4655 o5 ibias vss vss sky130_fd_pr__nfet_01v8 L=0.5u W=1u
M4656 o5 ibias vss vss sky130_fd_pr__nfet_01v8 L=0.5u W=1u
M4657 o5 ibias vss vss sky130_fd_pr__nfet_01v8 L=0.5u W=1u
M4658 o5 ibias vss vss sky130_fd_pr__nfet_01v8 L=0.5u W=1u
M4659 o5 ibias vss vss sky130_fd_pr__nfet_01v8 L=0.5u W=1u
M4660 o5 ibias vss vss sky130_fd_pr__nfet_01v8 L=0.5u W=1u
M4661 o5 ibias vss vss sky130_fd_pr__nfet_01v8 L=0.5u W=1u
M4662 o5 ibias vss vss sky130_fd_pr__nfet_01v8 L=0.5u W=1u
M4663 o5 ibias vss vss sky130_fd_pr__nfet_01v8 L=0.5u W=1u
M4664 o5 ibias vss vss sky130_fd_pr__nfet_01v8 L=0.5u W=1u
M4665 o5 ibias vss vss sky130_fd_pr__nfet_01v8 L=0.5u W=1u
M4666 o5 ibias vss vss sky130_fd_pr__nfet_01v8 L=0.5u W=1u
M4667 o5 ibias vss vss sky130_fd_pr__nfet_01v8 L=0.5u W=1u
M4668 o5 ibias vss vss sky130_fd_pr__nfet_01v8 L=0.5u W=1u
M4669 o5 ibias vss vss sky130_fd_pr__nfet_01v8 L=0.5u W=1u
M4670 o5 ibias vss vss sky130_fd_pr__nfet_01v8 L=0.5u W=1u
M4671 o5 ibias vss vss sky130_fd_pr__nfet_01v8 L=0.5u W=1u
M4672 o5 ibias vss vss sky130_fd_pr__nfet_01v8 L=0.5u W=1u
M4673 o5 ibias vss vss sky130_fd_pr__nfet_01v8 L=0.5u W=1u
M4674 o5 ibias vss vss sky130_fd_pr__nfet_01v8 L=0.5u W=1u
M4675 o5 ibias vss vss sky130_fd_pr__nfet_01v8 L=0.5u W=1u
M4676 o5 ibias vss vss sky130_fd_pr__nfet_01v8 L=0.5u W=1u
M4677 o5 ibias vss vss sky130_fd_pr__nfet_01v8 L=0.5u W=1u
M4678 o5 ibias vss vss sky130_fd_pr__nfet_01v8 L=0.5u W=1u
M4679 o5 ibias vss vss sky130_fd_pr__nfet_01v8 L=0.5u W=1u
M4680 o5 ibias vss vss sky130_fd_pr__nfet_01v8 L=0.5u W=1u
M4681 o5 ibias vss vss sky130_fd_pr__nfet_01v8 L=0.5u W=1u
M4682 o5 ibias vss vss sky130_fd_pr__nfet_01v8 L=0.5u W=1u
M4683 o5 ibias vss vss sky130_fd_pr__nfet_01v8 L=0.5u W=1u
M4684 o5 ibias vss vss sky130_fd_pr__nfet_01v8 L=0.5u W=1u
M4685 o5 ibias vss vss sky130_fd_pr__nfet_01v8 L=0.5u W=1u
M4686 o5 ibias vss vss sky130_fd_pr__nfet_01v8 L=0.5u W=1u
M4687 o5 ibias vss vss sky130_fd_pr__nfet_01v8 L=0.5u W=1u
M4688 o5 ibias vss vss sky130_fd_pr__nfet_01v8 L=0.5u W=1u
M4689 o5 ibias vss vss sky130_fd_pr__nfet_01v8 L=0.5u W=1u
M4690 o5 ibias vss vss sky130_fd_pr__nfet_01v8 L=0.5u W=1u
M4691 o5 ibias vss vss sky130_fd_pr__nfet_01v8 L=0.5u W=1u
M4692 o5 ibias vss vss sky130_fd_pr__nfet_01v8 L=0.5u W=1u
M4693 o5 ibias vss vss sky130_fd_pr__nfet_01v8 L=0.5u W=1u
M4694 o5 ibias vss vss sky130_fd_pr__nfet_01v8 L=0.5u W=1u
M4695 o5 ibias vss vss sky130_fd_pr__nfet_01v8 L=0.5u W=1u
M4696 o5 ibias vss vss sky130_fd_pr__nfet_01v8 L=0.5u W=1u
M4697 o5 ibias vss vss sky130_fd_pr__nfet_01v8 L=0.5u W=1u
M4698 o5 ibias vss vss sky130_fd_pr__nfet_01v8 L=0.5u W=1u
M4699 o5 ibias vss vss sky130_fd_pr__nfet_01v8 L=0.5u W=1u
M4700 o5 ibias vss vss sky130_fd_pr__nfet_01v8 L=0.5u W=1u
M4701 o5 ibias vss vss sky130_fd_pr__nfet_01v8 L=0.5u W=1u
M4702 o5 ibias vss vss sky130_fd_pr__nfet_01v8 L=0.5u W=1u
M4703 o5 ibias vss vss sky130_fd_pr__nfet_01v8 L=0.5u W=1u
M4704 o5 ibias vss vss sky130_fd_pr__nfet_01v8 L=0.5u W=1u
M4705 o5 ibias vss vss sky130_fd_pr__nfet_01v8 L=0.5u W=1u
M4706 o5 ibias vss vss sky130_fd_pr__nfet_01v8 L=0.5u W=1u
M4707 o5 ibias vss vss sky130_fd_pr__nfet_01v8 L=0.5u W=1u
M4708 o5 ibias vss vss sky130_fd_pr__nfet_01v8 L=0.5u W=1u
M4709 o5 ibias vss vss sky130_fd_pr__nfet_01v8 L=0.5u W=1u
M4710 o5 ibias vss vss sky130_fd_pr__nfet_01v8 L=0.5u W=1u
M4711 o5 ibias vss vss sky130_fd_pr__nfet_01v8 L=0.5u W=1u
M4712 o5 ibias vss vss sky130_fd_pr__nfet_01v8 L=0.5u W=1u
M4713 o5 ibias vss vss sky130_fd_pr__nfet_01v8 L=0.5u W=1u
M4714 o5 ibias vss vss sky130_fd_pr__nfet_01v8 L=0.5u W=1u
M4715 o5 ibias vss vss sky130_fd_pr__nfet_01v8 L=0.5u W=1u
M4716 o5 ibias vss vss sky130_fd_pr__nfet_01v8 L=0.5u W=1u
M4717 o5 ibias vss vss sky130_fd_pr__nfet_01v8 L=0.5u W=1u
M4718 o5 ibias vss vss sky130_fd_pr__nfet_01v8 L=0.5u W=1u
M4719 o5 ibias vss vss sky130_fd_pr__nfet_01v8 L=0.5u W=1u
M4720 o5 ibias vss vss sky130_fd_pr__nfet_01v8 L=0.5u W=1u
M4721 o5 ibias vss vss sky130_fd_pr__nfet_01v8 L=0.5u W=1u
M4722 o5 ibias vss vss sky130_fd_pr__nfet_01v8 L=0.5u W=1u
M4723 o5 ibias vss vss sky130_fd_pr__nfet_01v8 L=0.5u W=1u
M4724 o5 ibias vss vss sky130_fd_pr__nfet_01v8 L=0.5u W=1u
M4725 o5 ibias vss vss sky130_fd_pr__nfet_01v8 L=0.5u W=1u
M4726 o5 ibias vss vss sky130_fd_pr__nfet_01v8 L=0.5u W=1u
M4727 o5 ibias vss vss sky130_fd_pr__nfet_01v8 L=0.5u W=1u
M4728 o5 ibias vss vss sky130_fd_pr__nfet_01v8 L=0.5u W=1u
M4729 o5 ibias vss vss sky130_fd_pr__nfet_01v8 L=0.5u W=1u
M4730 o5 ibias vss vss sky130_fd_pr__nfet_01v8 L=0.5u W=1u
M4731 o5 ibias vss vss sky130_fd_pr__nfet_01v8 L=0.5u W=1u
M4732 o5 ibias vss vss sky130_fd_pr__nfet_01v8 L=0.5u W=1u
M4733 o5 ibias vss vss sky130_fd_pr__nfet_01v8 L=0.5u W=1u
M4734 o5 ibias vss vss sky130_fd_pr__nfet_01v8 L=0.5u W=1u
M4735 o5 ibias vss vss sky130_fd_pr__nfet_01v8 L=0.5u W=1u
M4736 o5 ibias vss vss sky130_fd_pr__nfet_01v8 L=0.5u W=1u
M4737 o5 ibias vss vss sky130_fd_pr__nfet_01v8 L=0.5u W=1u
M4738 o5 ibias vss vss sky130_fd_pr__nfet_01v8 L=0.5u W=1u
M4739 o5 ibias vss vss sky130_fd_pr__nfet_01v8 L=0.5u W=1u
M4740 o5 ibias vss vss sky130_fd_pr__nfet_01v8 L=0.5u W=1u
M4741 o5 ibias vss vss sky130_fd_pr__nfet_01v8 L=0.5u W=1u
M4742 o5 ibias vss vss sky130_fd_pr__nfet_01v8 L=0.5u W=1u
M4743 o5 ibias vss vss sky130_fd_pr__nfet_01v8 L=0.5u W=1u
M4744 o5 ibias vss vss sky130_fd_pr__nfet_01v8 L=0.5u W=1u
M4745 o5 ibias vss vss sky130_fd_pr__nfet_01v8 L=0.5u W=1u
M4746 o5 ibias vss vss sky130_fd_pr__nfet_01v8 L=0.5u W=1u
M4747 o5 ibias vss vss sky130_fd_pr__nfet_01v8 L=0.5u W=1u
M4748 o5 ibias vss vss sky130_fd_pr__nfet_01v8 L=0.5u W=1u
M4749 o5 ibias vss vss sky130_fd_pr__nfet_01v8 L=0.5u W=1u
M4750 o5 ibias vss vss sky130_fd_pr__nfet_01v8 L=0.5u W=1u
M4751 o5 ibias vss vss sky130_fd_pr__nfet_01v8 L=0.5u W=1u
M4752 o5 ibias vss vss sky130_fd_pr__nfet_01v8 L=0.5u W=1u
M4753 o5 ibias vss vss sky130_fd_pr__nfet_01v8 L=0.5u W=1u
M4754 o5 ibias vss vss sky130_fd_pr__nfet_01v8 L=0.5u W=1u
M4755 o5 ibias vss vss sky130_fd_pr__nfet_01v8 L=0.5u W=1u
M4756 o5 ibias vss vss sky130_fd_pr__nfet_01v8 L=0.5u W=1u
M4757 o5 ibias vss vss sky130_fd_pr__nfet_01v8 L=0.5u W=1u
M4758 o5 ibias vss vss sky130_fd_pr__nfet_01v8 L=0.5u W=1u
M4759 o5 ibias vss vss sky130_fd_pr__nfet_01v8 L=0.5u W=1u
M4760 o5 ibias vss vss sky130_fd_pr__nfet_01v8 L=0.5u W=1u
M4761 o5 ibias vss vss sky130_fd_pr__nfet_01v8 L=0.5u W=1u
M4762 o5 ibias vss vss sky130_fd_pr__nfet_01v8 L=0.5u W=1u
M4763 o5 ibias vss vss sky130_fd_pr__nfet_01v8 L=0.5u W=1u
M4764 o5 ibias vss vss sky130_fd_pr__nfet_01v8 L=0.5u W=1u
M4765 o5 ibias vss vss sky130_fd_pr__nfet_01v8 L=0.5u W=1u
M4766 o5 ibias vss vss sky130_fd_pr__nfet_01v8 L=0.5u W=1u
M4767 o5 ibias vss vss sky130_fd_pr__nfet_01v8 L=0.5u W=1u
M4768 o5 ibias vss vss sky130_fd_pr__nfet_01v8 L=0.5u W=1u
M4769 o5 ibias vss vss sky130_fd_pr__nfet_01v8 L=0.5u W=1u
M4770 o5 ibias vss vss sky130_fd_pr__nfet_01v8 L=0.5u W=1u
M4771 o5 ibias vss vss sky130_fd_pr__nfet_01v8 L=0.5u W=1u
M4772 o5 ibias vss vss sky130_fd_pr__nfet_01v8 L=0.5u W=1u
M4773 o5 ibias vss vss sky130_fd_pr__nfet_01v8 L=0.5u W=1u
M4774 o5 ibias vss vss sky130_fd_pr__nfet_01v8 L=0.5u W=1u
M4775 o5 ibias vss vss sky130_fd_pr__nfet_01v8 L=0.5u W=1u
M4776 o5 ibias vss vss sky130_fd_pr__nfet_01v8 L=0.5u W=1u
M4777 o5 ibias vss vss sky130_fd_pr__nfet_01v8 L=0.5u W=1u
M4778 o5 ibias vss vss sky130_fd_pr__nfet_01v8 L=0.5u W=1u
M4779 o5 ibias vss vss sky130_fd_pr__nfet_01v8 L=0.5u W=1u
M4780 o5 ibias vss vss sky130_fd_pr__nfet_01v8 L=0.5u W=1u
M4781 o5 ibias vss vss sky130_fd_pr__nfet_01v8 L=0.5u W=1u
M4782 o5 ibias vss vss sky130_fd_pr__nfet_01v8 L=0.5u W=1u
M4783 o5 ibias vss vss sky130_fd_pr__nfet_01v8 L=0.5u W=1u
M4784 o5 ibias vss vss sky130_fd_pr__nfet_01v8 L=0.5u W=1u
M4785 o5 ibias vss vss sky130_fd_pr__nfet_01v8 L=0.5u W=1u
M4786 o5 ibias vss vss sky130_fd_pr__nfet_01v8 L=0.5u W=1u
M4787 o5 ibias vss vss sky130_fd_pr__nfet_01v8 L=0.5u W=1u
M4788 o5 ibias vss vss sky130_fd_pr__nfet_01v8 L=0.5u W=1u
M4789 o5 ibias vss vss sky130_fd_pr__nfet_01v8 L=0.5u W=1u
M4790 o5 ibias vss vss sky130_fd_pr__nfet_01v8 L=0.5u W=1u
M4791 o5 ibias vss vss sky130_fd_pr__nfet_01v8 L=0.5u W=1u
M4792 o5 ibias vss vss sky130_fd_pr__nfet_01v8 L=0.5u W=1u
M4793 o5 ibias vss vss sky130_fd_pr__nfet_01v8 L=0.5u W=1u
M4794 o5 ibias vss vss sky130_fd_pr__nfet_01v8 L=0.5u W=1u
M4795 o5 ibias vss vss sky130_fd_pr__nfet_01v8 L=0.5u W=1u
M4796 o5 ibias vss vss sky130_fd_pr__nfet_01v8 L=0.5u W=1u
M4797 o5 ibias vss vss sky130_fd_pr__nfet_01v8 L=0.5u W=1u
M4798 o5 ibias vss vss sky130_fd_pr__nfet_01v8 L=0.5u W=1u
M4799 o5 ibias vss vss sky130_fd_pr__nfet_01v8 L=0.5u W=1u
M4800 o5 ibias vss vss sky130_fd_pr__nfet_01v8 L=0.5u W=1u
M4801 o5 ibias vss vss sky130_fd_pr__nfet_01v8 L=0.5u W=1u
M4802 o5 ibias vss vss sky130_fd_pr__nfet_01v8 L=0.5u W=1u
M4803 o5 ibias vss vss sky130_fd_pr__nfet_01v8 L=0.5u W=1u
M4804 o5 ibias vss vss sky130_fd_pr__nfet_01v8 L=0.5u W=1u
M4805 o5 ibias vss vss sky130_fd_pr__nfet_01v8 L=0.5u W=1u
M4806 o5 ibias vss vss sky130_fd_pr__nfet_01v8 L=0.5u W=1u
M4807 o5 ibias vss vss sky130_fd_pr__nfet_01v8 L=0.5u W=1u
M4808 o5 ibias vss vss sky130_fd_pr__nfet_01v8 L=0.5u W=1u
M4809 o5 ibias vss vss sky130_fd_pr__nfet_01v8 L=0.5u W=1u
M4810 o5 ibias vss vss sky130_fd_pr__nfet_01v8 L=0.5u W=1u
M4811 o5 ibias vss vss sky130_fd_pr__nfet_01v8 L=0.5u W=1u
M4812 o5 ibias vss vss sky130_fd_pr__nfet_01v8 L=0.5u W=1u
M4813 o5 ibias vss vss sky130_fd_pr__nfet_01v8 L=0.5u W=1u
M4814 o5 ibias vss vss sky130_fd_pr__nfet_01v8 L=0.5u W=1u
M4815 o5 ibias vss vss sky130_fd_pr__nfet_01v8 L=0.5u W=1u
M4816 o5 ibias vss vss sky130_fd_pr__nfet_01v8 L=0.5u W=1u
M4817 o5 ibias vss vss sky130_fd_pr__nfet_01v8 L=0.5u W=1u
M4818 o5 ibias vss vss sky130_fd_pr__nfet_01v8 L=0.5u W=1u
M4819 o5 ibias vss vss sky130_fd_pr__nfet_01v8 L=0.5u W=1u
M4820 o5 ibias vss vss sky130_fd_pr__nfet_01v8 L=0.5u W=1u
M4821 o5 ibias vss vss sky130_fd_pr__nfet_01v8 L=0.5u W=1u
M4822 o5 ibias vss vss sky130_fd_pr__nfet_01v8 L=0.5u W=1u
M4823 o5 ibias vss vss sky130_fd_pr__nfet_01v8 L=0.5u W=1u
M4824 o5 ibias vss vss sky130_fd_pr__nfet_01v8 L=0.5u W=1u
M4825 o5 ibias vss vss sky130_fd_pr__nfet_01v8 L=0.5u W=1u
M4826 o5 ibias vss vss sky130_fd_pr__nfet_01v8 L=0.5u W=1u
M4827 o5 ibias vss vss sky130_fd_pr__nfet_01v8 L=0.5u W=1u
M4828 o5 ibias vss vss sky130_fd_pr__nfet_01v8 L=0.5u W=1u
M4829 o5 ibias vss vss sky130_fd_pr__nfet_01v8 L=0.5u W=1u
M4830 o5 ibias vss vss sky130_fd_pr__nfet_01v8 L=0.5u W=1u
M4831 o5 ibias vss vss sky130_fd_pr__nfet_01v8 L=0.5u W=1u
M4832 o5 ibias vss vss sky130_fd_pr__nfet_01v8 L=0.5u W=1u
M4833 o5 ibias vss vss sky130_fd_pr__nfet_01v8 L=0.5u W=1u
M4834 o5 ibias vss vss sky130_fd_pr__nfet_01v8 L=0.5u W=1u
M4835 o5 ibias vss vss sky130_fd_pr__nfet_01v8 L=0.5u W=1u
M4836 o5 ibias vss vss sky130_fd_pr__nfet_01v8 L=0.5u W=1u
M4837 o5 ibias vss vss sky130_fd_pr__nfet_01v8 L=0.5u W=1u
M4838 o5 ibias vss vss sky130_fd_pr__nfet_01v8 L=0.5u W=1u
M4839 o5 ibias vss vss sky130_fd_pr__nfet_01v8 L=0.5u W=1u
M4840 o5 ibias vss vss sky130_fd_pr__nfet_01v8 L=0.5u W=1u
M4841 o5 ibias vss vss sky130_fd_pr__nfet_01v8 L=0.5u W=1u
M4842 o5 ibias vss vss sky130_fd_pr__nfet_01v8 L=0.5u W=1u
M4843 o5 ibias vss vss sky130_fd_pr__nfet_01v8 L=0.5u W=1u
M4844 o5 ibias vss vss sky130_fd_pr__nfet_01v8 L=0.5u W=1u
M4845 o5 ibias vss vss sky130_fd_pr__nfet_01v8 L=0.5u W=1u
M4846 o5 ibias vss vss sky130_fd_pr__nfet_01v8 L=0.5u W=1u
M4847 o5 ibias vss vss sky130_fd_pr__nfet_01v8 L=0.5u W=1u
M4848 o5 ibias vss vss sky130_fd_pr__nfet_01v8 L=0.5u W=1u
M4849 o5 ibias vss vss sky130_fd_pr__nfet_01v8 L=0.5u W=1u
M4850 o5 ibias vss vss sky130_fd_pr__nfet_01v8 L=0.5u W=1u
M4851 o5 ibias vss vss sky130_fd_pr__nfet_01v8 L=0.5u W=1u
M4852 o5 ibias vss vss sky130_fd_pr__nfet_01v8 L=0.5u W=1u
M4853 o5 ibias vss vss sky130_fd_pr__nfet_01v8 L=0.5u W=1u
M4854 o5 ibias vss vss sky130_fd_pr__nfet_01v8 L=0.5u W=1u
M4855 o5 ibias vss vss sky130_fd_pr__nfet_01v8 L=0.5u W=1u
M4856 o5 ibias vss vss sky130_fd_pr__nfet_01v8 L=0.5u W=1u
M4857 o5 ibias vss vss sky130_fd_pr__nfet_01v8 L=0.5u W=1u
M4858 o5 ibias vss vss sky130_fd_pr__nfet_01v8 L=0.5u W=1u
M4859 o5 ibias vss vss sky130_fd_pr__nfet_01v8 L=0.5u W=1u
M4860 o5 ibias vss vss sky130_fd_pr__nfet_01v8 L=0.5u W=1u
M4861 o5 ibias vss vss sky130_fd_pr__nfet_01v8 L=0.5u W=1u
M4862 o5 ibias vss vss sky130_fd_pr__nfet_01v8 L=0.5u W=1u
M4863 o5 ibias vss vss sky130_fd_pr__nfet_01v8 L=0.5u W=1u
M4864 o5 ibias vss vss sky130_fd_pr__nfet_01v8 L=0.5u W=1u
M4865 o5 ibias vss vss sky130_fd_pr__nfet_01v8 L=0.5u W=1u
M4866 o5 ibias vss vss sky130_fd_pr__nfet_01v8 L=0.5u W=1u
M4867 o5 ibias vss vss sky130_fd_pr__nfet_01v8 L=0.5u W=1u
M4868 o5 ibias vss vss sky130_fd_pr__nfet_01v8 L=0.5u W=1u
M4869 o5 ibias vss vss sky130_fd_pr__nfet_01v8 L=0.5u W=1u
M4870 o5 ibias vss vss sky130_fd_pr__nfet_01v8 L=0.5u W=1u
M4871 o5 ibias vss vss sky130_fd_pr__nfet_01v8 L=0.5u W=1u
M4872 o5 ibias vss vss sky130_fd_pr__nfet_01v8 L=0.5u W=1u
M4873 o5 ibias vss vss sky130_fd_pr__nfet_01v8 L=0.5u W=1u
M4874 o5 ibias vss vss sky130_fd_pr__nfet_01v8 L=0.5u W=1u
M4875 o5 ibias vss vss sky130_fd_pr__nfet_01v8 L=0.5u W=1u
M4876 o5 ibias vss vss sky130_fd_pr__nfet_01v8 L=0.5u W=1u
M4877 o5 ibias vss vss sky130_fd_pr__nfet_01v8 L=0.5u W=1u
M4878 o5 ibias vss vss sky130_fd_pr__nfet_01v8 L=0.5u W=1u
M4879 o5 ibias vss vss sky130_fd_pr__nfet_01v8 L=0.5u W=1u
M4880 o5 ibias vss vss sky130_fd_pr__nfet_01v8 L=0.5u W=1u
M4881 o5 ibias vss vss sky130_fd_pr__nfet_01v8 L=0.5u W=1u
M4882 o5 ibias vss vss sky130_fd_pr__nfet_01v8 L=0.5u W=1u
M4883 o5 ibias vss vss sky130_fd_pr__nfet_01v8 L=0.5u W=1u
M4884 o5 ibias vss vss sky130_fd_pr__nfet_01v8 L=0.5u W=1u
M4885 o5 ibias vss vss sky130_fd_pr__nfet_01v8 L=0.5u W=1u
M4886 o5 ibias vss vss sky130_fd_pr__nfet_01v8 L=0.5u W=1u
M4887 o5 ibias vss vss sky130_fd_pr__nfet_01v8 L=0.5u W=1u
M4888 o5 ibias vss vss sky130_fd_pr__nfet_01v8 L=0.5u W=1u
M4889 o5 ibias vss vss sky130_fd_pr__nfet_01v8 L=0.5u W=1u
M4890 o5 ibias vss vss sky130_fd_pr__nfet_01v8 L=0.5u W=1u
M4891 o5 ibias vss vss sky130_fd_pr__nfet_01v8 L=0.5u W=1u
M4892 o5 ibias vss vss sky130_fd_pr__nfet_01v8 L=0.5u W=1u
M4893 o5 ibias vss vss sky130_fd_pr__nfet_01v8 L=0.5u W=1u
M4894 o5 ibias vss vss sky130_fd_pr__nfet_01v8 L=0.5u W=1u
M4895 o5 ibias vss vss sky130_fd_pr__nfet_01v8 L=0.5u W=1u
M4896 o5 ibias vss vss sky130_fd_pr__nfet_01v8 L=0.5u W=1u
M4897 o5 ibias vss vss sky130_fd_pr__nfet_01v8 L=0.5u W=1u
M4898 o5 ibias vss vss sky130_fd_pr__nfet_01v8 L=0.5u W=1u
M4899 o5 ibias vss vss sky130_fd_pr__nfet_01v8 L=0.5u W=1u
M4900 o5 ibias vss vss sky130_fd_pr__nfet_01v8 L=0.5u W=1u
M4901 o5 ibias vss vss sky130_fd_pr__nfet_01v8 L=0.5u W=1u
M4902 o5 ibias vss vss sky130_fd_pr__nfet_01v8 L=0.5u W=1u
M4903 o5 ibias vss vss sky130_fd_pr__nfet_01v8 L=0.5u W=1u
M4904 o5 ibias vss vss sky130_fd_pr__nfet_01v8 L=0.5u W=1u
M4905 o5 ibias vss vss sky130_fd_pr__nfet_01v8 L=0.5u W=1u
M4906 o5 ibias vss vss sky130_fd_pr__nfet_01v8 L=0.5u W=1u
M4907 o5 ibias vss vss sky130_fd_pr__nfet_01v8 L=0.5u W=1u
M4908 o5 ibias vss vss sky130_fd_pr__nfet_01v8 L=0.5u W=1u
M4909 o5 ibias vss vss sky130_fd_pr__nfet_01v8 L=0.5u W=1u
M4910 o5 ibias vss vss sky130_fd_pr__nfet_01v8 L=0.5u W=1u
M4911 o5 ibias vss vss sky130_fd_pr__nfet_01v8 L=0.5u W=1u
M4912 o5 ibias vss vss sky130_fd_pr__nfet_01v8 L=0.5u W=1u
M4913 o5 ibias vss vss sky130_fd_pr__nfet_01v8 L=0.5u W=1u
M4914 o5 ibias vss vss sky130_fd_pr__nfet_01v8 L=0.5u W=1u
M4915 o5 ibias vss vss sky130_fd_pr__nfet_01v8 L=0.5u W=1u
M4916 o5 ibias vss vss sky130_fd_pr__nfet_01v8 L=0.5u W=1u
M4917 o5 ibias vss vss sky130_fd_pr__nfet_01v8 L=0.5u W=1u
M4918 o5 ibias vss vss sky130_fd_pr__nfet_01v8 L=0.5u W=1u
M4919 o5 ibias vss vss sky130_fd_pr__nfet_01v8 L=0.5u W=1u
M4920 o5 ibias vss vss sky130_fd_pr__nfet_01v8 L=0.5u W=1u
M4921 o5 ibias vss vss sky130_fd_pr__nfet_01v8 L=0.5u W=1u
M4922 o5 ibias vss vss sky130_fd_pr__nfet_01v8 L=0.5u W=1u
M4923 o5 ibias vss vss sky130_fd_pr__nfet_01v8 L=0.5u W=1u
M4924 o5 ibias vss vss sky130_fd_pr__nfet_01v8 L=0.5u W=1u
M4925 o5 ibias vss vss sky130_fd_pr__nfet_01v8 L=0.5u W=1u
M4926 o5 ibias vss vss sky130_fd_pr__nfet_01v8 L=0.5u W=1u
M4927 o5 ibias vss vss sky130_fd_pr__nfet_01v8 L=0.5u W=1u
M4928 o5 ibias vss vss sky130_fd_pr__nfet_01v8 L=0.5u W=1u
M4929 o5 ibias vss vss sky130_fd_pr__nfet_01v8 L=0.5u W=1u
M4930 o5 ibias vss vss sky130_fd_pr__nfet_01v8 L=0.5u W=1u
M4931 o5 ibias vss vss sky130_fd_pr__nfet_01v8 L=0.5u W=1u
M4932 o5 ibias vss vss sky130_fd_pr__nfet_01v8 L=0.5u W=1u
M4933 o5 ibias vss vss sky130_fd_pr__nfet_01v8 L=0.5u W=1u
M4934 o5 ibias vss vss sky130_fd_pr__nfet_01v8 L=0.5u W=1u
M4935 o5 ibias vss vss sky130_fd_pr__nfet_01v8 L=0.5u W=1u
M4936 o5 ibias vss vss sky130_fd_pr__nfet_01v8 L=0.5u W=1u
M4937 o5 ibias vss vss sky130_fd_pr__nfet_01v8 L=0.5u W=1u
M4938 o5 ibias vss vss sky130_fd_pr__nfet_01v8 L=0.5u W=1u
M4939 o5 ibias vss vss sky130_fd_pr__nfet_01v8 L=0.5u W=1u
M4940 o5 ibias vss vss sky130_fd_pr__nfet_01v8 L=0.5u W=1u
M4941 o5 ibias vss vss sky130_fd_pr__nfet_01v8 L=0.5u W=1u
M4942 o5 ibias vss vss sky130_fd_pr__nfet_01v8 L=0.5u W=1u
M4943 o5 ibias vss vss sky130_fd_pr__nfet_01v8 L=0.5u W=1u
M4944 o5 ibias vss vss sky130_fd_pr__nfet_01v8 L=0.5u W=1u
M4945 o5 ibias vss vss sky130_fd_pr__nfet_01v8 L=0.5u W=1u
M4946 o5 ibias vss vss sky130_fd_pr__nfet_01v8 L=0.5u W=1u
M4947 o5 ibias vss vss sky130_fd_pr__nfet_01v8 L=0.5u W=1u
M4948 o5 ibias vss vss sky130_fd_pr__nfet_01v8 L=0.5u W=1u
M4949 o5 ibias vss vss sky130_fd_pr__nfet_01v8 L=0.5u W=1u
M4950 o5 ibias vss vss sky130_fd_pr__nfet_01v8 L=0.5u W=1u
M4951 o5 ibias vss vss sky130_fd_pr__nfet_01v8 L=0.5u W=1u
M4952 o5 ibias vss vss sky130_fd_pr__nfet_01v8 L=0.5u W=1u
M4953 o5 ibias vss vss sky130_fd_pr__nfet_01v8 L=0.5u W=1u
M4954 o5 ibias vss vss sky130_fd_pr__nfet_01v8 L=0.5u W=1u
M4955 o5 ibias vss vss sky130_fd_pr__nfet_01v8 L=0.5u W=1u
M4956 o5 ibias vss vss sky130_fd_pr__nfet_01v8 L=0.5u W=1u
M4957 o5 ibias vss vss sky130_fd_pr__nfet_01v8 L=0.5u W=1u
M4958 o5 ibias vss vss sky130_fd_pr__nfet_01v8 L=0.5u W=1u
M4959 o5 ibias vss vss sky130_fd_pr__nfet_01v8 L=0.5u W=1u
M4960 o5 ibias vss vss sky130_fd_pr__nfet_01v8 L=0.5u W=1u
M4961 o5 ibias vss vss sky130_fd_pr__nfet_01v8 L=0.5u W=1u
M4962 o5 ibias vss vss sky130_fd_pr__nfet_01v8 L=0.5u W=1u
M4963 o5 ibias vss vss sky130_fd_pr__nfet_01v8 L=0.5u W=1u
M4964 o5 ibias vss vss sky130_fd_pr__nfet_01v8 L=0.5u W=1u
M4965 o5 ibias vss vss sky130_fd_pr__nfet_01v8 L=0.5u W=1u
M4966 o5 ibias vss vss sky130_fd_pr__nfet_01v8 L=0.5u W=1u
M4967 o5 ibias vss vss sky130_fd_pr__nfet_01v8 L=0.5u W=1u
M4968 o5 ibias vss vss sky130_fd_pr__nfet_01v8 L=0.5u W=1u
M4969 o5 ibias vss vss sky130_fd_pr__nfet_01v8 L=0.5u W=1u
M4970 o5 ibias vss vss sky130_fd_pr__nfet_01v8 L=0.5u W=1u
M4971 o5 ibias vss vss sky130_fd_pr__nfet_01v8 L=0.5u W=1u
M4972 o5 ibias vss vss sky130_fd_pr__nfet_01v8 L=0.5u W=1u
M4973 o5 ibias vss vss sky130_fd_pr__nfet_01v8 L=0.5u W=1u
M4974 o5 ibias vss vss sky130_fd_pr__nfet_01v8 L=0.5u W=1u
M4975 o5 ibias vss vss sky130_fd_pr__nfet_01v8 L=0.5u W=1u
M4976 o5 ibias vss vss sky130_fd_pr__nfet_01v8 L=0.5u W=1u
M4977 o5 ibias vss vss sky130_fd_pr__nfet_01v8 L=0.5u W=1u
M4978 o5 ibias vss vss sky130_fd_pr__nfet_01v8 L=0.5u W=1u
M4979 o5 ibias vss vss sky130_fd_pr__nfet_01v8 L=0.5u W=1u
M4980 o5 ibias vss vss sky130_fd_pr__nfet_01v8 L=0.5u W=1u
M4981 o5 ibias vss vss sky130_fd_pr__nfet_01v8 L=0.5u W=1u
M4982 o5 ibias vss vss sky130_fd_pr__nfet_01v8 L=0.5u W=1u
M4983 o5 ibias vss vss sky130_fd_pr__nfet_01v8 L=0.5u W=1u
M4984 o5 ibias vss vss sky130_fd_pr__nfet_01v8 L=0.5u W=1u
M4985 o5 ibias vss vss sky130_fd_pr__nfet_01v8 L=0.5u W=1u
M4986 o5 ibias vss vss sky130_fd_pr__nfet_01v8 L=0.5u W=1u
M4987 o5 ibias vss vss sky130_fd_pr__nfet_01v8 L=0.5u W=1u
M4988 o5 ibias vss vss sky130_fd_pr__nfet_01v8 L=0.5u W=1u
M4989 o5 ibias vss vss sky130_fd_pr__nfet_01v8 L=0.5u W=1u
M4990 o5 ibias vss vss sky130_fd_pr__nfet_01v8 L=0.5u W=1u
M4991 o5 ibias vss vss sky130_fd_pr__nfet_01v8 L=0.5u W=1u
M4992 o5 ibias vss vss sky130_fd_pr__nfet_01v8 L=0.5u W=1u
M4993 o5 ibias vss vss sky130_fd_pr__nfet_01v8 L=0.5u W=1u
M4994 o5 ibias vss vss sky130_fd_pr__nfet_01v8 L=0.5u W=1u
M4995 o5 ibias vss vss sky130_fd_pr__nfet_01v8 L=0.5u W=1u
M4996 o5 ibias vss vss sky130_fd_pr__nfet_01v8 L=0.5u W=1u
M4997 o5 ibias vss vss sky130_fd_pr__nfet_01v8 L=0.5u W=1u
M4998 o5 ibias vss vss sky130_fd_pr__nfet_01v8 L=0.5u W=1u
M4999 o5 ibias vss vss sky130_fd_pr__nfet_01v8 L=0.5u W=1u
M5000 o5 ibias vss vss sky130_fd_pr__nfet_01v8 L=0.5u W=1u
M5001 o5 ibias vss vss sky130_fd_pr__nfet_01v8 L=0.5u W=1u
M5002 o5 ibias vss vss sky130_fd_pr__nfet_01v8 L=0.5u W=1u
M5003 o5 ibias vss vss sky130_fd_pr__nfet_01v8 L=0.5u W=1u
M5004 o5 ibias vss vss sky130_fd_pr__nfet_01v8 L=0.5u W=1u
M5005 o5 ibias vss vss sky130_fd_pr__nfet_01v8 L=0.5u W=1u
M5006 o5 ibias vss vss sky130_fd_pr__nfet_01v8 L=0.5u W=1u
M5007 o5 ibias vss vss sky130_fd_pr__nfet_01v8 L=0.5u W=1u
M5008 o5 ibias vss vss sky130_fd_pr__nfet_01v8 L=0.5u W=1u
M5009 o5 ibias vss vss sky130_fd_pr__nfet_01v8 L=0.5u W=1u
M5010 o5 ibias vss vss sky130_fd_pr__nfet_01v8 L=0.5u W=1u
M5011 o5 ibias vss vss sky130_fd_pr__nfet_01v8 L=0.5u W=1u
M5012 o5 ibias vss vss sky130_fd_pr__nfet_01v8 L=0.5u W=1u
M5013 o5 ibias vss vss sky130_fd_pr__nfet_01v8 L=0.5u W=1u
M5014 o5 ibias vss vss sky130_fd_pr__nfet_01v8 L=0.5u W=1u
M5015 o5 ibias vss vss sky130_fd_pr__nfet_01v8 L=0.5u W=1u
M5016 o5 ibias vss vss sky130_fd_pr__nfet_01v8 L=0.5u W=1u
M5017 o5 ibias vss vss sky130_fd_pr__nfet_01v8 L=0.5u W=1u
M5018 o5 ibias vss vss sky130_fd_pr__nfet_01v8 L=0.5u W=1u
M5019 o5 ibias vss vss sky130_fd_pr__nfet_01v8 L=0.5u W=1u
M5020 o5 ibias vss vss sky130_fd_pr__nfet_01v8 L=0.5u W=1u
M5021 o5 ibias vss vss sky130_fd_pr__nfet_01v8 L=0.5u W=1u
M5022 o5 ibias vss vss sky130_fd_pr__nfet_01v8 L=0.5u W=1u
M5023 o5 ibias vss vss sky130_fd_pr__nfet_01v8 L=0.5u W=1u
M5024 o5 ibias vss vss sky130_fd_pr__nfet_01v8 L=0.5u W=1u
M5025 o5 ibias vss vss sky130_fd_pr__nfet_01v8 L=0.5u W=1u
M5026 o5 ibias vss vss sky130_fd_pr__nfet_01v8 L=0.5u W=1u
M5027 o5 ibias vss vss sky130_fd_pr__nfet_01v8 L=0.5u W=1u
M5028 o5 ibias vss vss sky130_fd_pr__nfet_01v8 L=0.5u W=1u
M5029 o5 ibias vss vss sky130_fd_pr__nfet_01v8 L=0.5u W=1u
M5030 o5 ibias vss vss sky130_fd_pr__nfet_01v8 L=0.5u W=1u
M5031 o5 ibias vss vss sky130_fd_pr__nfet_01v8 L=0.5u W=1u
M5032 o5 ibias vss vss sky130_fd_pr__nfet_01v8 L=0.5u W=1u
M5033 o5 ibias vss vss sky130_fd_pr__nfet_01v8 L=0.5u W=1u
M5034 o5 ibias vss vss sky130_fd_pr__nfet_01v8 L=0.5u W=1u
M5035 o5 ibias vss vss sky130_fd_pr__nfet_01v8 L=0.5u W=1u
M5036 o5 ibias vss vss sky130_fd_pr__nfet_01v8 L=0.5u W=1u
M5037 o5 ibias vss vss sky130_fd_pr__nfet_01v8 L=0.5u W=1u
M5038 o5 ibias vss vss sky130_fd_pr__nfet_01v8 L=0.5u W=1u
M5039 o5 ibias vss vss sky130_fd_pr__nfet_01v8 L=0.5u W=1u
M5040 o5 ibias vss vss sky130_fd_pr__nfet_01v8 L=0.5u W=1u
M5041 o5 ibias vss vss sky130_fd_pr__nfet_01v8 L=0.5u W=1u
M5042 o5 ibias vss vss sky130_fd_pr__nfet_01v8 L=0.5u W=1u
M5043 o5 ibias vss vss sky130_fd_pr__nfet_01v8 L=0.5u W=1u
M5044 o5 ibias vss vss sky130_fd_pr__nfet_01v8 L=0.5u W=1u
M5045 o5 ibias vss vss sky130_fd_pr__nfet_01v8 L=0.5u W=1u
M5046 o5 ibias vss vss sky130_fd_pr__nfet_01v8 L=0.5u W=1u
M5047 o5 ibias vss vss sky130_fd_pr__nfet_01v8 L=0.5u W=1u
M5048 o5 ibias vss vss sky130_fd_pr__nfet_01v8 L=0.5u W=1u
M5049 o5 ibias vss vss sky130_fd_pr__nfet_01v8 L=0.5u W=1u
M5050 o5 ibias vss vss sky130_fd_pr__nfet_01v8 L=0.5u W=1u
M5051 o5 ibias vss vss sky130_fd_pr__nfet_01v8 L=0.5u W=1u
M5052 o5 ibias vss vss sky130_fd_pr__nfet_01v8 L=0.5u W=1u
M5053 o5 ibias vss vss sky130_fd_pr__nfet_01v8 L=0.5u W=1u
M5054 o5 ibias vss vss sky130_fd_pr__nfet_01v8 L=0.5u W=1u
M5055 o5 ibias vss vss sky130_fd_pr__nfet_01v8 L=0.5u W=1u
M5056 o5 ibias vss vss sky130_fd_pr__nfet_01v8 L=0.5u W=1u
M5057 o5 ibias vss vss sky130_fd_pr__nfet_01v8 L=0.5u W=1u
M5058 o5 ibias vss vss sky130_fd_pr__nfet_01v8 L=0.5u W=1u
M5059 o5 ibias vss vss sky130_fd_pr__nfet_01v8 L=0.5u W=1u
M5060 o5 ibias vss vss sky130_fd_pr__nfet_01v8 L=0.5u W=1u
M5061 o5 ibias vss vss sky130_fd_pr__nfet_01v8 L=0.5u W=1u
M5062 o5 ibias vss vss sky130_fd_pr__nfet_01v8 L=0.5u W=1u
M5063 o5 ibias vss vss sky130_fd_pr__nfet_01v8 L=0.5u W=1u
M5064 o5 ibias vss vss sky130_fd_pr__nfet_01v8 L=0.5u W=1u
M5065 o5 ibias vss vss sky130_fd_pr__nfet_01v8 L=0.5u W=1u
M5066 o5 ibias vss vss sky130_fd_pr__nfet_01v8 L=0.5u W=1u
M5067 o5 ibias vss vss sky130_fd_pr__nfet_01v8 L=0.5u W=1u
M5068 o5 ibias vss vss sky130_fd_pr__nfet_01v8 L=0.5u W=1u
M5069 o5 ibias vss vss sky130_fd_pr__nfet_01v8 L=0.5u W=1u
M5070 o5 ibias vss vss sky130_fd_pr__nfet_01v8 L=0.5u W=1u
M5071 o5 ibias vss vss sky130_fd_pr__nfet_01v8 L=0.5u W=1u
M5072 o5 ibias vss vss sky130_fd_pr__nfet_01v8 L=0.5u W=1u
M5073 o5 ibias vss vss sky130_fd_pr__nfet_01v8 L=0.5u W=1u
M5074 o5 ibias vss vss sky130_fd_pr__nfet_01v8 L=0.5u W=1u
M5075 o5 ibias vss vss sky130_fd_pr__nfet_01v8 L=0.5u W=1u
M5076 o5 ibias vss vss sky130_fd_pr__nfet_01v8 L=0.5u W=1u
M5077 o5 ibias vss vss sky130_fd_pr__nfet_01v8 L=0.5u W=1u
M5078 o5 ibias vss vss sky130_fd_pr__nfet_01v8 L=0.5u W=1u
M5079 o5 ibias vss vss sky130_fd_pr__nfet_01v8 L=0.5u W=1u
M5080 o5 ibias vss vss sky130_fd_pr__nfet_01v8 L=0.5u W=1u
M5081 o5 ibias vss vss sky130_fd_pr__nfet_01v8 L=0.5u W=1u
M5082 o5 ibias vss vss sky130_fd_pr__nfet_01v8 L=0.5u W=1u
M5083 o5 ibias vss vss sky130_fd_pr__nfet_01v8 L=0.5u W=1u
M5084 o5 ibias vss vss sky130_fd_pr__nfet_01v8 L=0.5u W=1u
M5085 o5 ibias vss vss sky130_fd_pr__nfet_01v8 L=0.5u W=1u
M5086 o5 ibias vss vss sky130_fd_pr__nfet_01v8 L=0.5u W=1u
M5087 o5 ibias vss vss sky130_fd_pr__nfet_01v8 L=0.5u W=1u
M5088 o5 ibias vss vss sky130_fd_pr__nfet_01v8 L=0.5u W=1u
M5089 o5 ibias vss vss sky130_fd_pr__nfet_01v8 L=0.5u W=1u
M5090 o5 ibias vss vss sky130_fd_pr__nfet_01v8 L=0.5u W=1u
M5091 o5 ibias vss vss sky130_fd_pr__nfet_01v8 L=0.5u W=1u
M5092 o5 ibias vss vss sky130_fd_pr__nfet_01v8 L=0.5u W=1u
M5093 o5 ibias vss vss sky130_fd_pr__nfet_01v8 L=0.5u W=1u
M5094 o5 ibias vss vss sky130_fd_pr__nfet_01v8 L=0.5u W=1u
M5095 o5 ibias vss vss sky130_fd_pr__nfet_01v8 L=0.5u W=1u
M5096 o5 ibias vss vss sky130_fd_pr__nfet_01v8 L=0.5u W=1u
M5097 o5 ibias vss vss sky130_fd_pr__nfet_01v8 L=0.5u W=1u
M5098 o5 ibias vss vss sky130_fd_pr__nfet_01v8 L=0.5u W=1u
M5099 o5 ibias vss vss sky130_fd_pr__nfet_01v8 L=0.5u W=1u
M5100 o5 ibias vss vss sky130_fd_pr__nfet_01v8 L=0.5u W=1u
M5101 o5 ibias vss vss sky130_fd_pr__nfet_01v8 L=0.5u W=1u
M5102 o5 ibias vss vss sky130_fd_pr__nfet_01v8 L=0.5u W=1u
M5103 o5 ibias vss vss sky130_fd_pr__nfet_01v8 L=0.5u W=1u
M5104 o6 ibias vss vss sky130_fd_pr__nfet_01v8 L=0.5u W=1u
M5105 o6 ibias vss vss sky130_fd_pr__nfet_01v8 L=0.5u W=1u
M5106 o6 ibias vss vss sky130_fd_pr__nfet_01v8 L=0.5u W=1u
M5107 o6 ibias vss vss sky130_fd_pr__nfet_01v8 L=0.5u W=1u
M5108 o6 ibias vss vss sky130_fd_pr__nfet_01v8 L=0.5u W=1u
M5109 o6 ibias vss vss sky130_fd_pr__nfet_01v8 L=0.5u W=1u
M5110 o6 ibias vss vss sky130_fd_pr__nfet_01v8 L=0.5u W=1u
M5111 o6 ibias vss vss sky130_fd_pr__nfet_01v8 L=0.5u W=1u
M5112 o6 ibias vss vss sky130_fd_pr__nfet_01v8 L=0.5u W=1u
M5113 o6 ibias vss vss sky130_fd_pr__nfet_01v8 L=0.5u W=1u
M5114 o6 ibias vss vss sky130_fd_pr__nfet_01v8 L=0.5u W=1u
M5115 o6 ibias vss vss sky130_fd_pr__nfet_01v8 L=0.5u W=1u
M5116 o6 ibias vss vss sky130_fd_pr__nfet_01v8 L=0.5u W=1u
M5117 o6 ibias vss vss sky130_fd_pr__nfet_01v8 L=0.5u W=1u
M5118 o6 ibias vss vss sky130_fd_pr__nfet_01v8 L=0.5u W=1u
M5119 o6 ibias vss vss sky130_fd_pr__nfet_01v8 L=0.5u W=1u
M5120 o6 ibias vss vss sky130_fd_pr__nfet_01v8 L=0.5u W=1u
M5121 o6 ibias vss vss sky130_fd_pr__nfet_01v8 L=0.5u W=1u
M5122 o6 ibias vss vss sky130_fd_pr__nfet_01v8 L=0.5u W=1u
M5123 o6 ibias vss vss sky130_fd_pr__nfet_01v8 L=0.5u W=1u
M5124 o6 ibias vss vss sky130_fd_pr__nfet_01v8 L=0.5u W=1u
M5125 o6 ibias vss vss sky130_fd_pr__nfet_01v8 L=0.5u W=1u
M5126 o6 ibias vss vss sky130_fd_pr__nfet_01v8 L=0.5u W=1u
M5127 o6 ibias vss vss sky130_fd_pr__nfet_01v8 L=0.5u W=1u
M5128 o6 ibias vss vss sky130_fd_pr__nfet_01v8 L=0.5u W=1u
M5129 o6 ibias vss vss sky130_fd_pr__nfet_01v8 L=0.5u W=1u
M5130 o6 ibias vss vss sky130_fd_pr__nfet_01v8 L=0.5u W=1u
M5131 o6 ibias vss vss sky130_fd_pr__nfet_01v8 L=0.5u W=1u
M5132 o6 ibias vss vss sky130_fd_pr__nfet_01v8 L=0.5u W=1u
M5133 o6 ibias vss vss sky130_fd_pr__nfet_01v8 L=0.5u W=1u
M5134 o6 ibias vss vss sky130_fd_pr__nfet_01v8 L=0.5u W=1u
M5135 o6 ibias vss vss sky130_fd_pr__nfet_01v8 L=0.5u W=1u
M5136 o6 ibias vss vss sky130_fd_pr__nfet_01v8 L=0.5u W=1u
M5137 o6 ibias vss vss sky130_fd_pr__nfet_01v8 L=0.5u W=1u
M5138 o6 ibias vss vss sky130_fd_pr__nfet_01v8 L=0.5u W=1u
M5139 o6 ibias vss vss sky130_fd_pr__nfet_01v8 L=0.5u W=1u
M5140 o6 ibias vss vss sky130_fd_pr__nfet_01v8 L=0.5u W=1u
M5141 o6 ibias vss vss sky130_fd_pr__nfet_01v8 L=0.5u W=1u
M5142 o6 ibias vss vss sky130_fd_pr__nfet_01v8 L=0.5u W=1u
M5143 o6 ibias vss vss sky130_fd_pr__nfet_01v8 L=0.5u W=1u
M5144 o6 ibias vss vss sky130_fd_pr__nfet_01v8 L=0.5u W=1u
M5145 o6 ibias vss vss sky130_fd_pr__nfet_01v8 L=0.5u W=1u
M5146 o6 ibias vss vss sky130_fd_pr__nfet_01v8 L=0.5u W=1u
M5147 o6 ibias vss vss sky130_fd_pr__nfet_01v8 L=0.5u W=1u
M5148 o6 ibias vss vss sky130_fd_pr__nfet_01v8 L=0.5u W=1u
M5149 o6 ibias vss vss sky130_fd_pr__nfet_01v8 L=0.5u W=1u
M5150 o6 ibias vss vss sky130_fd_pr__nfet_01v8 L=0.5u W=1u
M5151 o6 ibias vss vss sky130_fd_pr__nfet_01v8 L=0.5u W=1u
M5152 o6 ibias vss vss sky130_fd_pr__nfet_01v8 L=0.5u W=1u
M5153 o6 ibias vss vss sky130_fd_pr__nfet_01v8 L=0.5u W=1u
M5154 o6 ibias vss vss sky130_fd_pr__nfet_01v8 L=0.5u W=1u
M5155 o6 ibias vss vss sky130_fd_pr__nfet_01v8 L=0.5u W=1u
M5156 o6 ibias vss vss sky130_fd_pr__nfet_01v8 L=0.5u W=1u
M5157 o6 ibias vss vss sky130_fd_pr__nfet_01v8 L=0.5u W=1u
M5158 o6 ibias vss vss sky130_fd_pr__nfet_01v8 L=0.5u W=1u
M5159 o6 ibias vss vss sky130_fd_pr__nfet_01v8 L=0.5u W=1u
M5160 o6 ibias vss vss sky130_fd_pr__nfet_01v8 L=0.5u W=1u
M5161 o6 ibias vss vss sky130_fd_pr__nfet_01v8 L=0.5u W=1u
M5162 o6 ibias vss vss sky130_fd_pr__nfet_01v8 L=0.5u W=1u
M5163 o6 ibias vss vss sky130_fd_pr__nfet_01v8 L=0.5u W=1u
M5164 o6 ibias vss vss sky130_fd_pr__nfet_01v8 L=0.5u W=1u
M5165 o6 ibias vss vss sky130_fd_pr__nfet_01v8 L=0.5u W=1u
M5166 o6 ibias vss vss sky130_fd_pr__nfet_01v8 L=0.5u W=1u
M5167 o6 ibias vss vss sky130_fd_pr__nfet_01v8 L=0.5u W=1u
M5168 o6 ibias vss vss sky130_fd_pr__nfet_01v8 L=0.5u W=1u
M5169 o6 ibias vss vss sky130_fd_pr__nfet_01v8 L=0.5u W=1u
M5170 o6 ibias vss vss sky130_fd_pr__nfet_01v8 L=0.5u W=1u
M5171 o6 ibias vss vss sky130_fd_pr__nfet_01v8 L=0.5u W=1u
M5172 o6 ibias vss vss sky130_fd_pr__nfet_01v8 L=0.5u W=1u
M5173 o6 ibias vss vss sky130_fd_pr__nfet_01v8 L=0.5u W=1u
M5174 o6 ibias vss vss sky130_fd_pr__nfet_01v8 L=0.5u W=1u
M5175 o6 ibias vss vss sky130_fd_pr__nfet_01v8 L=0.5u W=1u
M5176 o6 ibias vss vss sky130_fd_pr__nfet_01v8 L=0.5u W=1u
M5177 o6 ibias vss vss sky130_fd_pr__nfet_01v8 L=0.5u W=1u
M5178 o6 ibias vss vss sky130_fd_pr__nfet_01v8 L=0.5u W=1u
M5179 o6 ibias vss vss sky130_fd_pr__nfet_01v8 L=0.5u W=1u
M5180 o6 ibias vss vss sky130_fd_pr__nfet_01v8 L=0.5u W=1u
M5181 o6 ibias vss vss sky130_fd_pr__nfet_01v8 L=0.5u W=1u
M5182 o6 ibias vss vss sky130_fd_pr__nfet_01v8 L=0.5u W=1u
M5183 o6 ibias vss vss sky130_fd_pr__nfet_01v8 L=0.5u W=1u
M5184 o6 ibias vss vss sky130_fd_pr__nfet_01v8 L=0.5u W=1u
M5185 o6 ibias vss vss sky130_fd_pr__nfet_01v8 L=0.5u W=1u
M5186 o6 ibias vss vss sky130_fd_pr__nfet_01v8 L=0.5u W=1u
M5187 o6 ibias vss vss sky130_fd_pr__nfet_01v8 L=0.5u W=1u
M5188 o6 ibias vss vss sky130_fd_pr__nfet_01v8 L=0.5u W=1u
M5189 o6 ibias vss vss sky130_fd_pr__nfet_01v8 L=0.5u W=1u
M5190 o6 ibias vss vss sky130_fd_pr__nfet_01v8 L=0.5u W=1u
M5191 o6 ibias vss vss sky130_fd_pr__nfet_01v8 L=0.5u W=1u
M5192 o6 ibias vss vss sky130_fd_pr__nfet_01v8 L=0.5u W=1u
M5193 o6 ibias vss vss sky130_fd_pr__nfet_01v8 L=0.5u W=1u
M5194 o6 ibias vss vss sky130_fd_pr__nfet_01v8 L=0.5u W=1u
M5195 o6 ibias vss vss sky130_fd_pr__nfet_01v8 L=0.5u W=1u
M5196 o6 ibias vss vss sky130_fd_pr__nfet_01v8 L=0.5u W=1u
M5197 o6 ibias vss vss sky130_fd_pr__nfet_01v8 L=0.5u W=1u
M5198 o6 ibias vss vss sky130_fd_pr__nfet_01v8 L=0.5u W=1u
M5199 o6 ibias vss vss sky130_fd_pr__nfet_01v8 L=0.5u W=1u
M5200 o6 ibias vss vss sky130_fd_pr__nfet_01v8 L=0.5u W=1u
M5201 o6 ibias vss vss sky130_fd_pr__nfet_01v8 L=0.5u W=1u
M5202 o6 ibias vss vss sky130_fd_pr__nfet_01v8 L=0.5u W=1u
M5203 o6 ibias vss vss sky130_fd_pr__nfet_01v8 L=0.5u W=1u
M5204 o6 ibias vss vss sky130_fd_pr__nfet_01v8 L=0.5u W=1u
M5205 o6 ibias vss vss sky130_fd_pr__nfet_01v8 L=0.5u W=1u
M5206 o6 ibias vss vss sky130_fd_pr__nfet_01v8 L=0.5u W=1u
M5207 o6 ibias vss vss sky130_fd_pr__nfet_01v8 L=0.5u W=1u
M5208 o6 ibias vss vss sky130_fd_pr__nfet_01v8 L=0.5u W=1u
M5209 o6 ibias vss vss sky130_fd_pr__nfet_01v8 L=0.5u W=1u
M5210 o6 ibias vss vss sky130_fd_pr__nfet_01v8 L=0.5u W=1u
M5211 o6 ibias vss vss sky130_fd_pr__nfet_01v8 L=0.5u W=1u
M5212 o6 ibias vss vss sky130_fd_pr__nfet_01v8 L=0.5u W=1u
M5213 o6 ibias vss vss sky130_fd_pr__nfet_01v8 L=0.5u W=1u
M5214 o6 ibias vss vss sky130_fd_pr__nfet_01v8 L=0.5u W=1u
M5215 o6 ibias vss vss sky130_fd_pr__nfet_01v8 L=0.5u W=1u
M5216 o6 ibias vss vss sky130_fd_pr__nfet_01v8 L=0.5u W=1u
M5217 o6 ibias vss vss sky130_fd_pr__nfet_01v8 L=0.5u W=1u
M5218 o6 ibias vss vss sky130_fd_pr__nfet_01v8 L=0.5u W=1u
M5219 o6 ibias vss vss sky130_fd_pr__nfet_01v8 L=0.5u W=1u
M5220 o6 ibias vss vss sky130_fd_pr__nfet_01v8 L=0.5u W=1u
M5221 o6 ibias vss vss sky130_fd_pr__nfet_01v8 L=0.5u W=1u
M5222 o6 ibias vss vss sky130_fd_pr__nfet_01v8 L=0.5u W=1u
M5223 o6 ibias vss vss sky130_fd_pr__nfet_01v8 L=0.5u W=1u
M5224 o6 ibias vss vss sky130_fd_pr__nfet_01v8 L=0.5u W=1u
M5225 o6 ibias vss vss sky130_fd_pr__nfet_01v8 L=0.5u W=1u
M5226 o6 ibias vss vss sky130_fd_pr__nfet_01v8 L=0.5u W=1u
M5227 o6 ibias vss vss sky130_fd_pr__nfet_01v8 L=0.5u W=1u
M5228 o6 ibias vss vss sky130_fd_pr__nfet_01v8 L=0.5u W=1u
M5229 o6 ibias vss vss sky130_fd_pr__nfet_01v8 L=0.5u W=1u
M5230 o6 ibias vss vss sky130_fd_pr__nfet_01v8 L=0.5u W=1u
M5231 o6 ibias vss vss sky130_fd_pr__nfet_01v8 L=0.5u W=1u
M5232 o6 ibias vss vss sky130_fd_pr__nfet_01v8 L=0.5u W=1u
M5233 o6 ibias vss vss sky130_fd_pr__nfet_01v8 L=0.5u W=1u
M5234 o6 ibias vss vss sky130_fd_pr__nfet_01v8 L=0.5u W=1u
M5235 o6 ibias vss vss sky130_fd_pr__nfet_01v8 L=0.5u W=1u
M5236 o6 ibias vss vss sky130_fd_pr__nfet_01v8 L=0.5u W=1u
M5237 o6 ibias vss vss sky130_fd_pr__nfet_01v8 L=0.5u W=1u
M5238 o6 ibias vss vss sky130_fd_pr__nfet_01v8 L=0.5u W=1u
M5239 o6 ibias vss vss sky130_fd_pr__nfet_01v8 L=0.5u W=1u
M5240 o6 ibias vss vss sky130_fd_pr__nfet_01v8 L=0.5u W=1u
M5241 o6 ibias vss vss sky130_fd_pr__nfet_01v8 L=0.5u W=1u
M5242 o6 ibias vss vss sky130_fd_pr__nfet_01v8 L=0.5u W=1u
M5243 o6 ibias vss vss sky130_fd_pr__nfet_01v8 L=0.5u W=1u
M5244 o6 ibias vss vss sky130_fd_pr__nfet_01v8 L=0.5u W=1u
M5245 o6 ibias vss vss sky130_fd_pr__nfet_01v8 L=0.5u W=1u
M5246 o6 ibias vss vss sky130_fd_pr__nfet_01v8 L=0.5u W=1u
M5247 o6 ibias vss vss sky130_fd_pr__nfet_01v8 L=0.5u W=1u
M5248 o6 ibias vss vss sky130_fd_pr__nfet_01v8 L=0.5u W=1u
M5249 o6 ibias vss vss sky130_fd_pr__nfet_01v8 L=0.5u W=1u
M5250 o6 ibias vss vss sky130_fd_pr__nfet_01v8 L=0.5u W=1u
M5251 o6 ibias vss vss sky130_fd_pr__nfet_01v8 L=0.5u W=1u
M5252 o6 ibias vss vss sky130_fd_pr__nfet_01v8 L=0.5u W=1u
M5253 o6 ibias vss vss sky130_fd_pr__nfet_01v8 L=0.5u W=1u
M5254 o6 ibias vss vss sky130_fd_pr__nfet_01v8 L=0.5u W=1u
M5255 o6 ibias vss vss sky130_fd_pr__nfet_01v8 L=0.5u W=1u
M5256 o6 ibias vss vss sky130_fd_pr__nfet_01v8 L=0.5u W=1u
M5257 o6 ibias vss vss sky130_fd_pr__nfet_01v8 L=0.5u W=1u
M5258 o6 ibias vss vss sky130_fd_pr__nfet_01v8 L=0.5u W=1u
M5259 o6 ibias vss vss sky130_fd_pr__nfet_01v8 L=0.5u W=1u
M5260 o6 ibias vss vss sky130_fd_pr__nfet_01v8 L=0.5u W=1u
M5261 o6 ibias vss vss sky130_fd_pr__nfet_01v8 L=0.5u W=1u
M5262 o6 ibias vss vss sky130_fd_pr__nfet_01v8 L=0.5u W=1u
M5263 o6 ibias vss vss sky130_fd_pr__nfet_01v8 L=0.5u W=1u
M5264 o6 ibias vss vss sky130_fd_pr__nfet_01v8 L=0.5u W=1u
M5265 o6 ibias vss vss sky130_fd_pr__nfet_01v8 L=0.5u W=1u
M5266 o6 ibias vss vss sky130_fd_pr__nfet_01v8 L=0.5u W=1u
M5267 o6 ibias vss vss sky130_fd_pr__nfet_01v8 L=0.5u W=1u
M5268 o6 ibias vss vss sky130_fd_pr__nfet_01v8 L=0.5u W=1u
M5269 o6 ibias vss vss sky130_fd_pr__nfet_01v8 L=0.5u W=1u
M5270 o6 ibias vss vss sky130_fd_pr__nfet_01v8 L=0.5u W=1u
M5271 o6 ibias vss vss sky130_fd_pr__nfet_01v8 L=0.5u W=1u
M5272 o6 ibias vss vss sky130_fd_pr__nfet_01v8 L=0.5u W=1u
M5273 o6 ibias vss vss sky130_fd_pr__nfet_01v8 L=0.5u W=1u
M5274 o6 ibias vss vss sky130_fd_pr__nfet_01v8 L=0.5u W=1u
M5275 o6 ibias vss vss sky130_fd_pr__nfet_01v8 L=0.5u W=1u
M5276 o6 ibias vss vss sky130_fd_pr__nfet_01v8 L=0.5u W=1u
M5277 o6 ibias vss vss sky130_fd_pr__nfet_01v8 L=0.5u W=1u
M5278 o6 ibias vss vss sky130_fd_pr__nfet_01v8 L=0.5u W=1u
M5279 o6 ibias vss vss sky130_fd_pr__nfet_01v8 L=0.5u W=1u
M5280 o6 ibias vss vss sky130_fd_pr__nfet_01v8 L=0.5u W=1u
M5281 o6 ibias vss vss sky130_fd_pr__nfet_01v8 L=0.5u W=1u
M5282 o6 ibias vss vss sky130_fd_pr__nfet_01v8 L=0.5u W=1u
M5283 o6 ibias vss vss sky130_fd_pr__nfet_01v8 L=0.5u W=1u
M5284 o6 ibias vss vss sky130_fd_pr__nfet_01v8 L=0.5u W=1u
M5285 o6 ibias vss vss sky130_fd_pr__nfet_01v8 L=0.5u W=1u
M5286 o6 ibias vss vss sky130_fd_pr__nfet_01v8 L=0.5u W=1u
M5287 o6 ibias vss vss sky130_fd_pr__nfet_01v8 L=0.5u W=1u
M5288 o6 ibias vss vss sky130_fd_pr__nfet_01v8 L=0.5u W=1u
M5289 o6 ibias vss vss sky130_fd_pr__nfet_01v8 L=0.5u W=1u
M5290 o6 ibias vss vss sky130_fd_pr__nfet_01v8 L=0.5u W=1u
M5291 o6 ibias vss vss sky130_fd_pr__nfet_01v8 L=0.5u W=1u
M5292 o6 ibias vss vss sky130_fd_pr__nfet_01v8 L=0.5u W=1u
M5293 o6 ibias vss vss sky130_fd_pr__nfet_01v8 L=0.5u W=1u
M5294 o6 ibias vss vss sky130_fd_pr__nfet_01v8 L=0.5u W=1u
M5295 o6 ibias vss vss sky130_fd_pr__nfet_01v8 L=0.5u W=1u
M5296 o6 ibias vss vss sky130_fd_pr__nfet_01v8 L=0.5u W=1u
M5297 o6 ibias vss vss sky130_fd_pr__nfet_01v8 L=0.5u W=1u
M5298 o6 ibias vss vss sky130_fd_pr__nfet_01v8 L=0.5u W=1u
M5299 o6 ibias vss vss sky130_fd_pr__nfet_01v8 L=0.5u W=1u
M5300 o6 ibias vss vss sky130_fd_pr__nfet_01v8 L=0.5u W=1u
M5301 o6 ibias vss vss sky130_fd_pr__nfet_01v8 L=0.5u W=1u
M5302 o6 ibias vss vss sky130_fd_pr__nfet_01v8 L=0.5u W=1u
M5303 o6 ibias vss vss sky130_fd_pr__nfet_01v8 L=0.5u W=1u
M5304 o6 ibias vss vss sky130_fd_pr__nfet_01v8 L=0.5u W=1u
M5305 o6 ibias vss vss sky130_fd_pr__nfet_01v8 L=0.5u W=1u
M5306 o6 ibias vss vss sky130_fd_pr__nfet_01v8 L=0.5u W=1u
M5307 o6 ibias vss vss sky130_fd_pr__nfet_01v8 L=0.5u W=1u
M5308 o6 ibias vss vss sky130_fd_pr__nfet_01v8 L=0.5u W=1u
M5309 o6 ibias vss vss sky130_fd_pr__nfet_01v8 L=0.5u W=1u
M5310 o6 ibias vss vss sky130_fd_pr__nfet_01v8 L=0.5u W=1u
M5311 o6 ibias vss vss sky130_fd_pr__nfet_01v8 L=0.5u W=1u
M5312 o6 ibias vss vss sky130_fd_pr__nfet_01v8 L=0.5u W=1u
M5313 o6 ibias vss vss sky130_fd_pr__nfet_01v8 L=0.5u W=1u
M5314 o6 ibias vss vss sky130_fd_pr__nfet_01v8 L=0.5u W=1u
M5315 o6 ibias vss vss sky130_fd_pr__nfet_01v8 L=0.5u W=1u
M5316 o6 ibias vss vss sky130_fd_pr__nfet_01v8 L=0.5u W=1u
M5317 o6 ibias vss vss sky130_fd_pr__nfet_01v8 L=0.5u W=1u
M5318 o6 ibias vss vss sky130_fd_pr__nfet_01v8 L=0.5u W=1u
M5319 o6 ibias vss vss sky130_fd_pr__nfet_01v8 L=0.5u W=1u
M5320 o6 ibias vss vss sky130_fd_pr__nfet_01v8 L=0.5u W=1u
M5321 o6 ibias vss vss sky130_fd_pr__nfet_01v8 L=0.5u W=1u
M5322 o6 ibias vss vss sky130_fd_pr__nfet_01v8 L=0.5u W=1u
M5323 o6 ibias vss vss sky130_fd_pr__nfet_01v8 L=0.5u W=1u
M5324 o6 ibias vss vss sky130_fd_pr__nfet_01v8 L=0.5u W=1u
M5325 o6 ibias vss vss sky130_fd_pr__nfet_01v8 L=0.5u W=1u
M5326 o6 ibias vss vss sky130_fd_pr__nfet_01v8 L=0.5u W=1u
M5327 o6 ibias vss vss sky130_fd_pr__nfet_01v8 L=0.5u W=1u
M5328 o6 ibias vss vss sky130_fd_pr__nfet_01v8 L=0.5u W=1u
M5329 o6 ibias vss vss sky130_fd_pr__nfet_01v8 L=0.5u W=1u
M5330 o6 ibias vss vss sky130_fd_pr__nfet_01v8 L=0.5u W=1u
M5331 o6 ibias vss vss sky130_fd_pr__nfet_01v8 L=0.5u W=1u
M5332 o6 ibias vss vss sky130_fd_pr__nfet_01v8 L=0.5u W=1u
M5333 o6 ibias vss vss sky130_fd_pr__nfet_01v8 L=0.5u W=1u
M5334 o6 ibias vss vss sky130_fd_pr__nfet_01v8 L=0.5u W=1u
M5335 o6 ibias vss vss sky130_fd_pr__nfet_01v8 L=0.5u W=1u
M5336 o6 ibias vss vss sky130_fd_pr__nfet_01v8 L=0.5u W=1u
M5337 o6 ibias vss vss sky130_fd_pr__nfet_01v8 L=0.5u W=1u
M5338 o6 ibias vss vss sky130_fd_pr__nfet_01v8 L=0.5u W=1u
M5339 o6 ibias vss vss sky130_fd_pr__nfet_01v8 L=0.5u W=1u
M5340 o6 ibias vss vss sky130_fd_pr__nfet_01v8 L=0.5u W=1u
M5341 o6 ibias vss vss sky130_fd_pr__nfet_01v8 L=0.5u W=1u
M5342 o6 ibias vss vss sky130_fd_pr__nfet_01v8 L=0.5u W=1u
M5343 o6 ibias vss vss sky130_fd_pr__nfet_01v8 L=0.5u W=1u
M5344 o6 ibias vss vss sky130_fd_pr__nfet_01v8 L=0.5u W=1u
M5345 o6 ibias vss vss sky130_fd_pr__nfet_01v8 L=0.5u W=1u
M5346 o6 ibias vss vss sky130_fd_pr__nfet_01v8 L=0.5u W=1u
M5347 o6 ibias vss vss sky130_fd_pr__nfet_01v8 L=0.5u W=1u
M5348 o6 ibias vss vss sky130_fd_pr__nfet_01v8 L=0.5u W=1u
M5349 o6 ibias vss vss sky130_fd_pr__nfet_01v8 L=0.5u W=1u
M5350 o6 ibias vss vss sky130_fd_pr__nfet_01v8 L=0.5u W=1u
M5351 o6 ibias vss vss sky130_fd_pr__nfet_01v8 L=0.5u W=1u
M5352 o6 ibias vss vss sky130_fd_pr__nfet_01v8 L=0.5u W=1u
M5353 o6 ibias vss vss sky130_fd_pr__nfet_01v8 L=0.5u W=1u
M5354 o6 ibias vss vss sky130_fd_pr__nfet_01v8 L=0.5u W=1u
M5355 o6 ibias vss vss sky130_fd_pr__nfet_01v8 L=0.5u W=1u
M5356 o6 ibias vss vss sky130_fd_pr__nfet_01v8 L=0.5u W=1u
M5357 o6 ibias vss vss sky130_fd_pr__nfet_01v8 L=0.5u W=1u
M5358 o6 ibias vss vss sky130_fd_pr__nfet_01v8 L=0.5u W=1u
M5359 o6 ibias vss vss sky130_fd_pr__nfet_01v8 L=0.5u W=1u
M5360 o6 ibias vss vss sky130_fd_pr__nfet_01v8 L=0.5u W=1u
M5361 o6 ibias vss vss sky130_fd_pr__nfet_01v8 L=0.5u W=1u
M5362 o6 ibias vss vss sky130_fd_pr__nfet_01v8 L=0.5u W=1u
M5363 o6 ibias vss vss sky130_fd_pr__nfet_01v8 L=0.5u W=1u
M5364 o6 ibias vss vss sky130_fd_pr__nfet_01v8 L=0.5u W=1u
M5365 o6 ibias vss vss sky130_fd_pr__nfet_01v8 L=0.5u W=1u
M5366 o6 ibias vss vss sky130_fd_pr__nfet_01v8 L=0.5u W=1u
M5367 o6 ibias vss vss sky130_fd_pr__nfet_01v8 L=0.5u W=1u
M5368 o6 ibias vss vss sky130_fd_pr__nfet_01v8 L=0.5u W=1u
M5369 o6 ibias vss vss sky130_fd_pr__nfet_01v8 L=0.5u W=1u
M5370 o6 ibias vss vss sky130_fd_pr__nfet_01v8 L=0.5u W=1u
M5371 o6 ibias vss vss sky130_fd_pr__nfet_01v8 L=0.5u W=1u
M5372 o6 ibias vss vss sky130_fd_pr__nfet_01v8 L=0.5u W=1u
M5373 o6 ibias vss vss sky130_fd_pr__nfet_01v8 L=0.5u W=1u
M5374 o6 ibias vss vss sky130_fd_pr__nfet_01v8 L=0.5u W=1u
M5375 o6 ibias vss vss sky130_fd_pr__nfet_01v8 L=0.5u W=1u
M5376 o6 ibias vss vss sky130_fd_pr__nfet_01v8 L=0.5u W=1u
M5377 o6 ibias vss vss sky130_fd_pr__nfet_01v8 L=0.5u W=1u
M5378 o6 ibias vss vss sky130_fd_pr__nfet_01v8 L=0.5u W=1u
M5379 o6 ibias vss vss sky130_fd_pr__nfet_01v8 L=0.5u W=1u
M5380 o6 ibias vss vss sky130_fd_pr__nfet_01v8 L=0.5u W=1u
M5381 o6 ibias vss vss sky130_fd_pr__nfet_01v8 L=0.5u W=1u
M5382 o6 ibias vss vss sky130_fd_pr__nfet_01v8 L=0.5u W=1u
M5383 o6 ibias vss vss sky130_fd_pr__nfet_01v8 L=0.5u W=1u
M5384 o6 ibias vss vss sky130_fd_pr__nfet_01v8 L=0.5u W=1u
M5385 o6 ibias vss vss sky130_fd_pr__nfet_01v8 L=0.5u W=1u
M5386 o6 ibias vss vss sky130_fd_pr__nfet_01v8 L=0.5u W=1u
M5387 o6 ibias vss vss sky130_fd_pr__nfet_01v8 L=0.5u W=1u
M5388 o6 ibias vss vss sky130_fd_pr__nfet_01v8 L=0.5u W=1u
M5389 o6 ibias vss vss sky130_fd_pr__nfet_01v8 L=0.5u W=1u
M5390 o6 ibias vss vss sky130_fd_pr__nfet_01v8 L=0.5u W=1u
M5391 o6 ibias vss vss sky130_fd_pr__nfet_01v8 L=0.5u W=1u
M5392 o6 ibias vss vss sky130_fd_pr__nfet_01v8 L=0.5u W=1u
M5393 o6 ibias vss vss sky130_fd_pr__nfet_01v8 L=0.5u W=1u
M5394 o6 ibias vss vss sky130_fd_pr__nfet_01v8 L=0.5u W=1u
M5395 o6 ibias vss vss sky130_fd_pr__nfet_01v8 L=0.5u W=1u
M5396 o6 ibias vss vss sky130_fd_pr__nfet_01v8 L=0.5u W=1u
M5397 o6 ibias vss vss sky130_fd_pr__nfet_01v8 L=0.5u W=1u
M5398 o6 ibias vss vss sky130_fd_pr__nfet_01v8 L=0.5u W=1u
M5399 o6 ibias vss vss sky130_fd_pr__nfet_01v8 L=0.5u W=1u
M5400 o6 ibias vss vss sky130_fd_pr__nfet_01v8 L=0.5u W=1u
M5401 o6 ibias vss vss sky130_fd_pr__nfet_01v8 L=0.5u W=1u
M5402 o6 ibias vss vss sky130_fd_pr__nfet_01v8 L=0.5u W=1u
M5403 o6 ibias vss vss sky130_fd_pr__nfet_01v8 L=0.5u W=1u
M5404 o6 ibias vss vss sky130_fd_pr__nfet_01v8 L=0.5u W=1u
M5405 o6 ibias vss vss sky130_fd_pr__nfet_01v8 L=0.5u W=1u
M5406 o6 ibias vss vss sky130_fd_pr__nfet_01v8 L=0.5u W=1u
M5407 o6 ibias vss vss sky130_fd_pr__nfet_01v8 L=0.5u W=1u
M5408 o6 ibias vss vss sky130_fd_pr__nfet_01v8 L=0.5u W=1u
M5409 o6 ibias vss vss sky130_fd_pr__nfet_01v8 L=0.5u W=1u
M5410 o6 ibias vss vss sky130_fd_pr__nfet_01v8 L=0.5u W=1u
M5411 o6 ibias vss vss sky130_fd_pr__nfet_01v8 L=0.5u W=1u
M5412 o6 ibias vss vss sky130_fd_pr__nfet_01v8 L=0.5u W=1u
M5413 o6 ibias vss vss sky130_fd_pr__nfet_01v8 L=0.5u W=1u
M5414 o6 ibias vss vss sky130_fd_pr__nfet_01v8 L=0.5u W=1u
M5415 o6 ibias vss vss sky130_fd_pr__nfet_01v8 L=0.5u W=1u
M5416 o6 ibias vss vss sky130_fd_pr__nfet_01v8 L=0.5u W=1u
M5417 o6 ibias vss vss sky130_fd_pr__nfet_01v8 L=0.5u W=1u
M5418 o6 ibias vss vss sky130_fd_pr__nfet_01v8 L=0.5u W=1u
M5419 o6 ibias vss vss sky130_fd_pr__nfet_01v8 L=0.5u W=1u
M5420 o6 ibias vss vss sky130_fd_pr__nfet_01v8 L=0.5u W=1u
M5421 o6 ibias vss vss sky130_fd_pr__nfet_01v8 L=0.5u W=1u
M5422 o6 ibias vss vss sky130_fd_pr__nfet_01v8 L=0.5u W=1u
M5423 o6 ibias vss vss sky130_fd_pr__nfet_01v8 L=0.5u W=1u
M5424 o6 ibias vss vss sky130_fd_pr__nfet_01v8 L=0.5u W=1u
M5425 o6 ibias vss vss sky130_fd_pr__nfet_01v8 L=0.5u W=1u
M5426 o6 ibias vss vss sky130_fd_pr__nfet_01v8 L=0.5u W=1u
M5427 o6 ibias vss vss sky130_fd_pr__nfet_01v8 L=0.5u W=1u
M5428 o6 ibias vss vss sky130_fd_pr__nfet_01v8 L=0.5u W=1u
M5429 o6 ibias vss vss sky130_fd_pr__nfet_01v8 L=0.5u W=1u
M5430 o6 ibias vss vss sky130_fd_pr__nfet_01v8 L=0.5u W=1u
M5431 o6 ibias vss vss sky130_fd_pr__nfet_01v8 L=0.5u W=1u
M5432 o6 ibias vss vss sky130_fd_pr__nfet_01v8 L=0.5u W=1u
M5433 o6 ibias vss vss sky130_fd_pr__nfet_01v8 L=0.5u W=1u
M5434 o6 ibias vss vss sky130_fd_pr__nfet_01v8 L=0.5u W=1u
M5435 o6 ibias vss vss sky130_fd_pr__nfet_01v8 L=0.5u W=1u
M5436 o6 ibias vss vss sky130_fd_pr__nfet_01v8 L=0.5u W=1u
M5437 o6 ibias vss vss sky130_fd_pr__nfet_01v8 L=0.5u W=1u
M5438 o6 ibias vss vss sky130_fd_pr__nfet_01v8 L=0.5u W=1u
M5439 o6 ibias vss vss sky130_fd_pr__nfet_01v8 L=0.5u W=1u
M5440 o6 ibias vss vss sky130_fd_pr__nfet_01v8 L=0.5u W=1u
M5441 o6 ibias vss vss sky130_fd_pr__nfet_01v8 L=0.5u W=1u
M5442 o6 ibias vss vss sky130_fd_pr__nfet_01v8 L=0.5u W=1u
M5443 o6 ibias vss vss sky130_fd_pr__nfet_01v8 L=0.5u W=1u
M5444 o6 ibias vss vss sky130_fd_pr__nfet_01v8 L=0.5u W=1u
M5445 o6 ibias vss vss sky130_fd_pr__nfet_01v8 L=0.5u W=1u
M5446 o6 ibias vss vss sky130_fd_pr__nfet_01v8 L=0.5u W=1u
M5447 o6 ibias vss vss sky130_fd_pr__nfet_01v8 L=0.5u W=1u
M5448 o6 ibias vss vss sky130_fd_pr__nfet_01v8 L=0.5u W=1u
M5449 o6 ibias vss vss sky130_fd_pr__nfet_01v8 L=0.5u W=1u
M5450 o6 ibias vss vss sky130_fd_pr__nfet_01v8 L=0.5u W=1u
M5451 o6 ibias vss vss sky130_fd_pr__nfet_01v8 L=0.5u W=1u
M5452 o6 ibias vss vss sky130_fd_pr__nfet_01v8 L=0.5u W=1u
M5453 o6 ibias vss vss sky130_fd_pr__nfet_01v8 L=0.5u W=1u
M5454 o6 ibias vss vss sky130_fd_pr__nfet_01v8 L=0.5u W=1u
M5455 o6 ibias vss vss sky130_fd_pr__nfet_01v8 L=0.5u W=1u
M5456 o6 ibias vss vss sky130_fd_pr__nfet_01v8 L=0.5u W=1u
M5457 o6 ibias vss vss sky130_fd_pr__nfet_01v8 L=0.5u W=1u
M5458 o6 ibias vss vss sky130_fd_pr__nfet_01v8 L=0.5u W=1u
M5459 o6 ibias vss vss sky130_fd_pr__nfet_01v8 L=0.5u W=1u
M5460 o6 ibias vss vss sky130_fd_pr__nfet_01v8 L=0.5u W=1u
M5461 o6 ibias vss vss sky130_fd_pr__nfet_01v8 L=0.5u W=1u
M5462 o6 ibias vss vss sky130_fd_pr__nfet_01v8 L=0.5u W=1u
M5463 o6 ibias vss vss sky130_fd_pr__nfet_01v8 L=0.5u W=1u
M5464 o6 ibias vss vss sky130_fd_pr__nfet_01v8 L=0.5u W=1u
M5465 o6 ibias vss vss sky130_fd_pr__nfet_01v8 L=0.5u W=1u
M5466 o6 ibias vss vss sky130_fd_pr__nfet_01v8 L=0.5u W=1u
M5467 o6 ibias vss vss sky130_fd_pr__nfet_01v8 L=0.5u W=1u
M5468 o6 ibias vss vss sky130_fd_pr__nfet_01v8 L=0.5u W=1u
M5469 o6 ibias vss vss sky130_fd_pr__nfet_01v8 L=0.5u W=1u
M5470 o6 ibias vss vss sky130_fd_pr__nfet_01v8 L=0.5u W=1u
M5471 o6 ibias vss vss sky130_fd_pr__nfet_01v8 L=0.5u W=1u
M5472 o6 ibias vss vss sky130_fd_pr__nfet_01v8 L=0.5u W=1u
M5473 o6 ibias vss vss sky130_fd_pr__nfet_01v8 L=0.5u W=1u
M5474 o6 ibias vss vss sky130_fd_pr__nfet_01v8 L=0.5u W=1u
M5475 o6 ibias vss vss sky130_fd_pr__nfet_01v8 L=0.5u W=1u
M5476 o6 ibias vss vss sky130_fd_pr__nfet_01v8 L=0.5u W=1u
M5477 o6 ibias vss vss sky130_fd_pr__nfet_01v8 L=0.5u W=1u
M5478 o6 ibias vss vss sky130_fd_pr__nfet_01v8 L=0.5u W=1u
M5479 o6 ibias vss vss sky130_fd_pr__nfet_01v8 L=0.5u W=1u
M5480 o6 ibias vss vss sky130_fd_pr__nfet_01v8 L=0.5u W=1u
M5481 o6 ibias vss vss sky130_fd_pr__nfet_01v8 L=0.5u W=1u
M5482 o6 ibias vss vss sky130_fd_pr__nfet_01v8 L=0.5u W=1u
M5483 o6 ibias vss vss sky130_fd_pr__nfet_01v8 L=0.5u W=1u
M5484 o6 ibias vss vss sky130_fd_pr__nfet_01v8 L=0.5u W=1u
M5485 o6 ibias vss vss sky130_fd_pr__nfet_01v8 L=0.5u W=1u
M5486 o6 ibias vss vss sky130_fd_pr__nfet_01v8 L=0.5u W=1u
M5487 o6 ibias vss vss sky130_fd_pr__nfet_01v8 L=0.5u W=1u
M5488 o6 ibias vss vss sky130_fd_pr__nfet_01v8 L=0.5u W=1u
M5489 o6 ibias vss vss sky130_fd_pr__nfet_01v8 L=0.5u W=1u
M5490 o6 ibias vss vss sky130_fd_pr__nfet_01v8 L=0.5u W=1u
M5491 o6 ibias vss vss sky130_fd_pr__nfet_01v8 L=0.5u W=1u
M5492 o6 ibias vss vss sky130_fd_pr__nfet_01v8 L=0.5u W=1u
M5493 o6 ibias vss vss sky130_fd_pr__nfet_01v8 L=0.5u W=1u
M5494 o6 ibias vss vss sky130_fd_pr__nfet_01v8 L=0.5u W=1u
M5495 o6 ibias vss vss sky130_fd_pr__nfet_01v8 L=0.5u W=1u
M5496 o6 ibias vss vss sky130_fd_pr__nfet_01v8 L=0.5u W=1u
M5497 o6 ibias vss vss sky130_fd_pr__nfet_01v8 L=0.5u W=1u
M5498 o6 ibias vss vss sky130_fd_pr__nfet_01v8 L=0.5u W=1u
M5499 o6 ibias vss vss sky130_fd_pr__nfet_01v8 L=0.5u W=1u
M5500 o6 ibias vss vss sky130_fd_pr__nfet_01v8 L=0.5u W=1u
M5501 o6 ibias vss vss sky130_fd_pr__nfet_01v8 L=0.5u W=1u
M5502 o6 ibias vss vss sky130_fd_pr__nfet_01v8 L=0.5u W=1u
M5503 o6 ibias vss vss sky130_fd_pr__nfet_01v8 L=0.5u W=1u
M5504 o6 ibias vss vss sky130_fd_pr__nfet_01v8 L=0.5u W=1u
M5505 o6 ibias vss vss sky130_fd_pr__nfet_01v8 L=0.5u W=1u
M5506 o6 ibias vss vss sky130_fd_pr__nfet_01v8 L=0.5u W=1u
M5507 o6 ibias vss vss sky130_fd_pr__nfet_01v8 L=0.5u W=1u
M5508 o6 ibias vss vss sky130_fd_pr__nfet_01v8 L=0.5u W=1u
M5509 o6 ibias vss vss sky130_fd_pr__nfet_01v8 L=0.5u W=1u
M5510 o6 ibias vss vss sky130_fd_pr__nfet_01v8 L=0.5u W=1u
M5511 o6 ibias vss vss sky130_fd_pr__nfet_01v8 L=0.5u W=1u
M5512 o6 ibias vss vss sky130_fd_pr__nfet_01v8 L=0.5u W=1u
M5513 o6 ibias vss vss sky130_fd_pr__nfet_01v8 L=0.5u W=1u
M5514 o6 ibias vss vss sky130_fd_pr__nfet_01v8 L=0.5u W=1u
M5515 o6 ibias vss vss sky130_fd_pr__nfet_01v8 L=0.5u W=1u
M5516 o6 ibias vss vss sky130_fd_pr__nfet_01v8 L=0.5u W=1u
M5517 o6 ibias vss vss sky130_fd_pr__nfet_01v8 L=0.5u W=1u
M5518 o6 ibias vss vss sky130_fd_pr__nfet_01v8 L=0.5u W=1u
M5519 o6 ibias vss vss sky130_fd_pr__nfet_01v8 L=0.5u W=1u
M5520 o6 ibias vss vss sky130_fd_pr__nfet_01v8 L=0.5u W=1u
M5521 o6 ibias vss vss sky130_fd_pr__nfet_01v8 L=0.5u W=1u
M5522 o6 ibias vss vss sky130_fd_pr__nfet_01v8 L=0.5u W=1u
M5523 o6 ibias vss vss sky130_fd_pr__nfet_01v8 L=0.5u W=1u
M5524 o6 ibias vss vss sky130_fd_pr__nfet_01v8 L=0.5u W=1u
M5525 o6 ibias vss vss sky130_fd_pr__nfet_01v8 L=0.5u W=1u
M5526 o6 ibias vss vss sky130_fd_pr__nfet_01v8 L=0.5u W=1u
M5527 o6 ibias vss vss sky130_fd_pr__nfet_01v8 L=0.5u W=1u
M5528 o6 ibias vss vss sky130_fd_pr__nfet_01v8 L=0.5u W=1u
M5529 o6 ibias vss vss sky130_fd_pr__nfet_01v8 L=0.5u W=1u
M5530 o6 ibias vss vss sky130_fd_pr__nfet_01v8 L=0.5u W=1u
M5531 o6 ibias vss vss sky130_fd_pr__nfet_01v8 L=0.5u W=1u
M5532 o6 ibias vss vss sky130_fd_pr__nfet_01v8 L=0.5u W=1u
M5533 o6 ibias vss vss sky130_fd_pr__nfet_01v8 L=0.5u W=1u
M5534 o6 ibias vss vss sky130_fd_pr__nfet_01v8 L=0.5u W=1u
M5535 o6 ibias vss vss sky130_fd_pr__nfet_01v8 L=0.5u W=1u
M5536 o6 ibias vss vss sky130_fd_pr__nfet_01v8 L=0.5u W=1u
M5537 o6 ibias vss vss sky130_fd_pr__nfet_01v8 L=0.5u W=1u
M5538 o6 ibias vss vss sky130_fd_pr__nfet_01v8 L=0.5u W=1u
M5539 o6 ibias vss vss sky130_fd_pr__nfet_01v8 L=0.5u W=1u
M5540 o6 ibias vss vss sky130_fd_pr__nfet_01v8 L=0.5u W=1u
M5541 o6 ibias vss vss sky130_fd_pr__nfet_01v8 L=0.5u W=1u
M5542 o6 ibias vss vss sky130_fd_pr__nfet_01v8 L=0.5u W=1u
M5543 o6 ibias vss vss sky130_fd_pr__nfet_01v8 L=0.5u W=1u
M5544 o6 ibias vss vss sky130_fd_pr__nfet_01v8 L=0.5u W=1u
M5545 o6 ibias vss vss sky130_fd_pr__nfet_01v8 L=0.5u W=1u
M5546 o6 ibias vss vss sky130_fd_pr__nfet_01v8 L=0.5u W=1u
M5547 o6 ibias vss vss sky130_fd_pr__nfet_01v8 L=0.5u W=1u
M5548 o6 ibias vss vss sky130_fd_pr__nfet_01v8 L=0.5u W=1u
M5549 o6 ibias vss vss sky130_fd_pr__nfet_01v8 L=0.5u W=1u
M5550 o6 ibias vss vss sky130_fd_pr__nfet_01v8 L=0.5u W=1u
M5551 o6 ibias vss vss sky130_fd_pr__nfet_01v8 L=0.5u W=1u
M5552 o6 ibias vss vss sky130_fd_pr__nfet_01v8 L=0.5u W=1u
M5553 o6 ibias vss vss sky130_fd_pr__nfet_01v8 L=0.5u W=1u
M5554 o6 ibias vss vss sky130_fd_pr__nfet_01v8 L=0.5u W=1u
M5555 o6 ibias vss vss sky130_fd_pr__nfet_01v8 L=0.5u W=1u
M5556 o6 ibias vss vss sky130_fd_pr__nfet_01v8 L=0.5u W=1u
M5557 o6 ibias vss vss sky130_fd_pr__nfet_01v8 L=0.5u W=1u
M5558 o6 ibias vss vss sky130_fd_pr__nfet_01v8 L=0.5u W=1u
M5559 o6 ibias vss vss sky130_fd_pr__nfet_01v8 L=0.5u W=1u
M5560 o6 ibias vss vss sky130_fd_pr__nfet_01v8 L=0.5u W=1u
M5561 o6 ibias vss vss sky130_fd_pr__nfet_01v8 L=0.5u W=1u
M5562 o6 ibias vss vss sky130_fd_pr__nfet_01v8 L=0.5u W=1u
M5563 o6 ibias vss vss sky130_fd_pr__nfet_01v8 L=0.5u W=1u
M5564 o6 ibias vss vss sky130_fd_pr__nfet_01v8 L=0.5u W=1u
M5565 o6 ibias vss vss sky130_fd_pr__nfet_01v8 L=0.5u W=1u
M5566 o6 ibias vss vss sky130_fd_pr__nfet_01v8 L=0.5u W=1u
M5567 o6 ibias vss vss sky130_fd_pr__nfet_01v8 L=0.5u W=1u
M5568 o6 ibias vss vss sky130_fd_pr__nfet_01v8 L=0.5u W=1u
M5569 o6 ibias vss vss sky130_fd_pr__nfet_01v8 L=0.5u W=1u
M5570 o6 ibias vss vss sky130_fd_pr__nfet_01v8 L=0.5u W=1u
M5571 o6 ibias vss vss sky130_fd_pr__nfet_01v8 L=0.5u W=1u
M5572 o6 ibias vss vss sky130_fd_pr__nfet_01v8 L=0.5u W=1u
M5573 o6 ibias vss vss sky130_fd_pr__nfet_01v8 L=0.5u W=1u
M5574 o6 ibias vss vss sky130_fd_pr__nfet_01v8 L=0.5u W=1u
M5575 o6 ibias vss vss sky130_fd_pr__nfet_01v8 L=0.5u W=1u
M5576 o6 ibias vss vss sky130_fd_pr__nfet_01v8 L=0.5u W=1u
M5577 o6 ibias vss vss sky130_fd_pr__nfet_01v8 L=0.5u W=1u
M5578 o6 ibias vss vss sky130_fd_pr__nfet_01v8 L=0.5u W=1u
M5579 o6 ibias vss vss sky130_fd_pr__nfet_01v8 L=0.5u W=1u
M5580 o6 ibias vss vss sky130_fd_pr__nfet_01v8 L=0.5u W=1u
M5581 o6 ibias vss vss sky130_fd_pr__nfet_01v8 L=0.5u W=1u
M5582 o6 ibias vss vss sky130_fd_pr__nfet_01v8 L=0.5u W=1u
M5583 o6 ibias vss vss sky130_fd_pr__nfet_01v8 L=0.5u W=1u
M5584 o6 ibias vss vss sky130_fd_pr__nfet_01v8 L=0.5u W=1u
M5585 o6 ibias vss vss sky130_fd_pr__nfet_01v8 L=0.5u W=1u
M5586 o6 ibias vss vss sky130_fd_pr__nfet_01v8 L=0.5u W=1u
M5587 o6 ibias vss vss sky130_fd_pr__nfet_01v8 L=0.5u W=1u
M5588 o6 ibias vss vss sky130_fd_pr__nfet_01v8 L=0.5u W=1u
M5589 o6 ibias vss vss sky130_fd_pr__nfet_01v8 L=0.5u W=1u
M5590 o6 ibias vss vss sky130_fd_pr__nfet_01v8 L=0.5u W=1u
M5591 o6 ibias vss vss sky130_fd_pr__nfet_01v8 L=0.5u W=1u
M5592 o6 ibias vss vss sky130_fd_pr__nfet_01v8 L=0.5u W=1u
M5593 o6 ibias vss vss sky130_fd_pr__nfet_01v8 L=0.5u W=1u
M5594 o6 ibias vss vss sky130_fd_pr__nfet_01v8 L=0.5u W=1u
M5595 o6 ibias vss vss sky130_fd_pr__nfet_01v8 L=0.5u W=1u
M5596 o6 ibias vss vss sky130_fd_pr__nfet_01v8 L=0.5u W=1u
M5597 o6 ibias vss vss sky130_fd_pr__nfet_01v8 L=0.5u W=1u
M5598 o6 ibias vss vss sky130_fd_pr__nfet_01v8 L=0.5u W=1u
M5599 o6 ibias vss vss sky130_fd_pr__nfet_01v8 L=0.5u W=1u
M5600 o6 ibias vss vss sky130_fd_pr__nfet_01v8 L=0.5u W=1u
M5601 o6 ibias vss vss sky130_fd_pr__nfet_01v8 L=0.5u W=1u
M5602 o6 ibias vss vss sky130_fd_pr__nfet_01v8 L=0.5u W=1u
M5603 o6 ibias vss vss sky130_fd_pr__nfet_01v8 L=0.5u W=1u
M5604 o6 ibias vss vss sky130_fd_pr__nfet_01v8 L=0.5u W=1u
M5605 o6 ibias vss vss sky130_fd_pr__nfet_01v8 L=0.5u W=1u
M5606 o6 ibias vss vss sky130_fd_pr__nfet_01v8 L=0.5u W=1u
M5607 o6 ibias vss vss sky130_fd_pr__nfet_01v8 L=0.5u W=1u
M5608 o6 ibias vss vss sky130_fd_pr__nfet_01v8 L=0.5u W=1u
M5609 o6 ibias vss vss sky130_fd_pr__nfet_01v8 L=0.5u W=1u
M5610 o6 ibias vss vss sky130_fd_pr__nfet_01v8 L=0.5u W=1u
M5611 o6 ibias vss vss sky130_fd_pr__nfet_01v8 L=0.5u W=1u
M5612 o6 ibias vss vss sky130_fd_pr__nfet_01v8 L=0.5u W=1u
M5613 o6 ibias vss vss sky130_fd_pr__nfet_01v8 L=0.5u W=1u
M5614 o6 ibias vss vss sky130_fd_pr__nfet_01v8 L=0.5u W=1u
M5615 o6 ibias vss vss sky130_fd_pr__nfet_01v8 L=0.5u W=1u
M5616 o6 ibias vss vss sky130_fd_pr__nfet_01v8 L=0.5u W=1u
M5617 o6 ibias vss vss sky130_fd_pr__nfet_01v8 L=0.5u W=1u
M5618 o6 ibias vss vss sky130_fd_pr__nfet_01v8 L=0.5u W=1u
M5619 o6 ibias vss vss sky130_fd_pr__nfet_01v8 L=0.5u W=1u
M5620 o6 ibias vss vss sky130_fd_pr__nfet_01v8 L=0.5u W=1u
M5621 o6 ibias vss vss sky130_fd_pr__nfet_01v8 L=0.5u W=1u
M5622 o6 ibias vss vss sky130_fd_pr__nfet_01v8 L=0.5u W=1u
M5623 o6 ibias vss vss sky130_fd_pr__nfet_01v8 L=0.5u W=1u
M5624 o6 ibias vss vss sky130_fd_pr__nfet_01v8 L=0.5u W=1u
M5625 o6 ibias vss vss sky130_fd_pr__nfet_01v8 L=0.5u W=1u
M5626 o6 ibias vss vss sky130_fd_pr__nfet_01v8 L=0.5u W=1u
M5627 o6 ibias vss vss sky130_fd_pr__nfet_01v8 L=0.5u W=1u
M5628 o6 ibias vss vss sky130_fd_pr__nfet_01v8 L=0.5u W=1u
M5629 o6 ibias vss vss sky130_fd_pr__nfet_01v8 L=0.5u W=1u
M5630 o6 ibias vss vss sky130_fd_pr__nfet_01v8 L=0.5u W=1u
M5631 o6 ibias vss vss sky130_fd_pr__nfet_01v8 L=0.5u W=1u
M5632 o6 ibias vss vss sky130_fd_pr__nfet_01v8 L=0.5u W=1u
M5633 o6 ibias vss vss sky130_fd_pr__nfet_01v8 L=0.5u W=1u
M5634 o6 ibias vss vss sky130_fd_pr__nfet_01v8 L=0.5u W=1u
M5635 o6 ibias vss vss sky130_fd_pr__nfet_01v8 L=0.5u W=1u
M5636 o6 ibias vss vss sky130_fd_pr__nfet_01v8 L=0.5u W=1u
M5637 o6 ibias vss vss sky130_fd_pr__nfet_01v8 L=0.5u W=1u
M5638 o6 ibias vss vss sky130_fd_pr__nfet_01v8 L=0.5u W=1u
M5639 o6 ibias vss vss sky130_fd_pr__nfet_01v8 L=0.5u W=1u
M5640 o6 ibias vss vss sky130_fd_pr__nfet_01v8 L=0.5u W=1u
M5641 o6 ibias vss vss sky130_fd_pr__nfet_01v8 L=0.5u W=1u
M5642 o6 ibias vss vss sky130_fd_pr__nfet_01v8 L=0.5u W=1u
M5643 o6 ibias vss vss sky130_fd_pr__nfet_01v8 L=0.5u W=1u
M5644 o6 ibias vss vss sky130_fd_pr__nfet_01v8 L=0.5u W=1u
M5645 o6 ibias vss vss sky130_fd_pr__nfet_01v8 L=0.5u W=1u
M5646 o6 ibias vss vss sky130_fd_pr__nfet_01v8 L=0.5u W=1u
M5647 o6 ibias vss vss sky130_fd_pr__nfet_01v8 L=0.5u W=1u
M5648 o6 ibias vss vss sky130_fd_pr__nfet_01v8 L=0.5u W=1u
M5649 o6 ibias vss vss sky130_fd_pr__nfet_01v8 L=0.5u W=1u
M5650 o6 ibias vss vss sky130_fd_pr__nfet_01v8 L=0.5u W=1u
M5651 o6 ibias vss vss sky130_fd_pr__nfet_01v8 L=0.5u W=1u
M5652 o6 ibias vss vss sky130_fd_pr__nfet_01v8 L=0.5u W=1u
M5653 o6 ibias vss vss sky130_fd_pr__nfet_01v8 L=0.5u W=1u
M5654 o6 ibias vss vss sky130_fd_pr__nfet_01v8 L=0.5u W=1u
M5655 o6 ibias vss vss sky130_fd_pr__nfet_01v8 L=0.5u W=1u
M5656 o6 ibias vss vss sky130_fd_pr__nfet_01v8 L=0.5u W=1u
M5657 o6 ibias vss vss sky130_fd_pr__nfet_01v8 L=0.5u W=1u
M5658 o6 ibias vss vss sky130_fd_pr__nfet_01v8 L=0.5u W=1u
M5659 o6 ibias vss vss sky130_fd_pr__nfet_01v8 L=0.5u W=1u
M5660 o6 ibias vss vss sky130_fd_pr__nfet_01v8 L=0.5u W=1u
M5661 o6 ibias vss vss sky130_fd_pr__nfet_01v8 L=0.5u W=1u
M5662 o6 ibias vss vss sky130_fd_pr__nfet_01v8 L=0.5u W=1u
M5663 o6 ibias vss vss sky130_fd_pr__nfet_01v8 L=0.5u W=1u
M5664 o6 ibias vss vss sky130_fd_pr__nfet_01v8 L=0.5u W=1u
M5665 o6 ibias vss vss sky130_fd_pr__nfet_01v8 L=0.5u W=1u
M5666 o6 ibias vss vss sky130_fd_pr__nfet_01v8 L=0.5u W=1u
M5667 o6 ibias vss vss sky130_fd_pr__nfet_01v8 L=0.5u W=1u
M5668 o6 ibias vss vss sky130_fd_pr__nfet_01v8 L=0.5u W=1u
M5669 o6 ibias vss vss sky130_fd_pr__nfet_01v8 L=0.5u W=1u
M5670 o6 ibias vss vss sky130_fd_pr__nfet_01v8 L=0.5u W=1u
M5671 o6 ibias vss vss sky130_fd_pr__nfet_01v8 L=0.5u W=1u
M5672 o6 ibias vss vss sky130_fd_pr__nfet_01v8 L=0.5u W=1u
M5673 o6 ibias vss vss sky130_fd_pr__nfet_01v8 L=0.5u W=1u
M5674 o6 ibias vss vss sky130_fd_pr__nfet_01v8 L=0.5u W=1u
M5675 o6 ibias vss vss sky130_fd_pr__nfet_01v8 L=0.5u W=1u
M5676 o6 ibias vss vss sky130_fd_pr__nfet_01v8 L=0.5u W=1u
M5677 o6 ibias vss vss sky130_fd_pr__nfet_01v8 L=0.5u W=1u
M5678 o6 ibias vss vss sky130_fd_pr__nfet_01v8 L=0.5u W=1u
M5679 o6 ibias vss vss sky130_fd_pr__nfet_01v8 L=0.5u W=1u
M5680 o6 ibias vss vss sky130_fd_pr__nfet_01v8 L=0.5u W=1u
M5681 o6 ibias vss vss sky130_fd_pr__nfet_01v8 L=0.5u W=1u
M5682 o6 ibias vss vss sky130_fd_pr__nfet_01v8 L=0.5u W=1u
M5683 o6 ibias vss vss sky130_fd_pr__nfet_01v8 L=0.5u W=1u
M5684 o6 ibias vss vss sky130_fd_pr__nfet_01v8 L=0.5u W=1u
M5685 o6 ibias vss vss sky130_fd_pr__nfet_01v8 L=0.5u W=1u
M5686 o6 ibias vss vss sky130_fd_pr__nfet_01v8 L=0.5u W=1u
M5687 o6 ibias vss vss sky130_fd_pr__nfet_01v8 L=0.5u W=1u
M5688 o6 ibias vss vss sky130_fd_pr__nfet_01v8 L=0.5u W=1u
M5689 o6 ibias vss vss sky130_fd_pr__nfet_01v8 L=0.5u W=1u
M5690 o6 ibias vss vss sky130_fd_pr__nfet_01v8 L=0.5u W=1u
M5691 o6 ibias vss vss sky130_fd_pr__nfet_01v8 L=0.5u W=1u
M5692 o6 ibias vss vss sky130_fd_pr__nfet_01v8 L=0.5u W=1u
M5693 o6 ibias vss vss sky130_fd_pr__nfet_01v8 L=0.5u W=1u
M5694 o6 ibias vss vss sky130_fd_pr__nfet_01v8 L=0.5u W=1u
M5695 o6 ibias vss vss sky130_fd_pr__nfet_01v8 L=0.5u W=1u
M5696 o6 ibias vss vss sky130_fd_pr__nfet_01v8 L=0.5u W=1u
M5697 o6 ibias vss vss sky130_fd_pr__nfet_01v8 L=0.5u W=1u
M5698 o6 ibias vss vss sky130_fd_pr__nfet_01v8 L=0.5u W=1u
M5699 o6 ibias vss vss sky130_fd_pr__nfet_01v8 L=0.5u W=1u
M5700 o6 ibias vss vss sky130_fd_pr__nfet_01v8 L=0.5u W=1u
M5701 o6 ibias vss vss sky130_fd_pr__nfet_01v8 L=0.5u W=1u
M5702 o6 ibias vss vss sky130_fd_pr__nfet_01v8 L=0.5u W=1u
M5703 o6 ibias vss vss sky130_fd_pr__nfet_01v8 L=0.5u W=1u
M5704 o6 ibias vss vss sky130_fd_pr__nfet_01v8 L=0.5u W=1u
M5705 o6 ibias vss vss sky130_fd_pr__nfet_01v8 L=0.5u W=1u
M5706 o6 ibias vss vss sky130_fd_pr__nfet_01v8 L=0.5u W=1u
M5707 o6 ibias vss vss sky130_fd_pr__nfet_01v8 L=0.5u W=1u
M5708 o6 ibias vss vss sky130_fd_pr__nfet_01v8 L=0.5u W=1u
M5709 o6 ibias vss vss sky130_fd_pr__nfet_01v8 L=0.5u W=1u
M5710 o6 ibias vss vss sky130_fd_pr__nfet_01v8 L=0.5u W=1u
M5711 o6 ibias vss vss sky130_fd_pr__nfet_01v8 L=0.5u W=1u
M5712 o6 ibias vss vss sky130_fd_pr__nfet_01v8 L=0.5u W=1u
M5713 o6 ibias vss vss sky130_fd_pr__nfet_01v8 L=0.5u W=1u
M5714 o6 ibias vss vss sky130_fd_pr__nfet_01v8 L=0.5u W=1u
M5715 o6 ibias vss vss sky130_fd_pr__nfet_01v8 L=0.5u W=1u
M5716 o6 ibias vss vss sky130_fd_pr__nfet_01v8 L=0.5u W=1u
M5717 o6 ibias vss vss sky130_fd_pr__nfet_01v8 L=0.5u W=1u
M5718 o6 ibias vss vss sky130_fd_pr__nfet_01v8 L=0.5u W=1u
M5719 o6 ibias vss vss sky130_fd_pr__nfet_01v8 L=0.5u W=1u
M5720 o6 ibias vss vss sky130_fd_pr__nfet_01v8 L=0.5u W=1u
M5721 o6 ibias vss vss sky130_fd_pr__nfet_01v8 L=0.5u W=1u
M5722 o6 ibias vss vss sky130_fd_pr__nfet_01v8 L=0.5u W=1u
M5723 o6 ibias vss vss sky130_fd_pr__nfet_01v8 L=0.5u W=1u
M5724 o6 ibias vss vss sky130_fd_pr__nfet_01v8 L=0.5u W=1u
M5725 o6 ibias vss vss sky130_fd_pr__nfet_01v8 L=0.5u W=1u
M5726 o6 ibias vss vss sky130_fd_pr__nfet_01v8 L=0.5u W=1u
M5727 o6 ibias vss vss sky130_fd_pr__nfet_01v8 L=0.5u W=1u
M5728 o6 ibias vss vss sky130_fd_pr__nfet_01v8 L=0.5u W=1u
M5729 o6 ibias vss vss sky130_fd_pr__nfet_01v8 L=0.5u W=1u
M5730 o6 ibias vss vss sky130_fd_pr__nfet_01v8 L=0.5u W=1u
M5731 o6 ibias vss vss sky130_fd_pr__nfet_01v8 L=0.5u W=1u
M5732 o6 ibias vss vss sky130_fd_pr__nfet_01v8 L=0.5u W=1u
M5733 o6 ibias vss vss sky130_fd_pr__nfet_01v8 L=0.5u W=1u
M5734 o6 ibias vss vss sky130_fd_pr__nfet_01v8 L=0.5u W=1u
M5735 o6 ibias vss vss sky130_fd_pr__nfet_01v8 L=0.5u W=1u
M5736 o6 ibias vss vss sky130_fd_pr__nfet_01v8 L=0.5u W=1u
M5737 o6 ibias vss vss sky130_fd_pr__nfet_01v8 L=0.5u W=1u
M5738 o6 ibias vss vss sky130_fd_pr__nfet_01v8 L=0.5u W=1u
M5739 o6 ibias vss vss sky130_fd_pr__nfet_01v8 L=0.5u W=1u
M5740 o6 ibias vss vss sky130_fd_pr__nfet_01v8 L=0.5u W=1u
M5741 o6 ibias vss vss sky130_fd_pr__nfet_01v8 L=0.5u W=1u
M5742 o6 ibias vss vss sky130_fd_pr__nfet_01v8 L=0.5u W=1u
M5743 o6 ibias vss vss sky130_fd_pr__nfet_01v8 L=0.5u W=1u
M5744 o6 ibias vss vss sky130_fd_pr__nfet_01v8 L=0.5u W=1u
M5745 o6 ibias vss vss sky130_fd_pr__nfet_01v8 L=0.5u W=1u
M5746 o6 ibias vss vss sky130_fd_pr__nfet_01v8 L=0.5u W=1u
M5747 o6 ibias vss vss sky130_fd_pr__nfet_01v8 L=0.5u W=1u
M5748 o6 ibias vss vss sky130_fd_pr__nfet_01v8 L=0.5u W=1u
M5749 o6 ibias vss vss sky130_fd_pr__nfet_01v8 L=0.5u W=1u
M5750 o6 ibias vss vss sky130_fd_pr__nfet_01v8 L=0.5u W=1u
M5751 o6 ibias vss vss sky130_fd_pr__nfet_01v8 L=0.5u W=1u
M5752 o6 ibias vss vss sky130_fd_pr__nfet_01v8 L=0.5u W=1u
M5753 o6 ibias vss vss sky130_fd_pr__nfet_01v8 L=0.5u W=1u
M5754 o6 ibias vss vss sky130_fd_pr__nfet_01v8 L=0.5u W=1u
M5755 o6 ibias vss vss sky130_fd_pr__nfet_01v8 L=0.5u W=1u
M5756 o6 ibias vss vss sky130_fd_pr__nfet_01v8 L=0.5u W=1u
M5757 o6 ibias vss vss sky130_fd_pr__nfet_01v8 L=0.5u W=1u
M5758 o6 ibias vss vss sky130_fd_pr__nfet_01v8 L=0.5u W=1u
M5759 o6 ibias vss vss sky130_fd_pr__nfet_01v8 L=0.5u W=1u
M5760 o6 ibias vss vss sky130_fd_pr__nfet_01v8 L=0.5u W=1u
M5761 o6 ibias vss vss sky130_fd_pr__nfet_01v8 L=0.5u W=1u
M5762 o6 ibias vss vss sky130_fd_pr__nfet_01v8 L=0.5u W=1u
M5763 o6 ibias vss vss sky130_fd_pr__nfet_01v8 L=0.5u W=1u
M5764 o6 ibias vss vss sky130_fd_pr__nfet_01v8 L=0.5u W=1u
M5765 o6 ibias vss vss sky130_fd_pr__nfet_01v8 L=0.5u W=1u
M5766 o6 ibias vss vss sky130_fd_pr__nfet_01v8 L=0.5u W=1u
M5767 o6 ibias vss vss sky130_fd_pr__nfet_01v8 L=0.5u W=1u
M5768 o6 ibias vss vss sky130_fd_pr__nfet_01v8 L=0.5u W=1u
M5769 o6 ibias vss vss sky130_fd_pr__nfet_01v8 L=0.5u W=1u
M5770 o6 ibias vss vss sky130_fd_pr__nfet_01v8 L=0.5u W=1u
M5771 o6 ibias vss vss sky130_fd_pr__nfet_01v8 L=0.5u W=1u
M5772 o6 ibias vss vss sky130_fd_pr__nfet_01v8 L=0.5u W=1u
M5773 o6 ibias vss vss sky130_fd_pr__nfet_01v8 L=0.5u W=1u
M5774 o6 ibias vss vss sky130_fd_pr__nfet_01v8 L=0.5u W=1u
M5775 o6 ibias vss vss sky130_fd_pr__nfet_01v8 L=0.5u W=1u
M5776 o6 ibias vss vss sky130_fd_pr__nfet_01v8 L=0.5u W=1u
M5777 o6 ibias vss vss sky130_fd_pr__nfet_01v8 L=0.5u W=1u
M5778 o6 ibias vss vss sky130_fd_pr__nfet_01v8 L=0.5u W=1u
M5779 o6 ibias vss vss sky130_fd_pr__nfet_01v8 L=0.5u W=1u
M5780 o6 ibias vss vss sky130_fd_pr__nfet_01v8 L=0.5u W=1u
M5781 o6 ibias vss vss sky130_fd_pr__nfet_01v8 L=0.5u W=1u
M5782 o6 ibias vss vss sky130_fd_pr__nfet_01v8 L=0.5u W=1u
M5783 o6 ibias vss vss sky130_fd_pr__nfet_01v8 L=0.5u W=1u
M5784 o6 ibias vss vss sky130_fd_pr__nfet_01v8 L=0.5u W=1u
M5785 o6 ibias vss vss sky130_fd_pr__nfet_01v8 L=0.5u W=1u
M5786 o6 ibias vss vss sky130_fd_pr__nfet_01v8 L=0.5u W=1u
M5787 o6 ibias vss vss sky130_fd_pr__nfet_01v8 L=0.5u W=1u
M5788 o6 ibias vss vss sky130_fd_pr__nfet_01v8 L=0.5u W=1u
M5789 o6 ibias vss vss sky130_fd_pr__nfet_01v8 L=0.5u W=1u
M5790 o6 ibias vss vss sky130_fd_pr__nfet_01v8 L=0.5u W=1u
M5791 o6 ibias vss vss sky130_fd_pr__nfet_01v8 L=0.5u W=1u
M5792 o6 ibias vss vss sky130_fd_pr__nfet_01v8 L=0.5u W=1u
M5793 o6 ibias vss vss sky130_fd_pr__nfet_01v8 L=0.5u W=1u
M5794 o6 ibias vss vss sky130_fd_pr__nfet_01v8 L=0.5u W=1u
M5795 o6 ibias vss vss sky130_fd_pr__nfet_01v8 L=0.5u W=1u
M5796 o6 ibias vss vss sky130_fd_pr__nfet_01v8 L=0.5u W=1u
M5797 o6 ibias vss vss sky130_fd_pr__nfet_01v8 L=0.5u W=1u
M5798 o6 ibias vss vss sky130_fd_pr__nfet_01v8 L=0.5u W=1u
M5799 o6 ibias vss vss sky130_fd_pr__nfet_01v8 L=0.5u W=1u
M5800 o6 ibias vss vss sky130_fd_pr__nfet_01v8 L=0.5u W=1u
M5801 o6 ibias vss vss sky130_fd_pr__nfet_01v8 L=0.5u W=1u
M5802 o6 ibias vss vss sky130_fd_pr__nfet_01v8 L=0.5u W=1u
M5803 o6 ibias vss vss sky130_fd_pr__nfet_01v8 L=0.5u W=1u
M5804 o6 ibias vss vss sky130_fd_pr__nfet_01v8 L=0.5u W=1u
M5805 o6 ibias vss vss sky130_fd_pr__nfet_01v8 L=0.5u W=1u
M5806 o6 ibias vss vss sky130_fd_pr__nfet_01v8 L=0.5u W=1u
M5807 o6 ibias vss vss sky130_fd_pr__nfet_01v8 L=0.5u W=1u
M5808 o6 ibias vss vss sky130_fd_pr__nfet_01v8 L=0.5u W=1u
M5809 o6 ibias vss vss sky130_fd_pr__nfet_01v8 L=0.5u W=1u
M5810 o6 ibias vss vss sky130_fd_pr__nfet_01v8 L=0.5u W=1u
M5811 o6 ibias vss vss sky130_fd_pr__nfet_01v8 L=0.5u W=1u
M5812 o6 ibias vss vss sky130_fd_pr__nfet_01v8 L=0.5u W=1u
M5813 o6 ibias vss vss sky130_fd_pr__nfet_01v8 L=0.5u W=1u
M5814 o6 ibias vss vss sky130_fd_pr__nfet_01v8 L=0.5u W=1u
M5815 o6 ibias vss vss sky130_fd_pr__nfet_01v8 L=0.5u W=1u
M5816 o6 ibias vss vss sky130_fd_pr__nfet_01v8 L=0.5u W=1u
M5817 o6 ibias vss vss sky130_fd_pr__nfet_01v8 L=0.5u W=1u
M5818 o6 ibias vss vss sky130_fd_pr__nfet_01v8 L=0.5u W=1u
M5819 o6 ibias vss vss sky130_fd_pr__nfet_01v8 L=0.5u W=1u
M5820 o6 ibias vss vss sky130_fd_pr__nfet_01v8 L=0.5u W=1u
M5821 o6 ibias vss vss sky130_fd_pr__nfet_01v8 L=0.5u W=1u
M5822 o6 ibias vss vss sky130_fd_pr__nfet_01v8 L=0.5u W=1u
M5823 o6 ibias vss vss sky130_fd_pr__nfet_01v8 L=0.5u W=1u
M5824 o6 ibias vss vss sky130_fd_pr__nfet_01v8 L=0.5u W=1u
M5825 o6 ibias vss vss sky130_fd_pr__nfet_01v8 L=0.5u W=1u
M5826 o6 ibias vss vss sky130_fd_pr__nfet_01v8 L=0.5u W=1u
M5827 o6 ibias vss vss sky130_fd_pr__nfet_01v8 L=0.5u W=1u
M5828 o6 ibias vss vss sky130_fd_pr__nfet_01v8 L=0.5u W=1u
M5829 o6 ibias vss vss sky130_fd_pr__nfet_01v8 L=0.5u W=1u
M5830 o6 ibias vss vss sky130_fd_pr__nfet_01v8 L=0.5u W=1u
M5831 o6 ibias vss vss sky130_fd_pr__nfet_01v8 L=0.5u W=1u
M5832 o6 ibias vss vss sky130_fd_pr__nfet_01v8 L=0.5u W=1u
M5833 o6 ibias vss vss sky130_fd_pr__nfet_01v8 L=0.5u W=1u
M5834 o6 ibias vss vss sky130_fd_pr__nfet_01v8 L=0.5u W=1u
M5835 o6 ibias vss vss sky130_fd_pr__nfet_01v8 L=0.5u W=1u
M5836 o6 ibias vss vss sky130_fd_pr__nfet_01v8 L=0.5u W=1u
M5837 o6 ibias vss vss sky130_fd_pr__nfet_01v8 L=0.5u W=1u
M5838 o6 ibias vss vss sky130_fd_pr__nfet_01v8 L=0.5u W=1u
M5839 o6 ibias vss vss sky130_fd_pr__nfet_01v8 L=0.5u W=1u
M5840 o6 ibias vss vss sky130_fd_pr__nfet_01v8 L=0.5u W=1u
M5841 o6 ibias vss vss sky130_fd_pr__nfet_01v8 L=0.5u W=1u
M5842 o6 ibias vss vss sky130_fd_pr__nfet_01v8 L=0.5u W=1u
M5843 o6 ibias vss vss sky130_fd_pr__nfet_01v8 L=0.5u W=1u
M5844 o6 ibias vss vss sky130_fd_pr__nfet_01v8 L=0.5u W=1u
M5845 o6 ibias vss vss sky130_fd_pr__nfet_01v8 L=0.5u W=1u
M5846 o6 ibias vss vss sky130_fd_pr__nfet_01v8 L=0.5u W=1u
M5847 o6 ibias vss vss sky130_fd_pr__nfet_01v8 L=0.5u W=1u
M5848 o6 ibias vss vss sky130_fd_pr__nfet_01v8 L=0.5u W=1u
M5849 o6 ibias vss vss sky130_fd_pr__nfet_01v8 L=0.5u W=1u
M5850 o6 ibias vss vss sky130_fd_pr__nfet_01v8 L=0.5u W=1u
M5851 o6 ibias vss vss sky130_fd_pr__nfet_01v8 L=0.5u W=1u
M5852 o6 ibias vss vss sky130_fd_pr__nfet_01v8 L=0.5u W=1u
M5853 o6 ibias vss vss sky130_fd_pr__nfet_01v8 L=0.5u W=1u
M5854 o6 ibias vss vss sky130_fd_pr__nfet_01v8 L=0.5u W=1u
M5855 o6 ibias vss vss sky130_fd_pr__nfet_01v8 L=0.5u W=1u
M5856 o6 ibias vss vss sky130_fd_pr__nfet_01v8 L=0.5u W=1u
M5857 o6 ibias vss vss sky130_fd_pr__nfet_01v8 L=0.5u W=1u
M5858 o6 ibias vss vss sky130_fd_pr__nfet_01v8 L=0.5u W=1u
M5859 o6 ibias vss vss sky130_fd_pr__nfet_01v8 L=0.5u W=1u
M5860 o6 ibias vss vss sky130_fd_pr__nfet_01v8 L=0.5u W=1u
M5861 o6 ibias vss vss sky130_fd_pr__nfet_01v8 L=0.5u W=1u
M5862 o6 ibias vss vss sky130_fd_pr__nfet_01v8 L=0.5u W=1u
M5863 o6 ibias vss vss sky130_fd_pr__nfet_01v8 L=0.5u W=1u
M5864 o6 ibias vss vss sky130_fd_pr__nfet_01v8 L=0.5u W=1u
M5865 o6 ibias vss vss sky130_fd_pr__nfet_01v8 L=0.5u W=1u
M5866 o6 ibias vss vss sky130_fd_pr__nfet_01v8 L=0.5u W=1u
M5867 o6 ibias vss vss sky130_fd_pr__nfet_01v8 L=0.5u W=1u
M5868 o6 ibias vss vss sky130_fd_pr__nfet_01v8 L=0.5u W=1u
M5869 o6 ibias vss vss sky130_fd_pr__nfet_01v8 L=0.5u W=1u
M5870 o6 ibias vss vss sky130_fd_pr__nfet_01v8 L=0.5u W=1u
M5871 o6 ibias vss vss sky130_fd_pr__nfet_01v8 L=0.5u W=1u
M5872 o6 ibias vss vss sky130_fd_pr__nfet_01v8 L=0.5u W=1u
M5873 o6 ibias vss vss sky130_fd_pr__nfet_01v8 L=0.5u W=1u
M5874 o6 ibias vss vss sky130_fd_pr__nfet_01v8 L=0.5u W=1u
M5875 o6 ibias vss vss sky130_fd_pr__nfet_01v8 L=0.5u W=1u
M5876 o6 ibias vss vss sky130_fd_pr__nfet_01v8 L=0.5u W=1u
M5877 o6 ibias vss vss sky130_fd_pr__nfet_01v8 L=0.5u W=1u
M5878 o6 ibias vss vss sky130_fd_pr__nfet_01v8 L=0.5u W=1u
M5879 o6 ibias vss vss sky130_fd_pr__nfet_01v8 L=0.5u W=1u
M5880 o6 ibias vss vss sky130_fd_pr__nfet_01v8 L=0.5u W=1u
M5881 o6 ibias vss vss sky130_fd_pr__nfet_01v8 L=0.5u W=1u
M5882 o6 ibias vss vss sky130_fd_pr__nfet_01v8 L=0.5u W=1u
M5883 o6 ibias vss vss sky130_fd_pr__nfet_01v8 L=0.5u W=1u
M5884 o6 ibias vss vss sky130_fd_pr__nfet_01v8 L=0.5u W=1u
M5885 o6 ibias vss vss sky130_fd_pr__nfet_01v8 L=0.5u W=1u
M5886 o6 ibias vss vss sky130_fd_pr__nfet_01v8 L=0.5u W=1u
M5887 o6 ibias vss vss sky130_fd_pr__nfet_01v8 L=0.5u W=1u
M5888 o6 ibias vss vss sky130_fd_pr__nfet_01v8 L=0.5u W=1u
M5889 o6 ibias vss vss sky130_fd_pr__nfet_01v8 L=0.5u W=1u
M5890 o6 ibias vss vss sky130_fd_pr__nfet_01v8 L=0.5u W=1u
M5891 o6 ibias vss vss sky130_fd_pr__nfet_01v8 L=0.5u W=1u
M5892 o6 ibias vss vss sky130_fd_pr__nfet_01v8 L=0.5u W=1u
M5893 o6 ibias vss vss sky130_fd_pr__nfet_01v8 L=0.5u W=1u
M5894 o6 ibias vss vss sky130_fd_pr__nfet_01v8 L=0.5u W=1u
M5895 o6 ibias vss vss sky130_fd_pr__nfet_01v8 L=0.5u W=1u
M5896 o6 ibias vss vss sky130_fd_pr__nfet_01v8 L=0.5u W=1u
M5897 o6 ibias vss vss sky130_fd_pr__nfet_01v8 L=0.5u W=1u
M5898 o6 ibias vss vss sky130_fd_pr__nfet_01v8 L=0.5u W=1u
M5899 o6 ibias vss vss sky130_fd_pr__nfet_01v8 L=0.5u W=1u
M5900 o6 ibias vss vss sky130_fd_pr__nfet_01v8 L=0.5u W=1u
M5901 o6 ibias vss vss sky130_fd_pr__nfet_01v8 L=0.5u W=1u
M5902 o6 ibias vss vss sky130_fd_pr__nfet_01v8 L=0.5u W=1u
M5903 o6 ibias vss vss sky130_fd_pr__nfet_01v8 L=0.5u W=1u
M5904 o6 ibias vss vss sky130_fd_pr__nfet_01v8 L=0.5u W=1u
M5905 o6 ibias vss vss sky130_fd_pr__nfet_01v8 L=0.5u W=1u
M5906 o6 ibias vss vss sky130_fd_pr__nfet_01v8 L=0.5u W=1u
M5907 o6 ibias vss vss sky130_fd_pr__nfet_01v8 L=0.5u W=1u
M5908 o6 ibias vss vss sky130_fd_pr__nfet_01v8 L=0.5u W=1u
M5909 o6 ibias vss vss sky130_fd_pr__nfet_01v8 L=0.5u W=1u
M5910 o6 ibias vss vss sky130_fd_pr__nfet_01v8 L=0.5u W=1u
M5911 o6 ibias vss vss sky130_fd_pr__nfet_01v8 L=0.5u W=1u
M5912 o6 ibias vss vss sky130_fd_pr__nfet_01v8 L=0.5u W=1u
M5913 o6 ibias vss vss sky130_fd_pr__nfet_01v8 L=0.5u W=1u
M5914 o6 ibias vss vss sky130_fd_pr__nfet_01v8 L=0.5u W=1u
M5915 o6 ibias vss vss sky130_fd_pr__nfet_01v8 L=0.5u W=1u
M5916 o6 ibias vss vss sky130_fd_pr__nfet_01v8 L=0.5u W=1u
M5917 o6 ibias vss vss sky130_fd_pr__nfet_01v8 L=0.5u W=1u
M5918 o6 ibias vss vss sky130_fd_pr__nfet_01v8 L=0.5u W=1u
M5919 o6 ibias vss vss sky130_fd_pr__nfet_01v8 L=0.5u W=1u
M5920 o6 ibias vss vss sky130_fd_pr__nfet_01v8 L=0.5u W=1u
M5921 o6 ibias vss vss sky130_fd_pr__nfet_01v8 L=0.5u W=1u
M5922 o6 ibias vss vss sky130_fd_pr__nfet_01v8 L=0.5u W=1u
M5923 o6 ibias vss vss sky130_fd_pr__nfet_01v8 L=0.5u W=1u
M5924 o6 ibias vss vss sky130_fd_pr__nfet_01v8 L=0.5u W=1u
M5925 o6 ibias vss vss sky130_fd_pr__nfet_01v8 L=0.5u W=1u
M5926 o6 ibias vss vss sky130_fd_pr__nfet_01v8 L=0.5u W=1u
M5927 o6 ibias vss vss sky130_fd_pr__nfet_01v8 L=0.5u W=1u
M5928 o6 ibias vss vss sky130_fd_pr__nfet_01v8 L=0.5u W=1u
M5929 o6 ibias vss vss sky130_fd_pr__nfet_01v8 L=0.5u W=1u
M5930 o6 ibias vss vss sky130_fd_pr__nfet_01v8 L=0.5u W=1u
M5931 o6 ibias vss vss sky130_fd_pr__nfet_01v8 L=0.5u W=1u
M5932 o6 ibias vss vss sky130_fd_pr__nfet_01v8 L=0.5u W=1u
M5933 o6 ibias vss vss sky130_fd_pr__nfet_01v8 L=0.5u W=1u
M5934 o6 ibias vss vss sky130_fd_pr__nfet_01v8 L=0.5u W=1u
M5935 o6 ibias vss vss sky130_fd_pr__nfet_01v8 L=0.5u W=1u
M5936 o6 ibias vss vss sky130_fd_pr__nfet_01v8 L=0.5u W=1u
M5937 o6 ibias vss vss sky130_fd_pr__nfet_01v8 L=0.5u W=1u
M5938 o6 ibias vss vss sky130_fd_pr__nfet_01v8 L=0.5u W=1u
M5939 o6 ibias vss vss sky130_fd_pr__nfet_01v8 L=0.5u W=1u
M5940 o6 ibias vss vss sky130_fd_pr__nfet_01v8 L=0.5u W=1u
M5941 o6 ibias vss vss sky130_fd_pr__nfet_01v8 L=0.5u W=1u
M5942 o6 ibias vss vss sky130_fd_pr__nfet_01v8 L=0.5u W=1u
M5943 o6 ibias vss vss sky130_fd_pr__nfet_01v8 L=0.5u W=1u
M5944 o6 ibias vss vss sky130_fd_pr__nfet_01v8 L=0.5u W=1u
M5945 o6 ibias vss vss sky130_fd_pr__nfet_01v8 L=0.5u W=1u
M5946 o6 ibias vss vss sky130_fd_pr__nfet_01v8 L=0.5u W=1u
M5947 o6 ibias vss vss sky130_fd_pr__nfet_01v8 L=0.5u W=1u
M5948 o6 ibias vss vss sky130_fd_pr__nfet_01v8 L=0.5u W=1u
M5949 o6 ibias vss vss sky130_fd_pr__nfet_01v8 L=0.5u W=1u
M5950 o6 ibias vss vss sky130_fd_pr__nfet_01v8 L=0.5u W=1u
M5951 o6 ibias vss vss sky130_fd_pr__nfet_01v8 L=0.5u W=1u
M5952 o6 ibias vss vss sky130_fd_pr__nfet_01v8 L=0.5u W=1u
M5953 o6 ibias vss vss sky130_fd_pr__nfet_01v8 L=0.5u W=1u
M5954 o6 ibias vss vss sky130_fd_pr__nfet_01v8 L=0.5u W=1u
M5955 o6 ibias vss vss sky130_fd_pr__nfet_01v8 L=0.5u W=1u
M5956 o6 ibias vss vss sky130_fd_pr__nfet_01v8 L=0.5u W=1u
M5957 o6 ibias vss vss sky130_fd_pr__nfet_01v8 L=0.5u W=1u
M5958 o6 ibias vss vss sky130_fd_pr__nfet_01v8 L=0.5u W=1u
M5959 o6 ibias vss vss sky130_fd_pr__nfet_01v8 L=0.5u W=1u
M5960 o6 ibias vss vss sky130_fd_pr__nfet_01v8 L=0.5u W=1u
M5961 o6 ibias vss vss sky130_fd_pr__nfet_01v8 L=0.5u W=1u
M5962 o6 ibias vss vss sky130_fd_pr__nfet_01v8 L=0.5u W=1u
M5963 o6 ibias vss vss sky130_fd_pr__nfet_01v8 L=0.5u W=1u
M5964 o6 ibias vss vss sky130_fd_pr__nfet_01v8 L=0.5u W=1u
M5965 o6 ibias vss vss sky130_fd_pr__nfet_01v8 L=0.5u W=1u
M5966 o6 ibias vss vss sky130_fd_pr__nfet_01v8 L=0.5u W=1u
M5967 o6 ibias vss vss sky130_fd_pr__nfet_01v8 L=0.5u W=1u
M5968 o6 ibias vss vss sky130_fd_pr__nfet_01v8 L=0.5u W=1u
M5969 o6 ibias vss vss sky130_fd_pr__nfet_01v8 L=0.5u W=1u
M5970 o6 ibias vss vss sky130_fd_pr__nfet_01v8 L=0.5u W=1u
M5971 o6 ibias vss vss sky130_fd_pr__nfet_01v8 L=0.5u W=1u
M5972 o6 ibias vss vss sky130_fd_pr__nfet_01v8 L=0.5u W=1u
M5973 o6 ibias vss vss sky130_fd_pr__nfet_01v8 L=0.5u W=1u
M5974 o6 ibias vss vss sky130_fd_pr__nfet_01v8 L=0.5u W=1u
M5975 o6 ibias vss vss sky130_fd_pr__nfet_01v8 L=0.5u W=1u
M5976 o6 ibias vss vss sky130_fd_pr__nfet_01v8 L=0.5u W=1u
M5977 o6 ibias vss vss sky130_fd_pr__nfet_01v8 L=0.5u W=1u
M5978 o6 ibias vss vss sky130_fd_pr__nfet_01v8 L=0.5u W=1u
M5979 o6 ibias vss vss sky130_fd_pr__nfet_01v8 L=0.5u W=1u
M5980 o6 ibias vss vss sky130_fd_pr__nfet_01v8 L=0.5u W=1u
M5981 o6 ibias vss vss sky130_fd_pr__nfet_01v8 L=0.5u W=1u
M5982 o6 ibias vss vss sky130_fd_pr__nfet_01v8 L=0.5u W=1u
M5983 o6 ibias vss vss sky130_fd_pr__nfet_01v8 L=0.5u W=1u
M5984 o6 ibias vss vss sky130_fd_pr__nfet_01v8 L=0.5u W=1u
M5985 o6 ibias vss vss sky130_fd_pr__nfet_01v8 L=0.5u W=1u
M5986 o6 ibias vss vss sky130_fd_pr__nfet_01v8 L=0.5u W=1u
M5987 o6 ibias vss vss sky130_fd_pr__nfet_01v8 L=0.5u W=1u
M5988 o6 ibias vss vss sky130_fd_pr__nfet_01v8 L=0.5u W=1u
M5989 o6 ibias vss vss sky130_fd_pr__nfet_01v8 L=0.5u W=1u
M5990 o6 ibias vss vss sky130_fd_pr__nfet_01v8 L=0.5u W=1u
M5991 o6 ibias vss vss sky130_fd_pr__nfet_01v8 L=0.5u W=1u
M5992 o6 ibias vss vss sky130_fd_pr__nfet_01v8 L=0.5u W=1u
M5993 o6 ibias vss vss sky130_fd_pr__nfet_01v8 L=0.5u W=1u
M5994 o6 ibias vss vss sky130_fd_pr__nfet_01v8 L=0.5u W=1u
M5995 o6 ibias vss vss sky130_fd_pr__nfet_01v8 L=0.5u W=1u
M5996 o6 ibias vss vss sky130_fd_pr__nfet_01v8 L=0.5u W=1u
M5997 o6 ibias vss vss sky130_fd_pr__nfet_01v8 L=0.5u W=1u
M5998 o6 ibias vss vss sky130_fd_pr__nfet_01v8 L=0.5u W=1u
M5999 o6 ibias vss vss sky130_fd_pr__nfet_01v8 L=0.5u W=1u
M6000 o6 ibias vss vss sky130_fd_pr__nfet_01v8 L=0.5u W=1u
M6001 o6 ibias vss vss sky130_fd_pr__nfet_01v8 L=0.5u W=1u
M6002 o6 ibias vss vss sky130_fd_pr__nfet_01v8 L=0.5u W=1u
M6003 o6 ibias vss vss sky130_fd_pr__nfet_01v8 L=0.5u W=1u
M6004 o6 ibias vss vss sky130_fd_pr__nfet_01v8 L=0.5u W=1u
M6005 o6 ibias vss vss sky130_fd_pr__nfet_01v8 L=0.5u W=1u
M6006 o6 ibias vss vss sky130_fd_pr__nfet_01v8 L=0.5u W=1u
M6007 o6 ibias vss vss sky130_fd_pr__nfet_01v8 L=0.5u W=1u
M6008 o6 ibias vss vss sky130_fd_pr__nfet_01v8 L=0.5u W=1u
M6009 o6 ibias vss vss sky130_fd_pr__nfet_01v8 L=0.5u W=1u
M6010 o6 ibias vss vss sky130_fd_pr__nfet_01v8 L=0.5u W=1u
M6011 o6 ibias vss vss sky130_fd_pr__nfet_01v8 L=0.5u W=1u
M6012 o6 ibias vss vss sky130_fd_pr__nfet_01v8 L=0.5u W=1u
M6013 o6 ibias vss vss sky130_fd_pr__nfet_01v8 L=0.5u W=1u
M6014 o6 ibias vss vss sky130_fd_pr__nfet_01v8 L=0.5u W=1u
M6015 o6 ibias vss vss sky130_fd_pr__nfet_01v8 L=0.5u W=1u
M6016 o6 ibias vss vss sky130_fd_pr__nfet_01v8 L=0.5u W=1u
M6017 o6 ibias vss vss sky130_fd_pr__nfet_01v8 L=0.5u W=1u
M6018 o6 ibias vss vss sky130_fd_pr__nfet_01v8 L=0.5u W=1u
M6019 o6 ibias vss vss sky130_fd_pr__nfet_01v8 L=0.5u W=1u
M6020 o6 ibias vss vss sky130_fd_pr__nfet_01v8 L=0.5u W=1u
M6021 o6 ibias vss vss sky130_fd_pr__nfet_01v8 L=0.5u W=1u
M6022 o6 ibias vss vss sky130_fd_pr__nfet_01v8 L=0.5u W=1u
M6023 o6 ibias vss vss sky130_fd_pr__nfet_01v8 L=0.5u W=1u
M6024 o6 ibias vss vss sky130_fd_pr__nfet_01v8 L=0.5u W=1u
M6025 o6 ibias vss vss sky130_fd_pr__nfet_01v8 L=0.5u W=1u
M6026 o6 ibias vss vss sky130_fd_pr__nfet_01v8 L=0.5u W=1u
M6027 o6 ibias vss vss sky130_fd_pr__nfet_01v8 L=0.5u W=1u
M6028 o6 ibias vss vss sky130_fd_pr__nfet_01v8 L=0.5u W=1u
M6029 o6 ibias vss vss sky130_fd_pr__nfet_01v8 L=0.5u W=1u
M6030 o6 ibias vss vss sky130_fd_pr__nfet_01v8 L=0.5u W=1u
M6031 o6 ibias vss vss sky130_fd_pr__nfet_01v8 L=0.5u W=1u
M6032 o6 ibias vss vss sky130_fd_pr__nfet_01v8 L=0.5u W=1u
M6033 o6 ibias vss vss sky130_fd_pr__nfet_01v8 L=0.5u W=1u
M6034 o6 ibias vss vss sky130_fd_pr__nfet_01v8 L=0.5u W=1u
M6035 o6 ibias vss vss sky130_fd_pr__nfet_01v8 L=0.5u W=1u
M6036 o6 ibias vss vss sky130_fd_pr__nfet_01v8 L=0.5u W=1u
M6037 o6 ibias vss vss sky130_fd_pr__nfet_01v8 L=0.5u W=1u
M6038 o6 ibias vss vss sky130_fd_pr__nfet_01v8 L=0.5u W=1u
M6039 o6 ibias vss vss sky130_fd_pr__nfet_01v8 L=0.5u W=1u
M6040 o6 ibias vss vss sky130_fd_pr__nfet_01v8 L=0.5u W=1u
M6041 o6 ibias vss vss sky130_fd_pr__nfet_01v8 L=0.5u W=1u
M6042 o6 ibias vss vss sky130_fd_pr__nfet_01v8 L=0.5u W=1u
M6043 o6 ibias vss vss sky130_fd_pr__nfet_01v8 L=0.5u W=1u
M6044 o6 ibias vss vss sky130_fd_pr__nfet_01v8 L=0.5u W=1u
M6045 o6 ibias vss vss sky130_fd_pr__nfet_01v8 L=0.5u W=1u
M6046 o6 ibias vss vss sky130_fd_pr__nfet_01v8 L=0.5u W=1u
M6047 o6 ibias vss vss sky130_fd_pr__nfet_01v8 L=0.5u W=1u
M6048 o6 ibias vss vss sky130_fd_pr__nfet_01v8 L=0.5u W=1u
M6049 o6 ibias vss vss sky130_fd_pr__nfet_01v8 L=0.5u W=1u
M6050 o6 ibias vss vss sky130_fd_pr__nfet_01v8 L=0.5u W=1u
M6051 o6 ibias vss vss sky130_fd_pr__nfet_01v8 L=0.5u W=1u
M6052 o6 ibias vss vss sky130_fd_pr__nfet_01v8 L=0.5u W=1u
M6053 o6 ibias vss vss sky130_fd_pr__nfet_01v8 L=0.5u W=1u
M6054 o6 ibias vss vss sky130_fd_pr__nfet_01v8 L=0.5u W=1u
M6055 o6 ibias vss vss sky130_fd_pr__nfet_01v8 L=0.5u W=1u
M6056 o6 ibias vss vss sky130_fd_pr__nfet_01v8 L=0.5u W=1u
M6057 o6 ibias vss vss sky130_fd_pr__nfet_01v8 L=0.5u W=1u
M6058 o6 ibias vss vss sky130_fd_pr__nfet_01v8 L=0.5u W=1u
M6059 o6 ibias vss vss sky130_fd_pr__nfet_01v8 L=0.5u W=1u
M6060 o6 ibias vss vss sky130_fd_pr__nfet_01v8 L=0.5u W=1u
M6061 o6 ibias vss vss sky130_fd_pr__nfet_01v8 L=0.5u W=1u
M6062 o6 ibias vss vss sky130_fd_pr__nfet_01v8 L=0.5u W=1u
M6063 o6 ibias vss vss sky130_fd_pr__nfet_01v8 L=0.5u W=1u
M6064 o6 ibias vss vss sky130_fd_pr__nfet_01v8 L=0.5u W=1u
M6065 o6 ibias vss vss sky130_fd_pr__nfet_01v8 L=0.5u W=1u
M6066 o6 ibias vss vss sky130_fd_pr__nfet_01v8 L=0.5u W=1u
M6067 o6 ibias vss vss sky130_fd_pr__nfet_01v8 L=0.5u W=1u
M6068 o6 ibias vss vss sky130_fd_pr__nfet_01v8 L=0.5u W=1u
M6069 o6 ibias vss vss sky130_fd_pr__nfet_01v8 L=0.5u W=1u
M6070 o6 ibias vss vss sky130_fd_pr__nfet_01v8 L=0.5u W=1u
M6071 o6 ibias vss vss sky130_fd_pr__nfet_01v8 L=0.5u W=1u
M6072 o6 ibias vss vss sky130_fd_pr__nfet_01v8 L=0.5u W=1u
M6073 o6 ibias vss vss sky130_fd_pr__nfet_01v8 L=0.5u W=1u
M6074 o6 ibias vss vss sky130_fd_pr__nfet_01v8 L=0.5u W=1u
M6075 o6 ibias vss vss sky130_fd_pr__nfet_01v8 L=0.5u W=1u
M6076 o6 ibias vss vss sky130_fd_pr__nfet_01v8 L=0.5u W=1u
M6077 o6 ibias vss vss sky130_fd_pr__nfet_01v8 L=0.5u W=1u
M6078 o6 ibias vss vss sky130_fd_pr__nfet_01v8 L=0.5u W=1u
M6079 o6 ibias vss vss sky130_fd_pr__nfet_01v8 L=0.5u W=1u
M6080 o6 ibias vss vss sky130_fd_pr__nfet_01v8 L=0.5u W=1u
M6081 o6 ibias vss vss sky130_fd_pr__nfet_01v8 L=0.5u W=1u
M6082 o6 ibias vss vss sky130_fd_pr__nfet_01v8 L=0.5u W=1u
M6083 o6 ibias vss vss sky130_fd_pr__nfet_01v8 L=0.5u W=1u
M6084 o6 ibias vss vss sky130_fd_pr__nfet_01v8 L=0.5u W=1u
M6085 o6 ibias vss vss sky130_fd_pr__nfet_01v8 L=0.5u W=1u
M6086 o6 ibias vss vss sky130_fd_pr__nfet_01v8 L=0.5u W=1u
M6087 o6 ibias vss vss sky130_fd_pr__nfet_01v8 L=0.5u W=1u
M6088 o6 ibias vss vss sky130_fd_pr__nfet_01v8 L=0.5u W=1u
M6089 o6 ibias vss vss sky130_fd_pr__nfet_01v8 L=0.5u W=1u
M6090 o6 ibias vss vss sky130_fd_pr__nfet_01v8 L=0.5u W=1u
M6091 o6 ibias vss vss sky130_fd_pr__nfet_01v8 L=0.5u W=1u
M6092 o6 ibias vss vss sky130_fd_pr__nfet_01v8 L=0.5u W=1u
M6093 o6 ibias vss vss sky130_fd_pr__nfet_01v8 L=0.5u W=1u
M6094 o6 ibias vss vss sky130_fd_pr__nfet_01v8 L=0.5u W=1u
M6095 o6 ibias vss vss sky130_fd_pr__nfet_01v8 L=0.5u W=1u
M6096 o6 ibias vss vss sky130_fd_pr__nfet_01v8 L=0.5u W=1u
M6097 o6 ibias vss vss sky130_fd_pr__nfet_01v8 L=0.5u W=1u
M6098 o6 ibias vss vss sky130_fd_pr__nfet_01v8 L=0.5u W=1u
M6099 o6 ibias vss vss sky130_fd_pr__nfet_01v8 L=0.5u W=1u
M6100 o6 ibias vss vss sky130_fd_pr__nfet_01v8 L=0.5u W=1u
M6101 o6 ibias vss vss sky130_fd_pr__nfet_01v8 L=0.5u W=1u
M6102 o6 ibias vss vss sky130_fd_pr__nfet_01v8 L=0.5u W=1u
M6103 o6 ibias vss vss sky130_fd_pr__nfet_01v8 L=0.5u W=1u
M6104 o6 ibias vss vss sky130_fd_pr__nfet_01v8 L=0.5u W=1u
M6105 o6 ibias vss vss sky130_fd_pr__nfet_01v8 L=0.5u W=1u
M6106 o6 ibias vss vss sky130_fd_pr__nfet_01v8 L=0.5u W=1u
M6107 o6 ibias vss vss sky130_fd_pr__nfet_01v8 L=0.5u W=1u
M6108 o6 ibias vss vss sky130_fd_pr__nfet_01v8 L=0.5u W=1u
M6109 o6 ibias vss vss sky130_fd_pr__nfet_01v8 L=0.5u W=1u
M6110 o6 ibias vss vss sky130_fd_pr__nfet_01v8 L=0.5u W=1u
M6111 o6 ibias vss vss sky130_fd_pr__nfet_01v8 L=0.5u W=1u
M6112 o6 ibias vss vss sky130_fd_pr__nfet_01v8 L=0.5u W=1u
M6113 o6 ibias vss vss sky130_fd_pr__nfet_01v8 L=0.5u W=1u
M6114 o6 ibias vss vss sky130_fd_pr__nfet_01v8 L=0.5u W=1u
M6115 o6 ibias vss vss sky130_fd_pr__nfet_01v8 L=0.5u W=1u
M6116 o6 ibias vss vss sky130_fd_pr__nfet_01v8 L=0.5u W=1u
M6117 o6 ibias vss vss sky130_fd_pr__nfet_01v8 L=0.5u W=1u
M6118 o6 ibias vss vss sky130_fd_pr__nfet_01v8 L=0.5u W=1u
M6119 o6 ibias vss vss sky130_fd_pr__nfet_01v8 L=0.5u W=1u
M6120 o6 ibias vss vss sky130_fd_pr__nfet_01v8 L=0.5u W=1u
M6121 o6 ibias vss vss sky130_fd_pr__nfet_01v8 L=0.5u W=1u
M6122 o6 ibias vss vss sky130_fd_pr__nfet_01v8 L=0.5u W=1u
M6123 o6 ibias vss vss sky130_fd_pr__nfet_01v8 L=0.5u W=1u
M6124 o6 ibias vss vss sky130_fd_pr__nfet_01v8 L=0.5u W=1u
M6125 o6 ibias vss vss sky130_fd_pr__nfet_01v8 L=0.5u W=1u
M6126 o6 ibias vss vss sky130_fd_pr__nfet_01v8 L=0.5u W=1u
M6127 o6 ibias vss vss sky130_fd_pr__nfet_01v8 L=0.5u W=1u
M6128 o6 ibias vss vss sky130_fd_pr__nfet_01v8 L=0.5u W=1u
M6129 o6 ibias vss vss sky130_fd_pr__nfet_01v8 L=0.5u W=1u
M6130 o6 ibias vss vss sky130_fd_pr__nfet_01v8 L=0.5u W=1u
M6131 o6 ibias vss vss sky130_fd_pr__nfet_01v8 L=0.5u W=1u
M6132 o6 ibias vss vss sky130_fd_pr__nfet_01v8 L=0.5u W=1u
M6133 o6 ibias vss vss sky130_fd_pr__nfet_01v8 L=0.5u W=1u
M6134 o6 ibias vss vss sky130_fd_pr__nfet_01v8 L=0.5u W=1u
M6135 o6 ibias vss vss sky130_fd_pr__nfet_01v8 L=0.5u W=1u
M6136 o6 ibias vss vss sky130_fd_pr__nfet_01v8 L=0.5u W=1u
M6137 o6 ibias vss vss sky130_fd_pr__nfet_01v8 L=0.5u W=1u
M6138 o6 ibias vss vss sky130_fd_pr__nfet_01v8 L=0.5u W=1u
M6139 o6 ibias vss vss sky130_fd_pr__nfet_01v8 L=0.5u W=1u
M6140 o6 ibias vss vss sky130_fd_pr__nfet_01v8 L=0.5u W=1u
M6141 o6 ibias vss vss sky130_fd_pr__nfet_01v8 L=0.5u W=1u
M6142 o6 ibias vss vss sky130_fd_pr__nfet_01v8 L=0.5u W=1u
M6143 o6 ibias vss vss sky130_fd_pr__nfet_01v8 L=0.5u W=1u
M6144 o6 ibias vss vss sky130_fd_pr__nfet_01v8 L=0.5u W=1u
M6145 o6 ibias vss vss sky130_fd_pr__nfet_01v8 L=0.5u W=1u
M6146 o6 ibias vss vss sky130_fd_pr__nfet_01v8 L=0.5u W=1u
M6147 o6 ibias vss vss sky130_fd_pr__nfet_01v8 L=0.5u W=1u
M6148 o6 ibias vss vss sky130_fd_pr__nfet_01v8 L=0.5u W=1u
M6149 o6 ibias vss vss sky130_fd_pr__nfet_01v8 L=0.5u W=1u
M6150 o6 ibias vss vss sky130_fd_pr__nfet_01v8 L=0.5u W=1u
M6151 o6 ibias vss vss sky130_fd_pr__nfet_01v8 L=0.5u W=1u
M6152 o6 ibias vss vss sky130_fd_pr__nfet_01v8 L=0.5u W=1u
M6153 o6 ibias vss vss sky130_fd_pr__nfet_01v8 L=0.5u W=1u
M6154 o6 ibias vss vss sky130_fd_pr__nfet_01v8 L=0.5u W=1u
M6155 o6 ibias vss vss sky130_fd_pr__nfet_01v8 L=0.5u W=1u
M6156 o6 ibias vss vss sky130_fd_pr__nfet_01v8 L=0.5u W=1u
M6157 o6 ibias vss vss sky130_fd_pr__nfet_01v8 L=0.5u W=1u
M6158 o6 ibias vss vss sky130_fd_pr__nfet_01v8 L=0.5u W=1u
M6159 o6 ibias vss vss sky130_fd_pr__nfet_01v8 L=0.5u W=1u
M6160 o6 ibias vss vss sky130_fd_pr__nfet_01v8 L=0.5u W=1u
M6161 o6 ibias vss vss sky130_fd_pr__nfet_01v8 L=0.5u W=1u
M6162 o6 ibias vss vss sky130_fd_pr__nfet_01v8 L=0.5u W=1u
M6163 o6 ibias vss vss sky130_fd_pr__nfet_01v8 L=0.5u W=1u
M6164 o6 ibias vss vss sky130_fd_pr__nfet_01v8 L=0.5u W=1u
M6165 o6 ibias vss vss sky130_fd_pr__nfet_01v8 L=0.5u W=1u
M6166 o6 ibias vss vss sky130_fd_pr__nfet_01v8 L=0.5u W=1u
M6167 o6 ibias vss vss sky130_fd_pr__nfet_01v8 L=0.5u W=1u
M6168 o6 ibias vss vss sky130_fd_pr__nfet_01v8 L=0.5u W=1u
M6169 o6 ibias vss vss sky130_fd_pr__nfet_01v8 L=0.5u W=1u
M6170 o6 ibias vss vss sky130_fd_pr__nfet_01v8 L=0.5u W=1u
M6171 o6 ibias vss vss sky130_fd_pr__nfet_01v8 L=0.5u W=1u
M6172 o6 ibias vss vss sky130_fd_pr__nfet_01v8 L=0.5u W=1u
M6173 o6 ibias vss vss sky130_fd_pr__nfet_01v8 L=0.5u W=1u
M6174 o6 ibias vss vss sky130_fd_pr__nfet_01v8 L=0.5u W=1u
M6175 o6 ibias vss vss sky130_fd_pr__nfet_01v8 L=0.5u W=1u
M6176 o6 ibias vss vss sky130_fd_pr__nfet_01v8 L=0.5u W=1u
M6177 o6 ibias vss vss sky130_fd_pr__nfet_01v8 L=0.5u W=1u
M6178 o6 ibias vss vss sky130_fd_pr__nfet_01v8 L=0.5u W=1u
M6179 o6 ibias vss vss sky130_fd_pr__nfet_01v8 L=0.5u W=1u
M6180 o6 ibias vss vss sky130_fd_pr__nfet_01v8 L=0.5u W=1u
M6181 o6 ibias vss vss sky130_fd_pr__nfet_01v8 L=0.5u W=1u
M6182 o6 ibias vss vss sky130_fd_pr__nfet_01v8 L=0.5u W=1u
M6183 o6 ibias vss vss sky130_fd_pr__nfet_01v8 L=0.5u W=1u
M6184 o6 ibias vss vss sky130_fd_pr__nfet_01v8 L=0.5u W=1u
M6185 o6 ibias vss vss sky130_fd_pr__nfet_01v8 L=0.5u W=1u
M6186 o6 ibias vss vss sky130_fd_pr__nfet_01v8 L=0.5u W=1u
M6187 o6 ibias vss vss sky130_fd_pr__nfet_01v8 L=0.5u W=1u
M6188 o6 ibias vss vss sky130_fd_pr__nfet_01v8 L=0.5u W=1u
M6189 o6 ibias vss vss sky130_fd_pr__nfet_01v8 L=0.5u W=1u
M6190 o6 ibias vss vss sky130_fd_pr__nfet_01v8 L=0.5u W=1u
M6191 o6 ibias vss vss sky130_fd_pr__nfet_01v8 L=0.5u W=1u
M6192 o6 ibias vss vss sky130_fd_pr__nfet_01v8 L=0.5u W=1u
M6193 o6 ibias vss vss sky130_fd_pr__nfet_01v8 L=0.5u W=1u
M6194 o6 ibias vss vss sky130_fd_pr__nfet_01v8 L=0.5u W=1u
M6195 o6 ibias vss vss sky130_fd_pr__nfet_01v8 L=0.5u W=1u
M6196 o6 ibias vss vss sky130_fd_pr__nfet_01v8 L=0.5u W=1u
M6197 o6 ibias vss vss sky130_fd_pr__nfet_01v8 L=0.5u W=1u
M6198 o6 ibias vss vss sky130_fd_pr__nfet_01v8 L=0.5u W=1u
M6199 o6 ibias vss vss sky130_fd_pr__nfet_01v8 L=0.5u W=1u
M6200 o6 ibias vss vss sky130_fd_pr__nfet_01v8 L=0.5u W=1u
M6201 o6 ibias vss vss sky130_fd_pr__nfet_01v8 L=0.5u W=1u
M6202 o6 ibias vss vss sky130_fd_pr__nfet_01v8 L=0.5u W=1u
M6203 o6 ibias vss vss sky130_fd_pr__nfet_01v8 L=0.5u W=1u
M6204 o6 ibias vss vss sky130_fd_pr__nfet_01v8 L=0.5u W=1u
M6205 o6 ibias vss vss sky130_fd_pr__nfet_01v8 L=0.5u W=1u
M6206 o6 ibias vss vss sky130_fd_pr__nfet_01v8 L=0.5u W=1u
M6207 o6 ibias vss vss sky130_fd_pr__nfet_01v8 L=0.5u W=1u
M6208 o6 ibias vss vss sky130_fd_pr__nfet_01v8 L=0.5u W=1u
M6209 o6 ibias vss vss sky130_fd_pr__nfet_01v8 L=0.5u W=1u
M6210 o6 ibias vss vss sky130_fd_pr__nfet_01v8 L=0.5u W=1u
M6211 o6 ibias vss vss sky130_fd_pr__nfet_01v8 L=0.5u W=1u
M6212 o6 ibias vss vss sky130_fd_pr__nfet_01v8 L=0.5u W=1u
M6213 o6 ibias vss vss sky130_fd_pr__nfet_01v8 L=0.5u W=1u
M6214 o6 ibias vss vss sky130_fd_pr__nfet_01v8 L=0.5u W=1u
M6215 o6 ibias vss vss sky130_fd_pr__nfet_01v8 L=0.5u W=1u
M6216 o6 ibias vss vss sky130_fd_pr__nfet_01v8 L=0.5u W=1u
M6217 o6 ibias vss vss sky130_fd_pr__nfet_01v8 L=0.5u W=1u
M6218 o6 ibias vss vss sky130_fd_pr__nfet_01v8 L=0.5u W=1u
M6219 o6 ibias vss vss sky130_fd_pr__nfet_01v8 L=0.5u W=1u
M6220 o6 ibias vss vss sky130_fd_pr__nfet_01v8 L=0.5u W=1u
M6221 o6 ibias vss vss sky130_fd_pr__nfet_01v8 L=0.5u W=1u
M6222 o6 ibias vss vss sky130_fd_pr__nfet_01v8 L=0.5u W=1u
M6223 o6 ibias vss vss sky130_fd_pr__nfet_01v8 L=0.5u W=1u
M6224 o6 ibias vss vss sky130_fd_pr__nfet_01v8 L=0.5u W=1u
M6225 o6 ibias vss vss sky130_fd_pr__nfet_01v8 L=0.5u W=1u
M6226 o6 ibias vss vss sky130_fd_pr__nfet_01v8 L=0.5u W=1u
M6227 o6 ibias vss vss sky130_fd_pr__nfet_01v8 L=0.5u W=1u
M6228 o6 ibias vss vss sky130_fd_pr__nfet_01v8 L=0.5u W=1u
M6229 o6 ibias vss vss sky130_fd_pr__nfet_01v8 L=0.5u W=1u
M6230 o6 ibias vss vss sky130_fd_pr__nfet_01v8 L=0.5u W=1u
M6231 o6 ibias vss vss sky130_fd_pr__nfet_01v8 L=0.5u W=1u
M6232 o6 ibias vss vss sky130_fd_pr__nfet_01v8 L=0.5u W=1u
M6233 o6 ibias vss vss sky130_fd_pr__nfet_01v8 L=0.5u W=1u
M6234 o6 ibias vss vss sky130_fd_pr__nfet_01v8 L=0.5u W=1u
M6235 o6 ibias vss vss sky130_fd_pr__nfet_01v8 L=0.5u W=1u
M6236 o6 ibias vss vss sky130_fd_pr__nfet_01v8 L=0.5u W=1u
M6237 o6 ibias vss vss sky130_fd_pr__nfet_01v8 L=0.5u W=1u
M6238 o6 ibias vss vss sky130_fd_pr__nfet_01v8 L=0.5u W=1u
M6239 o6 ibias vss vss sky130_fd_pr__nfet_01v8 L=0.5u W=1u
M6240 o6 ibias vss vss sky130_fd_pr__nfet_01v8 L=0.5u W=1u
M6241 o6 ibias vss vss sky130_fd_pr__nfet_01v8 L=0.5u W=1u
M6242 o6 ibias vss vss sky130_fd_pr__nfet_01v8 L=0.5u W=1u
M6243 o6 ibias vss vss sky130_fd_pr__nfet_01v8 L=0.5u W=1u
M6244 o6 ibias vss vss sky130_fd_pr__nfet_01v8 L=0.5u W=1u
M6245 o6 ibias vss vss sky130_fd_pr__nfet_01v8 L=0.5u W=1u
M6246 o6 ibias vss vss sky130_fd_pr__nfet_01v8 L=0.5u W=1u
M6247 o6 ibias vss vss sky130_fd_pr__nfet_01v8 L=0.5u W=1u
M6248 o6 ibias vss vss sky130_fd_pr__nfet_01v8 L=0.5u W=1u
M6249 o6 ibias vss vss sky130_fd_pr__nfet_01v8 L=0.5u W=1u
M6250 o6 ibias vss vss sky130_fd_pr__nfet_01v8 L=0.5u W=1u
M6251 o6 ibias vss vss sky130_fd_pr__nfet_01v8 L=0.5u W=1u
M6252 o6 ibias vss vss sky130_fd_pr__nfet_01v8 L=0.5u W=1u
M6253 o6 ibias vss vss sky130_fd_pr__nfet_01v8 L=0.5u W=1u
M6254 o6 ibias vss vss sky130_fd_pr__nfet_01v8 L=0.5u W=1u
M6255 o6 ibias vss vss sky130_fd_pr__nfet_01v8 L=0.5u W=1u
M6256 o6 ibias vss vss sky130_fd_pr__nfet_01v8 L=0.5u W=1u
M6257 o6 ibias vss vss sky130_fd_pr__nfet_01v8 L=0.5u W=1u
M6258 o6 ibias vss vss sky130_fd_pr__nfet_01v8 L=0.5u W=1u
M6259 o6 ibias vss vss sky130_fd_pr__nfet_01v8 L=0.5u W=1u
M6260 o6 ibias vss vss sky130_fd_pr__nfet_01v8 L=0.5u W=1u
M6261 o6 ibias vss vss sky130_fd_pr__nfet_01v8 L=0.5u W=1u
M6262 o6 ibias vss vss sky130_fd_pr__nfet_01v8 L=0.5u W=1u
M6263 o6 ibias vss vss sky130_fd_pr__nfet_01v8 L=0.5u W=1u
M6264 o6 ibias vss vss sky130_fd_pr__nfet_01v8 L=0.5u W=1u
M6265 o6 ibias vss vss sky130_fd_pr__nfet_01v8 L=0.5u W=1u
M6266 o6 ibias vss vss sky130_fd_pr__nfet_01v8 L=0.5u W=1u
M6267 o6 ibias vss vss sky130_fd_pr__nfet_01v8 L=0.5u W=1u
M6268 o6 ibias vss vss sky130_fd_pr__nfet_01v8 L=0.5u W=1u
M6269 o6 ibias vss vss sky130_fd_pr__nfet_01v8 L=0.5u W=1u
M6270 o6 ibias vss vss sky130_fd_pr__nfet_01v8 L=0.5u W=1u
M6271 o6 ibias vss vss sky130_fd_pr__nfet_01v8 L=0.5u W=1u
M6272 o6 ibias vss vss sky130_fd_pr__nfet_01v8 L=0.5u W=1u
M6273 o6 ibias vss vss sky130_fd_pr__nfet_01v8 L=0.5u W=1u
M6274 o6 ibias vss vss sky130_fd_pr__nfet_01v8 L=0.5u W=1u
M6275 o6 ibias vss vss sky130_fd_pr__nfet_01v8 L=0.5u W=1u
M6276 o6 ibias vss vss sky130_fd_pr__nfet_01v8 L=0.5u W=1u
M6277 o6 ibias vss vss sky130_fd_pr__nfet_01v8 L=0.5u W=1u
M6278 o6 ibias vss vss sky130_fd_pr__nfet_01v8 L=0.5u W=1u
M6279 o6 ibias vss vss sky130_fd_pr__nfet_01v8 L=0.5u W=1u
M6280 o6 ibias vss vss sky130_fd_pr__nfet_01v8 L=0.5u W=1u
M6281 o6 ibias vss vss sky130_fd_pr__nfet_01v8 L=0.5u W=1u
M6282 o6 ibias vss vss sky130_fd_pr__nfet_01v8 L=0.5u W=1u
M6283 o6 ibias vss vss sky130_fd_pr__nfet_01v8 L=0.5u W=1u
M6284 o6 ibias vss vss sky130_fd_pr__nfet_01v8 L=0.5u W=1u
M6285 o6 ibias vss vss sky130_fd_pr__nfet_01v8 L=0.5u W=1u
M6286 o6 ibias vss vss sky130_fd_pr__nfet_01v8 L=0.5u W=1u
M6287 o6 ibias vss vss sky130_fd_pr__nfet_01v8 L=0.5u W=1u
M6288 o6 ibias vss vss sky130_fd_pr__nfet_01v8 L=0.5u W=1u
M6289 o6 ibias vss vss sky130_fd_pr__nfet_01v8 L=0.5u W=1u
M6290 o6 ibias vss vss sky130_fd_pr__nfet_01v8 L=0.5u W=1u
M6291 o6 ibias vss vss sky130_fd_pr__nfet_01v8 L=0.5u W=1u
M6292 o6 ibias vss vss sky130_fd_pr__nfet_01v8 L=0.5u W=1u
M6293 o6 ibias vss vss sky130_fd_pr__nfet_01v8 L=0.5u W=1u
M6294 o6 ibias vss vss sky130_fd_pr__nfet_01v8 L=0.5u W=1u
M6295 o6 ibias vss vss sky130_fd_pr__nfet_01v8 L=0.5u W=1u
M6296 o6 ibias vss vss sky130_fd_pr__nfet_01v8 L=0.5u W=1u
M6297 o6 ibias vss vss sky130_fd_pr__nfet_01v8 L=0.5u W=1u
M6298 o6 ibias vss vss sky130_fd_pr__nfet_01v8 L=0.5u W=1u
M6299 o6 ibias vss vss sky130_fd_pr__nfet_01v8 L=0.5u W=1u
M6300 o6 ibias vss vss sky130_fd_pr__nfet_01v8 L=0.5u W=1u
M6301 o6 ibias vss vss sky130_fd_pr__nfet_01v8 L=0.5u W=1u
M6302 o6 ibias vss vss sky130_fd_pr__nfet_01v8 L=0.5u W=1u
M6303 o6 ibias vss vss sky130_fd_pr__nfet_01v8 L=0.5u W=1u
M6304 o6 ibias vss vss sky130_fd_pr__nfet_01v8 L=0.5u W=1u
M6305 o6 ibias vss vss sky130_fd_pr__nfet_01v8 L=0.5u W=1u
M6306 o6 ibias vss vss sky130_fd_pr__nfet_01v8 L=0.5u W=1u
M6307 o6 ibias vss vss sky130_fd_pr__nfet_01v8 L=0.5u W=1u
M6308 o6 ibias vss vss sky130_fd_pr__nfet_01v8 L=0.5u W=1u
M6309 o6 ibias vss vss sky130_fd_pr__nfet_01v8 L=0.5u W=1u
M6310 o6 ibias vss vss sky130_fd_pr__nfet_01v8 L=0.5u W=1u
M6311 o6 ibias vss vss sky130_fd_pr__nfet_01v8 L=0.5u W=1u
M6312 o6 ibias vss vss sky130_fd_pr__nfet_01v8 L=0.5u W=1u
M6313 o6 ibias vss vss sky130_fd_pr__nfet_01v8 L=0.5u W=1u
M6314 o6 ibias vss vss sky130_fd_pr__nfet_01v8 L=0.5u W=1u
M6315 o6 ibias vss vss sky130_fd_pr__nfet_01v8 L=0.5u W=1u
M6316 o6 ibias vss vss sky130_fd_pr__nfet_01v8 L=0.5u W=1u
M6317 o6 ibias vss vss sky130_fd_pr__nfet_01v8 L=0.5u W=1u
M6318 o6 ibias vss vss sky130_fd_pr__nfet_01v8 L=0.5u W=1u
M6319 o6 ibias vss vss sky130_fd_pr__nfet_01v8 L=0.5u W=1u
M6320 o6 ibias vss vss sky130_fd_pr__nfet_01v8 L=0.5u W=1u
M6321 o6 ibias vss vss sky130_fd_pr__nfet_01v8 L=0.5u W=1u
M6322 o6 ibias vss vss sky130_fd_pr__nfet_01v8 L=0.5u W=1u
M6323 o6 ibias vss vss sky130_fd_pr__nfet_01v8 L=0.5u W=1u
M6324 o6 ibias vss vss sky130_fd_pr__nfet_01v8 L=0.5u W=1u
M6325 o6 ibias vss vss sky130_fd_pr__nfet_01v8 L=0.5u W=1u
M6326 o6 ibias vss vss sky130_fd_pr__nfet_01v8 L=0.5u W=1u
M6327 o6 ibias vss vss sky130_fd_pr__nfet_01v8 L=0.5u W=1u
M6328 o6 ibias vss vss sky130_fd_pr__nfet_01v8 L=0.5u W=1u
M6329 o6 ibias vss vss sky130_fd_pr__nfet_01v8 L=0.5u W=1u
M6330 o6 ibias vss vss sky130_fd_pr__nfet_01v8 L=0.5u W=1u
M6331 o6 ibias vss vss sky130_fd_pr__nfet_01v8 L=0.5u W=1u
M6332 o6 ibias vss vss sky130_fd_pr__nfet_01v8 L=0.5u W=1u
M6333 o6 ibias vss vss sky130_fd_pr__nfet_01v8 L=0.5u W=1u
M6334 o6 ibias vss vss sky130_fd_pr__nfet_01v8 L=0.5u W=1u
M6335 o6 ibias vss vss sky130_fd_pr__nfet_01v8 L=0.5u W=1u
M6336 o6 ibias vss vss sky130_fd_pr__nfet_01v8 L=0.5u W=1u
M6337 o6 ibias vss vss sky130_fd_pr__nfet_01v8 L=0.5u W=1u
M6338 o6 ibias vss vss sky130_fd_pr__nfet_01v8 L=0.5u W=1u
M6339 o6 ibias vss vss sky130_fd_pr__nfet_01v8 L=0.5u W=1u
M6340 o6 ibias vss vss sky130_fd_pr__nfet_01v8 L=0.5u W=1u
M6341 o6 ibias vss vss sky130_fd_pr__nfet_01v8 L=0.5u W=1u
M6342 o6 ibias vss vss sky130_fd_pr__nfet_01v8 L=0.5u W=1u
M6343 o6 ibias vss vss sky130_fd_pr__nfet_01v8 L=0.5u W=1u
M6344 o6 ibias vss vss sky130_fd_pr__nfet_01v8 L=0.5u W=1u
M6345 o6 ibias vss vss sky130_fd_pr__nfet_01v8 L=0.5u W=1u
M6346 o6 ibias vss vss sky130_fd_pr__nfet_01v8 L=0.5u W=1u
M6347 o6 ibias vss vss sky130_fd_pr__nfet_01v8 L=0.5u W=1u
M6348 o6 ibias vss vss sky130_fd_pr__nfet_01v8 L=0.5u W=1u
M6349 o6 ibias vss vss sky130_fd_pr__nfet_01v8 L=0.5u W=1u
M6350 o6 ibias vss vss sky130_fd_pr__nfet_01v8 L=0.5u W=1u
M6351 o6 ibias vss vss sky130_fd_pr__nfet_01v8 L=0.5u W=1u
M6352 o6 ibias vss vss sky130_fd_pr__nfet_01v8 L=0.5u W=1u
M6353 o6 ibias vss vss sky130_fd_pr__nfet_01v8 L=0.5u W=1u
M6354 o6 ibias vss vss sky130_fd_pr__nfet_01v8 L=0.5u W=1u
M6355 o6 ibias vss vss sky130_fd_pr__nfet_01v8 L=0.5u W=1u
M6356 o6 ibias vss vss sky130_fd_pr__nfet_01v8 L=0.5u W=1u
M6357 o6 ibias vss vss sky130_fd_pr__nfet_01v8 L=0.5u W=1u
M6358 o6 ibias vss vss sky130_fd_pr__nfet_01v8 L=0.5u W=1u
M6359 o6 ibias vss vss sky130_fd_pr__nfet_01v8 L=0.5u W=1u
M6360 o6 ibias vss vss sky130_fd_pr__nfet_01v8 L=0.5u W=1u
M6361 o6 ibias vss vss sky130_fd_pr__nfet_01v8 L=0.5u W=1u
M6362 o6 ibias vss vss sky130_fd_pr__nfet_01v8 L=0.5u W=1u
M6363 o6 ibias vss vss sky130_fd_pr__nfet_01v8 L=0.5u W=1u
M6364 o6 ibias vss vss sky130_fd_pr__nfet_01v8 L=0.5u W=1u
M6365 o6 ibias vss vss sky130_fd_pr__nfet_01v8 L=0.5u W=1u
M6366 o6 ibias vss vss sky130_fd_pr__nfet_01v8 L=0.5u W=1u
M6367 o6 ibias vss vss sky130_fd_pr__nfet_01v8 L=0.5u W=1u
M6368 o6 ibias vss vss sky130_fd_pr__nfet_01v8 L=0.5u W=1u
M6369 o6 ibias vss vss sky130_fd_pr__nfet_01v8 L=0.5u W=1u
M6370 o6 ibias vss vss sky130_fd_pr__nfet_01v8 L=0.5u W=1u
M6371 o6 ibias vss vss sky130_fd_pr__nfet_01v8 L=0.5u W=1u
M6372 o6 ibias vss vss sky130_fd_pr__nfet_01v8 L=0.5u W=1u
M6373 o6 ibias vss vss sky130_fd_pr__nfet_01v8 L=0.5u W=1u
M6374 o6 ibias vss vss sky130_fd_pr__nfet_01v8 L=0.5u W=1u
M6375 o6 ibias vss vss sky130_fd_pr__nfet_01v8 L=0.5u W=1u
M6376 o6 ibias vss vss sky130_fd_pr__nfet_01v8 L=0.5u W=1u
M6377 o6 ibias vss vss sky130_fd_pr__nfet_01v8 L=0.5u W=1u
M6378 o6 ibias vss vss sky130_fd_pr__nfet_01v8 L=0.5u W=1u
M6379 o6 ibias vss vss sky130_fd_pr__nfet_01v8 L=0.5u W=1u
M6380 o6 ibias vss vss sky130_fd_pr__nfet_01v8 L=0.5u W=1u
M6381 o6 ibias vss vss sky130_fd_pr__nfet_01v8 L=0.5u W=1u
M6382 o6 ibias vss vss sky130_fd_pr__nfet_01v8 L=0.5u W=1u
M6383 o6 ibias vss vss sky130_fd_pr__nfet_01v8 L=0.5u W=1u
M6384 o6 ibias vss vss sky130_fd_pr__nfet_01v8 L=0.5u W=1u
M6385 o6 ibias vss vss sky130_fd_pr__nfet_01v8 L=0.5u W=1u
M6386 o6 ibias vss vss sky130_fd_pr__nfet_01v8 L=0.5u W=1u
M6387 o6 ibias vss vss sky130_fd_pr__nfet_01v8 L=0.5u W=1u
M6388 o6 ibias vss vss sky130_fd_pr__nfet_01v8 L=0.5u W=1u
M6389 o6 ibias vss vss sky130_fd_pr__nfet_01v8 L=0.5u W=1u
M6390 o6 ibias vss vss sky130_fd_pr__nfet_01v8 L=0.5u W=1u
M6391 o6 ibias vss vss sky130_fd_pr__nfet_01v8 L=0.5u W=1u
M6392 o6 ibias vss vss sky130_fd_pr__nfet_01v8 L=0.5u W=1u
M6393 o6 ibias vss vss sky130_fd_pr__nfet_01v8 L=0.5u W=1u
M6394 o6 ibias vss vss sky130_fd_pr__nfet_01v8 L=0.5u W=1u
M6395 o6 ibias vss vss sky130_fd_pr__nfet_01v8 L=0.5u W=1u
M6396 o6 ibias vss vss sky130_fd_pr__nfet_01v8 L=0.5u W=1u
M6397 o6 ibias vss vss sky130_fd_pr__nfet_01v8 L=0.5u W=1u
M6398 o6 ibias vss vss sky130_fd_pr__nfet_01v8 L=0.5u W=1u
M6399 o6 ibias vss vss sky130_fd_pr__nfet_01v8 L=0.5u W=1u
M6400 o6 ibias vss vss sky130_fd_pr__nfet_01v8 L=0.5u W=1u
M6401 o6 ibias vss vss sky130_fd_pr__nfet_01v8 L=0.5u W=1u
M6402 o6 ibias vss vss sky130_fd_pr__nfet_01v8 L=0.5u W=1u
M6403 o6 ibias vss vss sky130_fd_pr__nfet_01v8 L=0.5u W=1u
M6404 o6 ibias vss vss sky130_fd_pr__nfet_01v8 L=0.5u W=1u
M6405 o6 ibias vss vss sky130_fd_pr__nfet_01v8 L=0.5u W=1u
M6406 o6 ibias vss vss sky130_fd_pr__nfet_01v8 L=0.5u W=1u
M6407 o6 ibias vss vss sky130_fd_pr__nfet_01v8 L=0.5u W=1u
M6408 o6 ibias vss vss sky130_fd_pr__nfet_01v8 L=0.5u W=1u
M6409 o6 ibias vss vss sky130_fd_pr__nfet_01v8 L=0.5u W=1u
M6410 o6 ibias vss vss sky130_fd_pr__nfet_01v8 L=0.5u W=1u
M6411 o6 ibias vss vss sky130_fd_pr__nfet_01v8 L=0.5u W=1u
M6412 o6 ibias vss vss sky130_fd_pr__nfet_01v8 L=0.5u W=1u
M6413 o6 ibias vss vss sky130_fd_pr__nfet_01v8 L=0.5u W=1u
M6414 o6 ibias vss vss sky130_fd_pr__nfet_01v8 L=0.5u W=1u
M6415 o6 ibias vss vss sky130_fd_pr__nfet_01v8 L=0.5u W=1u
M6416 o6 ibias vss vss sky130_fd_pr__nfet_01v8 L=0.5u W=1u
M6417 o6 ibias vss vss sky130_fd_pr__nfet_01v8 L=0.5u W=1u
M6418 o6 ibias vss vss sky130_fd_pr__nfet_01v8 L=0.5u W=1u
M6419 o6 ibias vss vss sky130_fd_pr__nfet_01v8 L=0.5u W=1u
M6420 o6 ibias vss vss sky130_fd_pr__nfet_01v8 L=0.5u W=1u
M6421 o6 ibias vss vss sky130_fd_pr__nfet_01v8 L=0.5u W=1u
M6422 o6 ibias vss vss sky130_fd_pr__nfet_01v8 L=0.5u W=1u
M6423 o6 ibias vss vss sky130_fd_pr__nfet_01v8 L=0.5u W=1u
M6424 o6 ibias vss vss sky130_fd_pr__nfet_01v8 L=0.5u W=1u
M6425 o6 ibias vss vss sky130_fd_pr__nfet_01v8 L=0.5u W=1u
M6426 o6 ibias vss vss sky130_fd_pr__nfet_01v8 L=0.5u W=1u
M6427 o6 ibias vss vss sky130_fd_pr__nfet_01v8 L=0.5u W=1u
M6428 o6 ibias vss vss sky130_fd_pr__nfet_01v8 L=0.5u W=1u
M6429 o6 ibias vss vss sky130_fd_pr__nfet_01v8 L=0.5u W=1u
M6430 o6 ibias vss vss sky130_fd_pr__nfet_01v8 L=0.5u W=1u
M6431 o6 ibias vss vss sky130_fd_pr__nfet_01v8 L=0.5u W=1u
M6432 o6 ibias vss vss sky130_fd_pr__nfet_01v8 L=0.5u W=1u
M6433 o6 ibias vss vss sky130_fd_pr__nfet_01v8 L=0.5u W=1u
M6434 o6 ibias vss vss sky130_fd_pr__nfet_01v8 L=0.5u W=1u
M6435 o6 ibias vss vss sky130_fd_pr__nfet_01v8 L=0.5u W=1u
M6436 o6 ibias vss vss sky130_fd_pr__nfet_01v8 L=0.5u W=1u
M6437 o6 ibias vss vss sky130_fd_pr__nfet_01v8 L=0.5u W=1u
M6438 o6 ibias vss vss sky130_fd_pr__nfet_01v8 L=0.5u W=1u
M6439 o6 ibias vss vss sky130_fd_pr__nfet_01v8 L=0.5u W=1u
M6440 o6 ibias vss vss sky130_fd_pr__nfet_01v8 L=0.5u W=1u
M6441 o6 ibias vss vss sky130_fd_pr__nfet_01v8 L=0.5u W=1u
M6442 o6 ibias vss vss sky130_fd_pr__nfet_01v8 L=0.5u W=1u
M6443 o6 ibias vss vss sky130_fd_pr__nfet_01v8 L=0.5u W=1u
M6444 o6 ibias vss vss sky130_fd_pr__nfet_01v8 L=0.5u W=1u
M6445 o6 ibias vss vss sky130_fd_pr__nfet_01v8 L=0.5u W=1u
M6446 o6 ibias vss vss sky130_fd_pr__nfet_01v8 L=0.5u W=1u
M6447 o6 ibias vss vss sky130_fd_pr__nfet_01v8 L=0.5u W=1u
M6448 o6 ibias vss vss sky130_fd_pr__nfet_01v8 L=0.5u W=1u
M6449 o6 ibias vss vss sky130_fd_pr__nfet_01v8 L=0.5u W=1u
M6450 o6 ibias vss vss sky130_fd_pr__nfet_01v8 L=0.5u W=1u
M6451 o6 ibias vss vss sky130_fd_pr__nfet_01v8 L=0.5u W=1u
M6452 o6 ibias vss vss sky130_fd_pr__nfet_01v8 L=0.5u W=1u
M6453 o6 ibias vss vss sky130_fd_pr__nfet_01v8 L=0.5u W=1u
M6454 o6 ibias vss vss sky130_fd_pr__nfet_01v8 L=0.5u W=1u
M6455 o6 ibias vss vss sky130_fd_pr__nfet_01v8 L=0.5u W=1u
M6456 o6 ibias vss vss sky130_fd_pr__nfet_01v8 L=0.5u W=1u
M6457 o6 ibias vss vss sky130_fd_pr__nfet_01v8 L=0.5u W=1u
M6458 o6 ibias vss vss sky130_fd_pr__nfet_01v8 L=0.5u W=1u
M6459 o6 ibias vss vss sky130_fd_pr__nfet_01v8 L=0.5u W=1u
M6460 o6 ibias vss vss sky130_fd_pr__nfet_01v8 L=0.5u W=1u
M6461 o6 ibias vss vss sky130_fd_pr__nfet_01v8 L=0.5u W=1u
M6462 o6 ibias vss vss sky130_fd_pr__nfet_01v8 L=0.5u W=1u
M6463 o6 ibias vss vss sky130_fd_pr__nfet_01v8 L=0.5u W=1u
M6464 o6 ibias vss vss sky130_fd_pr__nfet_01v8 L=0.5u W=1u
M6465 o6 ibias vss vss sky130_fd_pr__nfet_01v8 L=0.5u W=1u
M6466 o6 ibias vss vss sky130_fd_pr__nfet_01v8 L=0.5u W=1u
M6467 o6 ibias vss vss sky130_fd_pr__nfet_01v8 L=0.5u W=1u
M6468 o6 ibias vss vss sky130_fd_pr__nfet_01v8 L=0.5u W=1u
M6469 o6 ibias vss vss sky130_fd_pr__nfet_01v8 L=0.5u W=1u
M6470 o6 ibias vss vss sky130_fd_pr__nfet_01v8 L=0.5u W=1u
M6471 o6 ibias vss vss sky130_fd_pr__nfet_01v8 L=0.5u W=1u
M6472 o6 ibias vss vss sky130_fd_pr__nfet_01v8 L=0.5u W=1u
M6473 o6 ibias vss vss sky130_fd_pr__nfet_01v8 L=0.5u W=1u
M6474 o6 ibias vss vss sky130_fd_pr__nfet_01v8 L=0.5u W=1u
M6475 o6 ibias vss vss sky130_fd_pr__nfet_01v8 L=0.5u W=1u
M6476 o6 ibias vss vss sky130_fd_pr__nfet_01v8 L=0.5u W=1u
M6477 o6 ibias vss vss sky130_fd_pr__nfet_01v8 L=0.5u W=1u
M6478 o6 ibias vss vss sky130_fd_pr__nfet_01v8 L=0.5u W=1u
M6479 o6 ibias vss vss sky130_fd_pr__nfet_01v8 L=0.5u W=1u
M6480 o6 ibias vss vss sky130_fd_pr__nfet_01v8 L=0.5u W=1u
M6481 o6 ibias vss vss sky130_fd_pr__nfet_01v8 L=0.5u W=1u
M6482 o6 ibias vss vss sky130_fd_pr__nfet_01v8 L=0.5u W=1u
M6483 o6 ibias vss vss sky130_fd_pr__nfet_01v8 L=0.5u W=1u
M6484 o6 ibias vss vss sky130_fd_pr__nfet_01v8 L=0.5u W=1u
M6485 o6 ibias vss vss sky130_fd_pr__nfet_01v8 L=0.5u W=1u
M6486 o6 ibias vss vss sky130_fd_pr__nfet_01v8 L=0.5u W=1u
M6487 o6 ibias vss vss sky130_fd_pr__nfet_01v8 L=0.5u W=1u
M6488 o6 ibias vss vss sky130_fd_pr__nfet_01v8 L=0.5u W=1u
M6489 o6 ibias vss vss sky130_fd_pr__nfet_01v8 L=0.5u W=1u
M6490 o6 ibias vss vss sky130_fd_pr__nfet_01v8 L=0.5u W=1u
M6491 o6 ibias vss vss sky130_fd_pr__nfet_01v8 L=0.5u W=1u
M6492 o6 ibias vss vss sky130_fd_pr__nfet_01v8 L=0.5u W=1u
M6493 o6 ibias vss vss sky130_fd_pr__nfet_01v8 L=0.5u W=1u
M6494 o6 ibias vss vss sky130_fd_pr__nfet_01v8 L=0.5u W=1u
M6495 o6 ibias vss vss sky130_fd_pr__nfet_01v8 L=0.5u W=1u
M6496 o6 ibias vss vss sky130_fd_pr__nfet_01v8 L=0.5u W=1u
M6497 o6 ibias vss vss sky130_fd_pr__nfet_01v8 L=0.5u W=1u
M6498 o6 ibias vss vss sky130_fd_pr__nfet_01v8 L=0.5u W=1u
M6499 o6 ibias vss vss sky130_fd_pr__nfet_01v8 L=0.5u W=1u
M6500 o6 ibias vss vss sky130_fd_pr__nfet_01v8 L=0.5u W=1u
M6501 o6 ibias vss vss sky130_fd_pr__nfet_01v8 L=0.5u W=1u
M6502 o6 ibias vss vss sky130_fd_pr__nfet_01v8 L=0.5u W=1u
M6503 o6 ibias vss vss sky130_fd_pr__nfet_01v8 L=0.5u W=1u
M6504 o6 ibias vss vss sky130_fd_pr__nfet_01v8 L=0.5u W=1u
M6505 o6 ibias vss vss sky130_fd_pr__nfet_01v8 L=0.5u W=1u
M6506 o6 ibias vss vss sky130_fd_pr__nfet_01v8 L=0.5u W=1u
M6507 o6 ibias vss vss sky130_fd_pr__nfet_01v8 L=0.5u W=1u
M6508 o6 ibias vss vss sky130_fd_pr__nfet_01v8 L=0.5u W=1u
M6509 o6 ibias vss vss sky130_fd_pr__nfet_01v8 L=0.5u W=1u
M6510 o6 ibias vss vss sky130_fd_pr__nfet_01v8 L=0.5u W=1u
M6511 o6 ibias vss vss sky130_fd_pr__nfet_01v8 L=0.5u W=1u
M6512 o6 ibias vss vss sky130_fd_pr__nfet_01v8 L=0.5u W=1u
M6513 o6 ibias vss vss sky130_fd_pr__nfet_01v8 L=0.5u W=1u
M6514 o6 ibias vss vss sky130_fd_pr__nfet_01v8 L=0.5u W=1u
M6515 o6 ibias vss vss sky130_fd_pr__nfet_01v8 L=0.5u W=1u
M6516 o6 ibias vss vss sky130_fd_pr__nfet_01v8 L=0.5u W=1u
M6517 o6 ibias vss vss sky130_fd_pr__nfet_01v8 L=0.5u W=1u
M6518 o6 ibias vss vss sky130_fd_pr__nfet_01v8 L=0.5u W=1u
M6519 o6 ibias vss vss sky130_fd_pr__nfet_01v8 L=0.5u W=1u
M6520 o6 ibias vss vss sky130_fd_pr__nfet_01v8 L=0.5u W=1u
M6521 o6 ibias vss vss sky130_fd_pr__nfet_01v8 L=0.5u W=1u
M6522 o6 ibias vss vss sky130_fd_pr__nfet_01v8 L=0.5u W=1u
M6523 o6 ibias vss vss sky130_fd_pr__nfet_01v8 L=0.5u W=1u
M6524 o6 ibias vss vss sky130_fd_pr__nfet_01v8 L=0.5u W=1u
M6525 o6 ibias vss vss sky130_fd_pr__nfet_01v8 L=0.5u W=1u
M6526 o6 ibias vss vss sky130_fd_pr__nfet_01v8 L=0.5u W=1u
M6527 o6 ibias vss vss sky130_fd_pr__nfet_01v8 L=0.5u W=1u
M6528 o6 ibias vss vss sky130_fd_pr__nfet_01v8 L=0.5u W=1u
M6529 o6 ibias vss vss sky130_fd_pr__nfet_01v8 L=0.5u W=1u
M6530 o6 ibias vss vss sky130_fd_pr__nfet_01v8 L=0.5u W=1u
M6531 o6 ibias vss vss sky130_fd_pr__nfet_01v8 L=0.5u W=1u
M6532 o6 ibias vss vss sky130_fd_pr__nfet_01v8 L=0.5u W=1u
M6533 o6 ibias vss vss sky130_fd_pr__nfet_01v8 L=0.5u W=1u
M6534 o6 ibias vss vss sky130_fd_pr__nfet_01v8 L=0.5u W=1u
M6535 o6 ibias vss vss sky130_fd_pr__nfet_01v8 L=0.5u W=1u
M6536 o6 ibias vss vss sky130_fd_pr__nfet_01v8 L=0.5u W=1u
M6537 o6 ibias vss vss sky130_fd_pr__nfet_01v8 L=0.5u W=1u
M6538 o6 ibias vss vss sky130_fd_pr__nfet_01v8 L=0.5u W=1u
M6539 o6 ibias vss vss sky130_fd_pr__nfet_01v8 L=0.5u W=1u
M6540 o6 ibias vss vss sky130_fd_pr__nfet_01v8 L=0.5u W=1u
M6541 o6 ibias vss vss sky130_fd_pr__nfet_01v8 L=0.5u W=1u
M6542 o6 ibias vss vss sky130_fd_pr__nfet_01v8 L=0.5u W=1u
M6543 o6 ibias vss vss sky130_fd_pr__nfet_01v8 L=0.5u W=1u
M6544 o6 ibias vss vss sky130_fd_pr__nfet_01v8 L=0.5u W=1u
M6545 o6 ibias vss vss sky130_fd_pr__nfet_01v8 L=0.5u W=1u
M6546 o6 ibias vss vss sky130_fd_pr__nfet_01v8 L=0.5u W=1u
M6547 o6 ibias vss vss sky130_fd_pr__nfet_01v8 L=0.5u W=1u
M6548 o6 ibias vss vss sky130_fd_pr__nfet_01v8 L=0.5u W=1u
M6549 o6 ibias vss vss sky130_fd_pr__nfet_01v8 L=0.5u W=1u
M6550 o6 ibias vss vss sky130_fd_pr__nfet_01v8 L=0.5u W=1u
M6551 o6 ibias vss vss sky130_fd_pr__nfet_01v8 L=0.5u W=1u
M6552 o6 ibias vss vss sky130_fd_pr__nfet_01v8 L=0.5u W=1u
M6553 o6 ibias vss vss sky130_fd_pr__nfet_01v8 L=0.5u W=1u
M6554 o6 ibias vss vss sky130_fd_pr__nfet_01v8 L=0.5u W=1u
M6555 o6 ibias vss vss sky130_fd_pr__nfet_01v8 L=0.5u W=1u
M6556 o6 ibias vss vss sky130_fd_pr__nfet_01v8 L=0.5u W=1u
M6557 o6 ibias vss vss sky130_fd_pr__nfet_01v8 L=0.5u W=1u
M6558 o6 ibias vss vss sky130_fd_pr__nfet_01v8 L=0.5u W=1u
M6559 o6 ibias vss vss sky130_fd_pr__nfet_01v8 L=0.5u W=1u
M6560 o6 ibias vss vss sky130_fd_pr__nfet_01v8 L=0.5u W=1u
M6561 o6 ibias vss vss sky130_fd_pr__nfet_01v8 L=0.5u W=1u
M6562 o6 ibias vss vss sky130_fd_pr__nfet_01v8 L=0.5u W=1u
M6563 o6 ibias vss vss sky130_fd_pr__nfet_01v8 L=0.5u W=1u
M6564 o6 ibias vss vss sky130_fd_pr__nfet_01v8 L=0.5u W=1u
M6565 o6 ibias vss vss sky130_fd_pr__nfet_01v8 L=0.5u W=1u
M6566 o6 ibias vss vss sky130_fd_pr__nfet_01v8 L=0.5u W=1u
M6567 o6 ibias vss vss sky130_fd_pr__nfet_01v8 L=0.5u W=1u
M6568 o6 ibias vss vss sky130_fd_pr__nfet_01v8 L=0.5u W=1u
M6569 o6 ibias vss vss sky130_fd_pr__nfet_01v8 L=0.5u W=1u
M6570 o6 ibias vss vss sky130_fd_pr__nfet_01v8 L=0.5u W=1u
M6571 o6 ibias vss vss sky130_fd_pr__nfet_01v8 L=0.5u W=1u
M6572 o6 ibias vss vss sky130_fd_pr__nfet_01v8 L=0.5u W=1u
M6573 o6 ibias vss vss sky130_fd_pr__nfet_01v8 L=0.5u W=1u
M6574 o6 ibias vss vss sky130_fd_pr__nfet_01v8 L=0.5u W=1u
M6575 o6 ibias vss vss sky130_fd_pr__nfet_01v8 L=0.5u W=1u
M6576 o6 ibias vss vss sky130_fd_pr__nfet_01v8 L=0.5u W=1u
M6577 o6 ibias vss vss sky130_fd_pr__nfet_01v8 L=0.5u W=1u
M6578 o6 ibias vss vss sky130_fd_pr__nfet_01v8 L=0.5u W=1u
M6579 o6 ibias vss vss sky130_fd_pr__nfet_01v8 L=0.5u W=1u
M6580 o6 ibias vss vss sky130_fd_pr__nfet_01v8 L=0.5u W=1u
M6581 o6 ibias vss vss sky130_fd_pr__nfet_01v8 L=0.5u W=1u
M6582 o6 ibias vss vss sky130_fd_pr__nfet_01v8 L=0.5u W=1u
M6583 o6 ibias vss vss sky130_fd_pr__nfet_01v8 L=0.5u W=1u
M6584 o6 ibias vss vss sky130_fd_pr__nfet_01v8 L=0.5u W=1u
M6585 o6 ibias vss vss sky130_fd_pr__nfet_01v8 L=0.5u W=1u
M6586 o6 ibias vss vss sky130_fd_pr__nfet_01v8 L=0.5u W=1u
M6587 o6 ibias vss vss sky130_fd_pr__nfet_01v8 L=0.5u W=1u
M6588 o6 ibias vss vss sky130_fd_pr__nfet_01v8 L=0.5u W=1u
M6589 o6 ibias vss vss sky130_fd_pr__nfet_01v8 L=0.5u W=1u
M6590 o6 ibias vss vss sky130_fd_pr__nfet_01v8 L=0.5u W=1u
M6591 o6 ibias vss vss sky130_fd_pr__nfet_01v8 L=0.5u W=1u
M6592 o6 ibias vss vss sky130_fd_pr__nfet_01v8 L=0.5u W=1u
M6593 o6 ibias vss vss sky130_fd_pr__nfet_01v8 L=0.5u W=1u
M6594 o6 ibias vss vss sky130_fd_pr__nfet_01v8 L=0.5u W=1u
M6595 o6 ibias vss vss sky130_fd_pr__nfet_01v8 L=0.5u W=1u
M6596 o6 ibias vss vss sky130_fd_pr__nfet_01v8 L=0.5u W=1u
M6597 o6 ibias vss vss sky130_fd_pr__nfet_01v8 L=0.5u W=1u
M6598 o6 ibias vss vss sky130_fd_pr__nfet_01v8 L=0.5u W=1u
M6599 o6 ibias vss vss sky130_fd_pr__nfet_01v8 L=0.5u W=1u
M6600 o6 ibias vss vss sky130_fd_pr__nfet_01v8 L=0.5u W=1u
M6601 o6 ibias vss vss sky130_fd_pr__nfet_01v8 L=0.5u W=1u
M6602 o6 ibias vss vss sky130_fd_pr__nfet_01v8 L=0.5u W=1u
M6603 o6 ibias vss vss sky130_fd_pr__nfet_01v8 L=0.5u W=1u
M6604 o6 ibias vss vss sky130_fd_pr__nfet_01v8 L=0.5u W=1u
M6605 o6 ibias vss vss sky130_fd_pr__nfet_01v8 L=0.5u W=1u
M6606 o6 ibias vss vss sky130_fd_pr__nfet_01v8 L=0.5u W=1u
M6607 o6 ibias vss vss sky130_fd_pr__nfet_01v8 L=0.5u W=1u
M6608 o6 ibias vss vss sky130_fd_pr__nfet_01v8 L=0.5u W=1u
M6609 o6 ibias vss vss sky130_fd_pr__nfet_01v8 L=0.5u W=1u
M6610 o6 ibias vss vss sky130_fd_pr__nfet_01v8 L=0.5u W=1u
M6611 o6 ibias vss vss sky130_fd_pr__nfet_01v8 L=0.5u W=1u
M6612 o6 ibias vss vss sky130_fd_pr__nfet_01v8 L=0.5u W=1u
M6613 o6 ibias vss vss sky130_fd_pr__nfet_01v8 L=0.5u W=1u
M6614 o6 ibias vss vss sky130_fd_pr__nfet_01v8 L=0.5u W=1u
M6615 o6 ibias vss vss sky130_fd_pr__nfet_01v8 L=0.5u W=1u
M6616 o6 ibias vss vss sky130_fd_pr__nfet_01v8 L=0.5u W=1u
M6617 o6 ibias vss vss sky130_fd_pr__nfet_01v8 L=0.5u W=1u
M6618 o6 ibias vss vss sky130_fd_pr__nfet_01v8 L=0.5u W=1u
M6619 o6 ibias vss vss sky130_fd_pr__nfet_01v8 L=0.5u W=1u
M6620 o6 ibias vss vss sky130_fd_pr__nfet_01v8 L=0.5u W=1u
M6621 o6 ibias vss vss sky130_fd_pr__nfet_01v8 L=0.5u W=1u
M6622 o6 ibias vss vss sky130_fd_pr__nfet_01v8 L=0.5u W=1u
M6623 o6 ibias vss vss sky130_fd_pr__nfet_01v8 L=0.5u W=1u
M6624 o6 ibias vss vss sky130_fd_pr__nfet_01v8 L=0.5u W=1u
M6625 o6 ibias vss vss sky130_fd_pr__nfet_01v8 L=0.5u W=1u
M6626 o6 ibias vss vss sky130_fd_pr__nfet_01v8 L=0.5u W=1u
M6627 o6 ibias vss vss sky130_fd_pr__nfet_01v8 L=0.5u W=1u
M6628 o6 ibias vss vss sky130_fd_pr__nfet_01v8 L=0.5u W=1u
M6629 o6 ibias vss vss sky130_fd_pr__nfet_01v8 L=0.5u W=1u
M6630 o6 ibias vss vss sky130_fd_pr__nfet_01v8 L=0.5u W=1u
M6631 o6 ibias vss vss sky130_fd_pr__nfet_01v8 L=0.5u W=1u
M6632 o6 ibias vss vss sky130_fd_pr__nfet_01v8 L=0.5u W=1u
M6633 o6 ibias vss vss sky130_fd_pr__nfet_01v8 L=0.5u W=1u
M6634 o6 ibias vss vss sky130_fd_pr__nfet_01v8 L=0.5u W=1u
M6635 o6 ibias vss vss sky130_fd_pr__nfet_01v8 L=0.5u W=1u
M6636 o6 ibias vss vss sky130_fd_pr__nfet_01v8 L=0.5u W=1u
M6637 o6 ibias vss vss sky130_fd_pr__nfet_01v8 L=0.5u W=1u
M6638 o6 ibias vss vss sky130_fd_pr__nfet_01v8 L=0.5u W=1u
M6639 o6 ibias vss vss sky130_fd_pr__nfet_01v8 L=0.5u W=1u
M6640 o6 ibias vss vss sky130_fd_pr__nfet_01v8 L=0.5u W=1u
M6641 o6 ibias vss vss sky130_fd_pr__nfet_01v8 L=0.5u W=1u
M6642 o6 ibias vss vss sky130_fd_pr__nfet_01v8 L=0.5u W=1u
M6643 o6 ibias vss vss sky130_fd_pr__nfet_01v8 L=0.5u W=1u
M6644 o6 ibias vss vss sky130_fd_pr__nfet_01v8 L=0.5u W=1u
M6645 o6 ibias vss vss sky130_fd_pr__nfet_01v8 L=0.5u W=1u
M6646 o6 ibias vss vss sky130_fd_pr__nfet_01v8 L=0.5u W=1u
M6647 o6 ibias vss vss sky130_fd_pr__nfet_01v8 L=0.5u W=1u
M6648 o6 ibias vss vss sky130_fd_pr__nfet_01v8 L=0.5u W=1u
M6649 o6 ibias vss vss sky130_fd_pr__nfet_01v8 L=0.5u W=1u
M6650 o6 ibias vss vss sky130_fd_pr__nfet_01v8 L=0.5u W=1u
M6651 o6 ibias vss vss sky130_fd_pr__nfet_01v8 L=0.5u W=1u
M6652 o6 ibias vss vss sky130_fd_pr__nfet_01v8 L=0.5u W=1u
M6653 o6 ibias vss vss sky130_fd_pr__nfet_01v8 L=0.5u W=1u
M6654 o6 ibias vss vss sky130_fd_pr__nfet_01v8 L=0.5u W=1u
M6655 o6 ibias vss vss sky130_fd_pr__nfet_01v8 L=0.5u W=1u
M6656 o6 ibias vss vss sky130_fd_pr__nfet_01v8 L=0.5u W=1u
M6657 o6 ibias vss vss sky130_fd_pr__nfet_01v8 L=0.5u W=1u
M6658 o6 ibias vss vss sky130_fd_pr__nfet_01v8 L=0.5u W=1u
M6659 o6 ibias vss vss sky130_fd_pr__nfet_01v8 L=0.5u W=1u
M6660 o6 ibias vss vss sky130_fd_pr__nfet_01v8 L=0.5u W=1u
M6661 o6 ibias vss vss sky130_fd_pr__nfet_01v8 L=0.5u W=1u
M6662 o6 ibias vss vss sky130_fd_pr__nfet_01v8 L=0.5u W=1u
M6663 o6 ibias vss vss sky130_fd_pr__nfet_01v8 L=0.5u W=1u
M6664 o6 ibias vss vss sky130_fd_pr__nfet_01v8 L=0.5u W=1u
M6665 o6 ibias vss vss sky130_fd_pr__nfet_01v8 L=0.5u W=1u
M6666 o6 ibias vss vss sky130_fd_pr__nfet_01v8 L=0.5u W=1u
M6667 o6 ibias vss vss sky130_fd_pr__nfet_01v8 L=0.5u W=1u
M6668 o6 ibias vss vss sky130_fd_pr__nfet_01v8 L=0.5u W=1u
M6669 o6 ibias vss vss sky130_fd_pr__nfet_01v8 L=0.5u W=1u
M6670 o6 ibias vss vss sky130_fd_pr__nfet_01v8 L=0.5u W=1u
M6671 o6 ibias vss vss sky130_fd_pr__nfet_01v8 L=0.5u W=1u
M6672 o6 ibias vss vss sky130_fd_pr__nfet_01v8 L=0.5u W=1u
M6673 o6 ibias vss vss sky130_fd_pr__nfet_01v8 L=0.5u W=1u
M6674 o6 ibias vss vss sky130_fd_pr__nfet_01v8 L=0.5u W=1u
M6675 o6 ibias vss vss sky130_fd_pr__nfet_01v8 L=0.5u W=1u
M6676 o6 ibias vss vss sky130_fd_pr__nfet_01v8 L=0.5u W=1u
M6677 o6 ibias vss vss sky130_fd_pr__nfet_01v8 L=0.5u W=1u
M6678 o6 ibias vss vss sky130_fd_pr__nfet_01v8 L=0.5u W=1u
M6679 o6 ibias vss vss sky130_fd_pr__nfet_01v8 L=0.5u W=1u
M6680 o6 ibias vss vss sky130_fd_pr__nfet_01v8 L=0.5u W=1u
M6681 o6 ibias vss vss sky130_fd_pr__nfet_01v8 L=0.5u W=1u
M6682 o6 ibias vss vss sky130_fd_pr__nfet_01v8 L=0.5u W=1u
M6683 o6 ibias vss vss sky130_fd_pr__nfet_01v8 L=0.5u W=1u
M6684 o6 ibias vss vss sky130_fd_pr__nfet_01v8 L=0.5u W=1u
M6685 o6 ibias vss vss sky130_fd_pr__nfet_01v8 L=0.5u W=1u
M6686 o6 ibias vss vss sky130_fd_pr__nfet_01v8 L=0.5u W=1u
M6687 o6 ibias vss vss sky130_fd_pr__nfet_01v8 L=0.5u W=1u
M6688 o6 ibias vss vss sky130_fd_pr__nfet_01v8 L=0.5u W=1u
M6689 o6 ibias vss vss sky130_fd_pr__nfet_01v8 L=0.5u W=1u
M6690 o6 ibias vss vss sky130_fd_pr__nfet_01v8 L=0.5u W=1u
M6691 o6 ibias vss vss sky130_fd_pr__nfet_01v8 L=0.5u W=1u
M6692 o6 ibias vss vss sky130_fd_pr__nfet_01v8 L=0.5u W=1u
M6693 o6 ibias vss vss sky130_fd_pr__nfet_01v8 L=0.5u W=1u
M6694 o6 ibias vss vss sky130_fd_pr__nfet_01v8 L=0.5u W=1u
M6695 o6 ibias vss vss sky130_fd_pr__nfet_01v8 L=0.5u W=1u
M6696 o6 ibias vss vss sky130_fd_pr__nfet_01v8 L=0.5u W=1u
M6697 o6 ibias vss vss sky130_fd_pr__nfet_01v8 L=0.5u W=1u
M6698 o6 ibias vss vss sky130_fd_pr__nfet_01v8 L=0.5u W=1u
M6699 o6 ibias vss vss sky130_fd_pr__nfet_01v8 L=0.5u W=1u
M6700 o6 ibias vss vss sky130_fd_pr__nfet_01v8 L=0.5u W=1u
M6701 o6 ibias vss vss sky130_fd_pr__nfet_01v8 L=0.5u W=1u
M6702 o6 ibias vss vss sky130_fd_pr__nfet_01v8 L=0.5u W=1u
M6703 o6 ibias vss vss sky130_fd_pr__nfet_01v8 L=0.5u W=1u
M6704 o6 ibias vss vss sky130_fd_pr__nfet_01v8 L=0.5u W=1u
M6705 o6 ibias vss vss sky130_fd_pr__nfet_01v8 L=0.5u W=1u
M6706 o6 ibias vss vss sky130_fd_pr__nfet_01v8 L=0.5u W=1u
M6707 o6 ibias vss vss sky130_fd_pr__nfet_01v8 L=0.5u W=1u
M6708 o6 ibias vss vss sky130_fd_pr__nfet_01v8 L=0.5u W=1u
M6709 o6 ibias vss vss sky130_fd_pr__nfet_01v8 L=0.5u W=1u
M6710 o6 ibias vss vss sky130_fd_pr__nfet_01v8 L=0.5u W=1u
M6711 o6 ibias vss vss sky130_fd_pr__nfet_01v8 L=0.5u W=1u
M6712 o6 ibias vss vss sky130_fd_pr__nfet_01v8 L=0.5u W=1u
M6713 o6 ibias vss vss sky130_fd_pr__nfet_01v8 L=0.5u W=1u
M6714 o6 ibias vss vss sky130_fd_pr__nfet_01v8 L=0.5u W=1u
M6715 o6 ibias vss vss sky130_fd_pr__nfet_01v8 L=0.5u W=1u
M6716 o6 ibias vss vss sky130_fd_pr__nfet_01v8 L=0.5u W=1u
M6717 o6 ibias vss vss sky130_fd_pr__nfet_01v8 L=0.5u W=1u
M6718 o6 ibias vss vss sky130_fd_pr__nfet_01v8 L=0.5u W=1u
M6719 o6 ibias vss vss sky130_fd_pr__nfet_01v8 L=0.5u W=1u
M6720 o6 ibias vss vss sky130_fd_pr__nfet_01v8 L=0.5u W=1u
M6721 o6 ibias vss vss sky130_fd_pr__nfet_01v8 L=0.5u W=1u
M6722 o6 ibias vss vss sky130_fd_pr__nfet_01v8 L=0.5u W=1u
M6723 o6 ibias vss vss sky130_fd_pr__nfet_01v8 L=0.5u W=1u
M6724 o6 ibias vss vss sky130_fd_pr__nfet_01v8 L=0.5u W=1u
M6725 o6 ibias vss vss sky130_fd_pr__nfet_01v8 L=0.5u W=1u
M6726 o6 ibias vss vss sky130_fd_pr__nfet_01v8 L=0.5u W=1u
M6727 o6 ibias vss vss sky130_fd_pr__nfet_01v8 L=0.5u W=1u
M6728 o6 ibias vss vss sky130_fd_pr__nfet_01v8 L=0.5u W=1u
M6729 o6 ibias vss vss sky130_fd_pr__nfet_01v8 L=0.5u W=1u
M6730 o6 ibias vss vss sky130_fd_pr__nfet_01v8 L=0.5u W=1u
M6731 o6 ibias vss vss sky130_fd_pr__nfet_01v8 L=0.5u W=1u
M6732 o6 ibias vss vss sky130_fd_pr__nfet_01v8 L=0.5u W=1u
M6733 o6 ibias vss vss sky130_fd_pr__nfet_01v8 L=0.5u W=1u
M6734 o6 ibias vss vss sky130_fd_pr__nfet_01v8 L=0.5u W=1u
M6735 o6 ibias vss vss sky130_fd_pr__nfet_01v8 L=0.5u W=1u
M6736 o6 ibias vss vss sky130_fd_pr__nfet_01v8 L=0.5u W=1u
M6737 o6 ibias vss vss sky130_fd_pr__nfet_01v8 L=0.5u W=1u
M6738 o6 ibias vss vss sky130_fd_pr__nfet_01v8 L=0.5u W=1u
M6739 o6 ibias vss vss sky130_fd_pr__nfet_01v8 L=0.5u W=1u
M6740 o6 ibias vss vss sky130_fd_pr__nfet_01v8 L=0.5u W=1u
M6741 o6 ibias vss vss sky130_fd_pr__nfet_01v8 L=0.5u W=1u
M6742 o6 ibias vss vss sky130_fd_pr__nfet_01v8 L=0.5u W=1u
M6743 o6 ibias vss vss sky130_fd_pr__nfet_01v8 L=0.5u W=1u
M6744 o6 ibias vss vss sky130_fd_pr__nfet_01v8 L=0.5u W=1u
M6745 o6 ibias vss vss sky130_fd_pr__nfet_01v8 L=0.5u W=1u
M6746 o6 ibias vss vss sky130_fd_pr__nfet_01v8 L=0.5u W=1u
M6747 o6 ibias vss vss sky130_fd_pr__nfet_01v8 L=0.5u W=1u
M6748 o6 ibias vss vss sky130_fd_pr__nfet_01v8 L=0.5u W=1u
M6749 o6 ibias vss vss sky130_fd_pr__nfet_01v8 L=0.5u W=1u
M6750 o6 ibias vss vss sky130_fd_pr__nfet_01v8 L=0.5u W=1u
M6751 o6 ibias vss vss sky130_fd_pr__nfet_01v8 L=0.5u W=1u
M6752 o6 ibias vss vss sky130_fd_pr__nfet_01v8 L=0.5u W=1u
M6753 o6 ibias vss vss sky130_fd_pr__nfet_01v8 L=0.5u W=1u
M6754 o6 ibias vss vss sky130_fd_pr__nfet_01v8 L=0.5u W=1u
M6755 o6 ibias vss vss sky130_fd_pr__nfet_01v8 L=0.5u W=1u
M6756 o6 ibias vss vss sky130_fd_pr__nfet_01v8 L=0.5u W=1u
M6757 o6 ibias vss vss sky130_fd_pr__nfet_01v8 L=0.5u W=1u
M6758 o6 ibias vss vss sky130_fd_pr__nfet_01v8 L=0.5u W=1u
M6759 o6 ibias vss vss sky130_fd_pr__nfet_01v8 L=0.5u W=1u
M6760 o6 ibias vss vss sky130_fd_pr__nfet_01v8 L=0.5u W=1u
M6761 o6 ibias vss vss sky130_fd_pr__nfet_01v8 L=0.5u W=1u
M6762 o6 ibias vss vss sky130_fd_pr__nfet_01v8 L=0.5u W=1u
M6763 o6 ibias vss vss sky130_fd_pr__nfet_01v8 L=0.5u W=1u
M6764 o6 ibias vss vss sky130_fd_pr__nfet_01v8 L=0.5u W=1u
M6765 o6 ibias vss vss sky130_fd_pr__nfet_01v8 L=0.5u W=1u
M6766 o6 ibias vss vss sky130_fd_pr__nfet_01v8 L=0.5u W=1u
M6767 o6 ibias vss vss sky130_fd_pr__nfet_01v8 L=0.5u W=1u
M6768 o6 ibias vss vss sky130_fd_pr__nfet_01v8 L=0.5u W=1u
M6769 o6 ibias vss vss sky130_fd_pr__nfet_01v8 L=0.5u W=1u
M6770 o6 ibias vss vss sky130_fd_pr__nfet_01v8 L=0.5u W=1u
M6771 o6 ibias vss vss sky130_fd_pr__nfet_01v8 L=0.5u W=1u
M6772 o6 ibias vss vss sky130_fd_pr__nfet_01v8 L=0.5u W=1u
M6773 o6 ibias vss vss sky130_fd_pr__nfet_01v8 L=0.5u W=1u
M6774 o6 ibias vss vss sky130_fd_pr__nfet_01v8 L=0.5u W=1u
M6775 o6 ibias vss vss sky130_fd_pr__nfet_01v8 L=0.5u W=1u
M6776 o6 ibias vss vss sky130_fd_pr__nfet_01v8 L=0.5u W=1u
M6777 o6 ibias vss vss sky130_fd_pr__nfet_01v8 L=0.5u W=1u
M6778 o6 ibias vss vss sky130_fd_pr__nfet_01v8 L=0.5u W=1u
M6779 o6 ibias vss vss sky130_fd_pr__nfet_01v8 L=0.5u W=1u
M6780 o6 ibias vss vss sky130_fd_pr__nfet_01v8 L=0.5u W=1u
M6781 o6 ibias vss vss sky130_fd_pr__nfet_01v8 L=0.5u W=1u
M6782 o6 ibias vss vss sky130_fd_pr__nfet_01v8 L=0.5u W=1u
M6783 o6 ibias vss vss sky130_fd_pr__nfet_01v8 L=0.5u W=1u
M6784 o6 ibias vss vss sky130_fd_pr__nfet_01v8 L=0.5u W=1u
M6785 o6 ibias vss vss sky130_fd_pr__nfet_01v8 L=0.5u W=1u
M6786 o6 ibias vss vss sky130_fd_pr__nfet_01v8 L=0.5u W=1u
M6787 o6 ibias vss vss sky130_fd_pr__nfet_01v8 L=0.5u W=1u
M6788 o6 ibias vss vss sky130_fd_pr__nfet_01v8 L=0.5u W=1u
M6789 o6 ibias vss vss sky130_fd_pr__nfet_01v8 L=0.5u W=1u
M6790 o6 ibias vss vss sky130_fd_pr__nfet_01v8 L=0.5u W=1u
M6791 o6 ibias vss vss sky130_fd_pr__nfet_01v8 L=0.5u W=1u
M6792 o6 ibias vss vss sky130_fd_pr__nfet_01v8 L=0.5u W=1u
M6793 o6 ibias vss vss sky130_fd_pr__nfet_01v8 L=0.5u W=1u
M6794 o6 ibias vss vss sky130_fd_pr__nfet_01v8 L=0.5u W=1u
M6795 o6 ibias vss vss sky130_fd_pr__nfet_01v8 L=0.5u W=1u
M6796 o6 ibias vss vss sky130_fd_pr__nfet_01v8 L=0.5u W=1u
M6797 o6 ibias vss vss sky130_fd_pr__nfet_01v8 L=0.5u W=1u
M6798 o6 ibias vss vss sky130_fd_pr__nfet_01v8 L=0.5u W=1u
M6799 o6 ibias vss vss sky130_fd_pr__nfet_01v8 L=0.5u W=1u
M6800 o6 ibias vss vss sky130_fd_pr__nfet_01v8 L=0.5u W=1u
M6801 o6 ibias vss vss sky130_fd_pr__nfet_01v8 L=0.5u W=1u
M6802 o6 ibias vss vss sky130_fd_pr__nfet_01v8 L=0.5u W=1u
M6803 o6 ibias vss vss sky130_fd_pr__nfet_01v8 L=0.5u W=1u
M6804 o6 ibias vss vss sky130_fd_pr__nfet_01v8 L=0.5u W=1u
M6805 o6 ibias vss vss sky130_fd_pr__nfet_01v8 L=0.5u W=1u
M6806 o6 ibias vss vss sky130_fd_pr__nfet_01v8 L=0.5u W=1u
M6807 o6 ibias vss vss sky130_fd_pr__nfet_01v8 L=0.5u W=1u
M6808 o6 ibias vss vss sky130_fd_pr__nfet_01v8 L=0.5u W=1u
M6809 o6 ibias vss vss sky130_fd_pr__nfet_01v8 L=0.5u W=1u
M6810 o6 ibias vss vss sky130_fd_pr__nfet_01v8 L=0.5u W=1u
M6811 o6 ibias vss vss sky130_fd_pr__nfet_01v8 L=0.5u W=1u
M6812 o6 ibias vss vss sky130_fd_pr__nfet_01v8 L=0.5u W=1u
M6813 o6 ibias vss vss sky130_fd_pr__nfet_01v8 L=0.5u W=1u
M6814 o6 ibias vss vss sky130_fd_pr__nfet_01v8 L=0.5u W=1u
M6815 o6 ibias vss vss sky130_fd_pr__nfet_01v8 L=0.5u W=1u
M6816 o6 ibias vss vss sky130_fd_pr__nfet_01v8 L=0.5u W=1u
M6817 o6 ibias vss vss sky130_fd_pr__nfet_01v8 L=0.5u W=1u
M6818 o6 ibias vss vss sky130_fd_pr__nfet_01v8 L=0.5u W=1u
M6819 o6 ibias vss vss sky130_fd_pr__nfet_01v8 L=0.5u W=1u
M6820 o6 ibias vss vss sky130_fd_pr__nfet_01v8 L=0.5u W=1u
M6821 o6 ibias vss vss sky130_fd_pr__nfet_01v8 L=0.5u W=1u
M6822 o6 ibias vss vss sky130_fd_pr__nfet_01v8 L=0.5u W=1u
M6823 o6 ibias vss vss sky130_fd_pr__nfet_01v8 L=0.5u W=1u
M6824 o6 ibias vss vss sky130_fd_pr__nfet_01v8 L=0.5u W=1u
M6825 o6 ibias vss vss sky130_fd_pr__nfet_01v8 L=0.5u W=1u
M6826 o6 ibias vss vss sky130_fd_pr__nfet_01v8 L=0.5u W=1u
M6827 o6 ibias vss vss sky130_fd_pr__nfet_01v8 L=0.5u W=1u
M6828 o6 ibias vss vss sky130_fd_pr__nfet_01v8 L=0.5u W=1u
M6829 o6 ibias vss vss sky130_fd_pr__nfet_01v8 L=0.5u W=1u
M6830 o6 ibias vss vss sky130_fd_pr__nfet_01v8 L=0.5u W=1u
M6831 o6 ibias vss vss sky130_fd_pr__nfet_01v8 L=0.5u W=1u
M6832 o6 ibias vss vss sky130_fd_pr__nfet_01v8 L=0.5u W=1u
M6833 o6 ibias vss vss sky130_fd_pr__nfet_01v8 L=0.5u W=1u
M6834 o6 ibias vss vss sky130_fd_pr__nfet_01v8 L=0.5u W=1u
M6835 o6 ibias vss vss sky130_fd_pr__nfet_01v8 L=0.5u W=1u
M6836 o6 ibias vss vss sky130_fd_pr__nfet_01v8 L=0.5u W=1u
M6837 o6 ibias vss vss sky130_fd_pr__nfet_01v8 L=0.5u W=1u
M6838 o6 ibias vss vss sky130_fd_pr__nfet_01v8 L=0.5u W=1u
M6839 o6 ibias vss vss sky130_fd_pr__nfet_01v8 L=0.5u W=1u
M6840 o6 ibias vss vss sky130_fd_pr__nfet_01v8 L=0.5u W=1u
M6841 o6 ibias vss vss sky130_fd_pr__nfet_01v8 L=0.5u W=1u
M6842 o6 ibias vss vss sky130_fd_pr__nfet_01v8 L=0.5u W=1u
M6843 o6 ibias vss vss sky130_fd_pr__nfet_01v8 L=0.5u W=1u
M6844 o6 ibias vss vss sky130_fd_pr__nfet_01v8 L=0.5u W=1u
M6845 o6 ibias vss vss sky130_fd_pr__nfet_01v8 L=0.5u W=1u
M6846 o6 ibias vss vss sky130_fd_pr__nfet_01v8 L=0.5u W=1u
M6847 o6 ibias vss vss sky130_fd_pr__nfet_01v8 L=0.5u W=1u
M6848 o6 ibias vss vss sky130_fd_pr__nfet_01v8 L=0.5u W=1u
M6849 o6 ibias vss vss sky130_fd_pr__nfet_01v8 L=0.5u W=1u
M6850 o6 ibias vss vss sky130_fd_pr__nfet_01v8 L=0.5u W=1u
M6851 o6 ibias vss vss sky130_fd_pr__nfet_01v8 L=0.5u W=1u
M6852 o6 ibias vss vss sky130_fd_pr__nfet_01v8 L=0.5u W=1u
M6853 o6 ibias vss vss sky130_fd_pr__nfet_01v8 L=0.5u W=1u
M6854 o6 ibias vss vss sky130_fd_pr__nfet_01v8 L=0.5u W=1u
M6855 o6 ibias vss vss sky130_fd_pr__nfet_01v8 L=0.5u W=1u
M6856 o6 ibias vss vss sky130_fd_pr__nfet_01v8 L=0.5u W=1u
M6857 o6 ibias vss vss sky130_fd_pr__nfet_01v8 L=0.5u W=1u
M6858 o6 ibias vss vss sky130_fd_pr__nfet_01v8 L=0.5u W=1u
M6859 o6 ibias vss vss sky130_fd_pr__nfet_01v8 L=0.5u W=1u
M6860 o6 ibias vss vss sky130_fd_pr__nfet_01v8 L=0.5u W=1u
M6861 o6 ibias vss vss sky130_fd_pr__nfet_01v8 L=0.5u W=1u
M6862 o6 ibias vss vss sky130_fd_pr__nfet_01v8 L=0.5u W=1u
M6863 o6 ibias vss vss sky130_fd_pr__nfet_01v8 L=0.5u W=1u
M6864 o6 ibias vss vss sky130_fd_pr__nfet_01v8 L=0.5u W=1u
M6865 o6 ibias vss vss sky130_fd_pr__nfet_01v8 L=0.5u W=1u
M6866 o6 ibias vss vss sky130_fd_pr__nfet_01v8 L=0.5u W=1u
M6867 o6 ibias vss vss sky130_fd_pr__nfet_01v8 L=0.5u W=1u
M6868 o6 ibias vss vss sky130_fd_pr__nfet_01v8 L=0.5u W=1u
M6869 o6 ibias vss vss sky130_fd_pr__nfet_01v8 L=0.5u W=1u
M6870 o6 ibias vss vss sky130_fd_pr__nfet_01v8 L=0.5u W=1u
M6871 o6 ibias vss vss sky130_fd_pr__nfet_01v8 L=0.5u W=1u
M6872 o6 ibias vss vss sky130_fd_pr__nfet_01v8 L=0.5u W=1u
M6873 o6 ibias vss vss sky130_fd_pr__nfet_01v8 L=0.5u W=1u
M6874 o6 ibias vss vss sky130_fd_pr__nfet_01v8 L=0.5u W=1u
M6875 o6 ibias vss vss sky130_fd_pr__nfet_01v8 L=0.5u W=1u
M6876 o6 ibias vss vss sky130_fd_pr__nfet_01v8 L=0.5u W=1u
M6877 o6 ibias vss vss sky130_fd_pr__nfet_01v8 L=0.5u W=1u
M6878 o6 ibias vss vss sky130_fd_pr__nfet_01v8 L=0.5u W=1u
M6879 o6 ibias vss vss sky130_fd_pr__nfet_01v8 L=0.5u W=1u
M6880 o6 ibias vss vss sky130_fd_pr__nfet_01v8 L=0.5u W=1u
M6881 o6 ibias vss vss sky130_fd_pr__nfet_01v8 L=0.5u W=1u
M6882 o6 ibias vss vss sky130_fd_pr__nfet_01v8 L=0.5u W=1u
M6883 o6 ibias vss vss sky130_fd_pr__nfet_01v8 L=0.5u W=1u
M6884 o6 ibias vss vss sky130_fd_pr__nfet_01v8 L=0.5u W=1u
M6885 o6 ibias vss vss sky130_fd_pr__nfet_01v8 L=0.5u W=1u
M6886 o6 ibias vss vss sky130_fd_pr__nfet_01v8 L=0.5u W=1u
M6887 o6 ibias vss vss sky130_fd_pr__nfet_01v8 L=0.5u W=1u
M6888 o6 ibias vss vss sky130_fd_pr__nfet_01v8 L=0.5u W=1u
M6889 o6 ibias vss vss sky130_fd_pr__nfet_01v8 L=0.5u W=1u
M6890 o6 ibias vss vss sky130_fd_pr__nfet_01v8 L=0.5u W=1u
M6891 o6 ibias vss vss sky130_fd_pr__nfet_01v8 L=0.5u W=1u
M6892 o6 ibias vss vss sky130_fd_pr__nfet_01v8 L=0.5u W=1u
M6893 o6 ibias vss vss sky130_fd_pr__nfet_01v8 L=0.5u W=1u
M6894 o6 ibias vss vss sky130_fd_pr__nfet_01v8 L=0.5u W=1u
M6895 o6 ibias vss vss sky130_fd_pr__nfet_01v8 L=0.5u W=1u
M6896 o6 ibias vss vss sky130_fd_pr__nfet_01v8 L=0.5u W=1u
M6897 o6 ibias vss vss sky130_fd_pr__nfet_01v8 L=0.5u W=1u
M6898 o6 ibias vss vss sky130_fd_pr__nfet_01v8 L=0.5u W=1u
M6899 o6 ibias vss vss sky130_fd_pr__nfet_01v8 L=0.5u W=1u
M6900 o6 ibias vss vss sky130_fd_pr__nfet_01v8 L=0.5u W=1u
M6901 o6 ibias vss vss sky130_fd_pr__nfet_01v8 L=0.5u W=1u
M6902 o6 ibias vss vss sky130_fd_pr__nfet_01v8 L=0.5u W=1u
M6903 o6 ibias vss vss sky130_fd_pr__nfet_01v8 L=0.5u W=1u
M6904 o6 ibias vss vss sky130_fd_pr__nfet_01v8 L=0.5u W=1u
M6905 o6 ibias vss vss sky130_fd_pr__nfet_01v8 L=0.5u W=1u
M6906 o6 ibias vss vss sky130_fd_pr__nfet_01v8 L=0.5u W=1u
M6907 o6 ibias vss vss sky130_fd_pr__nfet_01v8 L=0.5u W=1u
M6908 o6 ibias vss vss sky130_fd_pr__nfet_01v8 L=0.5u W=1u
M6909 o6 ibias vss vss sky130_fd_pr__nfet_01v8 L=0.5u W=1u
M6910 o6 ibias vss vss sky130_fd_pr__nfet_01v8 L=0.5u W=1u
M6911 o6 ibias vss vss sky130_fd_pr__nfet_01v8 L=0.5u W=1u
M6912 o6 ibias vss vss sky130_fd_pr__nfet_01v8 L=0.5u W=1u
M6913 o6 ibias vss vss sky130_fd_pr__nfet_01v8 L=0.5u W=1u
M6914 o6 ibias vss vss sky130_fd_pr__nfet_01v8 L=0.5u W=1u
M6915 o6 ibias vss vss sky130_fd_pr__nfet_01v8 L=0.5u W=1u
M6916 o6 ibias vss vss sky130_fd_pr__nfet_01v8 L=0.5u W=1u
M6917 o6 ibias vss vss sky130_fd_pr__nfet_01v8 L=0.5u W=1u
M6918 o6 ibias vss vss sky130_fd_pr__nfet_01v8 L=0.5u W=1u
M6919 o6 ibias vss vss sky130_fd_pr__nfet_01v8 L=0.5u W=1u
M6920 o6 ibias vss vss sky130_fd_pr__nfet_01v8 L=0.5u W=1u
M6921 o6 ibias vss vss sky130_fd_pr__nfet_01v8 L=0.5u W=1u
M6922 o6 ibias vss vss sky130_fd_pr__nfet_01v8 L=0.5u W=1u
M6923 o6 ibias vss vss sky130_fd_pr__nfet_01v8 L=0.5u W=1u
M6924 o6 ibias vss vss sky130_fd_pr__nfet_01v8 L=0.5u W=1u
M6925 o6 ibias vss vss sky130_fd_pr__nfet_01v8 L=0.5u W=1u
M6926 o6 ibias vss vss sky130_fd_pr__nfet_01v8 L=0.5u W=1u
M6927 o6 ibias vss vss sky130_fd_pr__nfet_01v8 L=0.5u W=1u
M6928 o6 ibias vss vss sky130_fd_pr__nfet_01v8 L=0.5u W=1u
M6929 o6 ibias vss vss sky130_fd_pr__nfet_01v8 L=0.5u W=1u
M6930 o6 ibias vss vss sky130_fd_pr__nfet_01v8 L=0.5u W=1u
M6931 o6 ibias vss vss sky130_fd_pr__nfet_01v8 L=0.5u W=1u
M6932 o6 ibias vss vss sky130_fd_pr__nfet_01v8 L=0.5u W=1u
M6933 o6 ibias vss vss sky130_fd_pr__nfet_01v8 L=0.5u W=1u
M6934 o6 ibias vss vss sky130_fd_pr__nfet_01v8 L=0.5u W=1u
M6935 o6 ibias vss vss sky130_fd_pr__nfet_01v8 L=0.5u W=1u
M6936 o6 ibias vss vss sky130_fd_pr__nfet_01v8 L=0.5u W=1u
M6937 o6 ibias vss vss sky130_fd_pr__nfet_01v8 L=0.5u W=1u
M6938 o6 ibias vss vss sky130_fd_pr__nfet_01v8 L=0.5u W=1u
M6939 o6 ibias vss vss sky130_fd_pr__nfet_01v8 L=0.5u W=1u
M6940 o6 ibias vss vss sky130_fd_pr__nfet_01v8 L=0.5u W=1u
M6941 o6 ibias vss vss sky130_fd_pr__nfet_01v8 L=0.5u W=1u
M6942 o6 ibias vss vss sky130_fd_pr__nfet_01v8 L=0.5u W=1u
M6943 o6 ibias vss vss sky130_fd_pr__nfet_01v8 L=0.5u W=1u
M6944 o6 ibias vss vss sky130_fd_pr__nfet_01v8 L=0.5u W=1u
M6945 o6 ibias vss vss sky130_fd_pr__nfet_01v8 L=0.5u W=1u
M6946 o6 ibias vss vss sky130_fd_pr__nfet_01v8 L=0.5u W=1u
M6947 o6 ibias vss vss sky130_fd_pr__nfet_01v8 L=0.5u W=1u
M6948 o6 ibias vss vss sky130_fd_pr__nfet_01v8 L=0.5u W=1u
M6949 o6 ibias vss vss sky130_fd_pr__nfet_01v8 L=0.5u W=1u
M6950 o6 ibias vss vss sky130_fd_pr__nfet_01v8 L=0.5u W=1u
M6951 o6 ibias vss vss sky130_fd_pr__nfet_01v8 L=0.5u W=1u
M6952 o6 ibias vss vss sky130_fd_pr__nfet_01v8 L=0.5u W=1u
M6953 o6 ibias vss vss sky130_fd_pr__nfet_01v8 L=0.5u W=1u
M6954 o6 ibias vss vss sky130_fd_pr__nfet_01v8 L=0.5u W=1u
M6955 o6 ibias vss vss sky130_fd_pr__nfet_01v8 L=0.5u W=1u
M6956 o6 ibias vss vss sky130_fd_pr__nfet_01v8 L=0.5u W=1u
M6957 o6 ibias vss vss sky130_fd_pr__nfet_01v8 L=0.5u W=1u
M6958 o6 ibias vss vss sky130_fd_pr__nfet_01v8 L=0.5u W=1u
M6959 o6 ibias vss vss sky130_fd_pr__nfet_01v8 L=0.5u W=1u
M6960 o6 ibias vss vss sky130_fd_pr__nfet_01v8 L=0.5u W=1u
M6961 o6 ibias vss vss sky130_fd_pr__nfet_01v8 L=0.5u W=1u
M6962 o6 ibias vss vss sky130_fd_pr__nfet_01v8 L=0.5u W=1u
M6963 o6 ibias vss vss sky130_fd_pr__nfet_01v8 L=0.5u W=1u
M6964 o6 ibias vss vss sky130_fd_pr__nfet_01v8 L=0.5u W=1u
M6965 o6 ibias vss vss sky130_fd_pr__nfet_01v8 L=0.5u W=1u
M6966 o6 ibias vss vss sky130_fd_pr__nfet_01v8 L=0.5u W=1u
M6967 o6 ibias vss vss sky130_fd_pr__nfet_01v8 L=0.5u W=1u
M6968 o6 ibias vss vss sky130_fd_pr__nfet_01v8 L=0.5u W=1u
M6969 o6 ibias vss vss sky130_fd_pr__nfet_01v8 L=0.5u W=1u
M6970 o6 ibias vss vss sky130_fd_pr__nfet_01v8 L=0.5u W=1u
M6971 o6 ibias vss vss sky130_fd_pr__nfet_01v8 L=0.5u W=1u
M6972 o6 ibias vss vss sky130_fd_pr__nfet_01v8 L=0.5u W=1u
M6973 o6 ibias vss vss sky130_fd_pr__nfet_01v8 L=0.5u W=1u
M6974 o6 ibias vss vss sky130_fd_pr__nfet_01v8 L=0.5u W=1u
M6975 o6 ibias vss vss sky130_fd_pr__nfet_01v8 L=0.5u W=1u
M6976 o6 ibias vss vss sky130_fd_pr__nfet_01v8 L=0.5u W=1u
M6977 o6 ibias vss vss sky130_fd_pr__nfet_01v8 L=0.5u W=1u
M6978 o6 ibias vss vss sky130_fd_pr__nfet_01v8 L=0.5u W=1u
M6979 o6 ibias vss vss sky130_fd_pr__nfet_01v8 L=0.5u W=1u
M6980 o6 ibias vss vss sky130_fd_pr__nfet_01v8 L=0.5u W=1u
M6981 o6 ibias vss vss sky130_fd_pr__nfet_01v8 L=0.5u W=1u
M6982 o6 ibias vss vss sky130_fd_pr__nfet_01v8 L=0.5u W=1u
M6983 o6 ibias vss vss sky130_fd_pr__nfet_01v8 L=0.5u W=1u
M6984 o6 ibias vss vss sky130_fd_pr__nfet_01v8 L=0.5u W=1u
M6985 o6 ibias vss vss sky130_fd_pr__nfet_01v8 L=0.5u W=1u
M6986 o6 ibias vss vss sky130_fd_pr__nfet_01v8 L=0.5u W=1u
M6987 o6 ibias vss vss sky130_fd_pr__nfet_01v8 L=0.5u W=1u
M6988 o6 ibias vss vss sky130_fd_pr__nfet_01v8 L=0.5u W=1u
M6989 o6 ibias vss vss sky130_fd_pr__nfet_01v8 L=0.5u W=1u
M6990 o6 ibias vss vss sky130_fd_pr__nfet_01v8 L=0.5u W=1u
M6991 o6 ibias vss vss sky130_fd_pr__nfet_01v8 L=0.5u W=1u
M6992 o6 ibias vss vss sky130_fd_pr__nfet_01v8 L=0.5u W=1u
M6993 o6 ibias vss vss sky130_fd_pr__nfet_01v8 L=0.5u W=1u
M6994 o6 ibias vss vss sky130_fd_pr__nfet_01v8 L=0.5u W=1u
M6995 o6 ibias vss vss sky130_fd_pr__nfet_01v8 L=0.5u W=1u
M6996 o6 ibias vss vss sky130_fd_pr__nfet_01v8 L=0.5u W=1u
M6997 o6 ibias vss vss sky130_fd_pr__nfet_01v8 L=0.5u W=1u
M6998 o6 ibias vss vss sky130_fd_pr__nfet_01v8 L=0.5u W=1u
M6999 o6 ibias vss vss sky130_fd_pr__nfet_01v8 L=0.5u W=1u
M7000 o6 ibias vss vss sky130_fd_pr__nfet_01v8 L=0.5u W=1u
M7001 o6 ibias vss vss sky130_fd_pr__nfet_01v8 L=0.5u W=1u
M7002 o6 ibias vss vss sky130_fd_pr__nfet_01v8 L=0.5u W=1u
M7003 o6 ibias vss vss sky130_fd_pr__nfet_01v8 L=0.5u W=1u
M7004 o6 ibias vss vss sky130_fd_pr__nfet_01v8 L=0.5u W=1u
M7005 o6 ibias vss vss sky130_fd_pr__nfet_01v8 L=0.5u W=1u
M7006 o6 ibias vss vss sky130_fd_pr__nfet_01v8 L=0.5u W=1u
M7007 o6 ibias vss vss sky130_fd_pr__nfet_01v8 L=0.5u W=1u
M7008 o6 ibias vss vss sky130_fd_pr__nfet_01v8 L=0.5u W=1u
M7009 o6 ibias vss vss sky130_fd_pr__nfet_01v8 L=0.5u W=1u
M7010 o6 ibias vss vss sky130_fd_pr__nfet_01v8 L=0.5u W=1u
M7011 o6 ibias vss vss sky130_fd_pr__nfet_01v8 L=0.5u W=1u
M7012 o6 ibias vss vss sky130_fd_pr__nfet_01v8 L=0.5u W=1u
M7013 o6 ibias vss vss sky130_fd_pr__nfet_01v8 L=0.5u W=1u
M7014 o6 ibias vss vss sky130_fd_pr__nfet_01v8 L=0.5u W=1u
M7015 o6 ibias vss vss sky130_fd_pr__nfet_01v8 L=0.5u W=1u
M7016 o6 ibias vss vss sky130_fd_pr__nfet_01v8 L=0.5u W=1u
M7017 o6 ibias vss vss sky130_fd_pr__nfet_01v8 L=0.5u W=1u
M7018 o6 ibias vss vss sky130_fd_pr__nfet_01v8 L=0.5u W=1u
M7019 o6 ibias vss vss sky130_fd_pr__nfet_01v8 L=0.5u W=1u
M7020 o6 ibias vss vss sky130_fd_pr__nfet_01v8 L=0.5u W=1u
M7021 o6 ibias vss vss sky130_fd_pr__nfet_01v8 L=0.5u W=1u
M7022 o6 ibias vss vss sky130_fd_pr__nfet_01v8 L=0.5u W=1u
M7023 o6 ibias vss vss sky130_fd_pr__nfet_01v8 L=0.5u W=1u
M7024 o6 ibias vss vss sky130_fd_pr__nfet_01v8 L=0.5u W=1u
M7025 o6 ibias vss vss sky130_fd_pr__nfet_01v8 L=0.5u W=1u
M7026 o6 ibias vss vss sky130_fd_pr__nfet_01v8 L=0.5u W=1u
M7027 o6 ibias vss vss sky130_fd_pr__nfet_01v8 L=0.5u W=1u
M7028 o6 ibias vss vss sky130_fd_pr__nfet_01v8 L=0.5u W=1u
M7029 o6 ibias vss vss sky130_fd_pr__nfet_01v8 L=0.5u W=1u
M7030 o6 ibias vss vss sky130_fd_pr__nfet_01v8 L=0.5u W=1u
M7031 o6 ibias vss vss sky130_fd_pr__nfet_01v8 L=0.5u W=1u
M7032 o6 ibias vss vss sky130_fd_pr__nfet_01v8 L=0.5u W=1u
M7033 o6 ibias vss vss sky130_fd_pr__nfet_01v8 L=0.5u W=1u
M7034 o6 ibias vss vss sky130_fd_pr__nfet_01v8 L=0.5u W=1u
M7035 o6 ibias vss vss sky130_fd_pr__nfet_01v8 L=0.5u W=1u
M7036 o6 ibias vss vss sky130_fd_pr__nfet_01v8 L=0.5u W=1u
M7037 o6 ibias vss vss sky130_fd_pr__nfet_01v8 L=0.5u W=1u
M7038 o6 ibias vss vss sky130_fd_pr__nfet_01v8 L=0.5u W=1u
M7039 o6 ibias vss vss sky130_fd_pr__nfet_01v8 L=0.5u W=1u
M7040 o6 ibias vss vss sky130_fd_pr__nfet_01v8 L=0.5u W=1u
M7041 o6 ibias vss vss sky130_fd_pr__nfet_01v8 L=0.5u W=1u
M7042 o6 ibias vss vss sky130_fd_pr__nfet_01v8 L=0.5u W=1u
M7043 o6 ibias vss vss sky130_fd_pr__nfet_01v8 L=0.5u W=1u
M7044 o6 ibias vss vss sky130_fd_pr__nfet_01v8 L=0.5u W=1u
M7045 o6 ibias vss vss sky130_fd_pr__nfet_01v8 L=0.5u W=1u
M7046 o6 ibias vss vss sky130_fd_pr__nfet_01v8 L=0.5u W=1u
M7047 o6 ibias vss vss sky130_fd_pr__nfet_01v8 L=0.5u W=1u
M7048 o6 ibias vss vss sky130_fd_pr__nfet_01v8 L=0.5u W=1u
M7049 o6 ibias vss vss sky130_fd_pr__nfet_01v8 L=0.5u W=1u
M7050 o6 ibias vss vss sky130_fd_pr__nfet_01v8 L=0.5u W=1u
M7051 o6 ibias vss vss sky130_fd_pr__nfet_01v8 L=0.5u W=1u
M7052 o6 ibias vss vss sky130_fd_pr__nfet_01v8 L=0.5u W=1u
M7053 o6 ibias vss vss sky130_fd_pr__nfet_01v8 L=0.5u W=1u
M7054 o6 ibias vss vss sky130_fd_pr__nfet_01v8 L=0.5u W=1u
M7055 o6 ibias vss vss sky130_fd_pr__nfet_01v8 L=0.5u W=1u
M7056 o6 ibias vss vss sky130_fd_pr__nfet_01v8 L=0.5u W=1u
M7057 o6 ibias vss vss sky130_fd_pr__nfet_01v8 L=0.5u W=1u
M7058 o6 ibias vss vss sky130_fd_pr__nfet_01v8 L=0.5u W=1u
M7059 o6 ibias vss vss sky130_fd_pr__nfet_01v8 L=0.5u W=1u
M7060 o6 ibias vss vss sky130_fd_pr__nfet_01v8 L=0.5u W=1u
M7061 o6 ibias vss vss sky130_fd_pr__nfet_01v8 L=0.5u W=1u
M7062 o6 ibias vss vss sky130_fd_pr__nfet_01v8 L=0.5u W=1u
M7063 o6 ibias vss vss sky130_fd_pr__nfet_01v8 L=0.5u W=1u
M7064 o6 ibias vss vss sky130_fd_pr__nfet_01v8 L=0.5u W=1u
M7065 o6 ibias vss vss sky130_fd_pr__nfet_01v8 L=0.5u W=1u
M7066 o6 ibias vss vss sky130_fd_pr__nfet_01v8 L=0.5u W=1u
M7067 o6 ibias vss vss sky130_fd_pr__nfet_01v8 L=0.5u W=1u
M7068 o6 ibias vss vss sky130_fd_pr__nfet_01v8 L=0.5u W=1u
M7069 o6 ibias vss vss sky130_fd_pr__nfet_01v8 L=0.5u W=1u
M7070 o6 ibias vss vss sky130_fd_pr__nfet_01v8 L=0.5u W=1u
M7071 o6 ibias vss vss sky130_fd_pr__nfet_01v8 L=0.5u W=1u
M7072 o6 ibias vss vss sky130_fd_pr__nfet_01v8 L=0.5u W=1u
M7073 o6 ibias vss vss sky130_fd_pr__nfet_01v8 L=0.5u W=1u
M7074 o6 ibias vss vss sky130_fd_pr__nfet_01v8 L=0.5u W=1u
M7075 o6 ibias vss vss sky130_fd_pr__nfet_01v8 L=0.5u W=1u
M7076 o6 ibias vss vss sky130_fd_pr__nfet_01v8 L=0.5u W=1u
M7077 o6 ibias vss vss sky130_fd_pr__nfet_01v8 L=0.5u W=1u
M7078 o6 ibias vss vss sky130_fd_pr__nfet_01v8 L=0.5u W=1u
M7079 o6 ibias vss vss sky130_fd_pr__nfet_01v8 L=0.5u W=1u
M7080 o6 ibias vss vss sky130_fd_pr__nfet_01v8 L=0.5u W=1u
M7081 o6 ibias vss vss sky130_fd_pr__nfet_01v8 L=0.5u W=1u
M7082 o6 ibias vss vss sky130_fd_pr__nfet_01v8 L=0.5u W=1u
M7083 o6 ibias vss vss sky130_fd_pr__nfet_01v8 L=0.5u W=1u
M7084 o6 ibias vss vss sky130_fd_pr__nfet_01v8 L=0.5u W=1u
M7085 o6 ibias vss vss sky130_fd_pr__nfet_01v8 L=0.5u W=1u
M7086 o6 ibias vss vss sky130_fd_pr__nfet_01v8 L=0.5u W=1u
M7087 o6 ibias vss vss sky130_fd_pr__nfet_01v8 L=0.5u W=1u
M7088 o6 ibias vss vss sky130_fd_pr__nfet_01v8 L=0.5u W=1u
M7089 o6 ibias vss vss sky130_fd_pr__nfet_01v8 L=0.5u W=1u
M7090 o6 ibias vss vss sky130_fd_pr__nfet_01v8 L=0.5u W=1u
M7091 o6 ibias vss vss sky130_fd_pr__nfet_01v8 L=0.5u W=1u
M7092 o6 ibias vss vss sky130_fd_pr__nfet_01v8 L=0.5u W=1u
M7093 o6 ibias vss vss sky130_fd_pr__nfet_01v8 L=0.5u W=1u
M7094 o6 ibias vss vss sky130_fd_pr__nfet_01v8 L=0.5u W=1u
M7095 o6 ibias vss vss sky130_fd_pr__nfet_01v8 L=0.5u W=1u
M7096 o6 ibias vss vss sky130_fd_pr__nfet_01v8 L=0.5u W=1u
M7097 o6 ibias vss vss sky130_fd_pr__nfet_01v8 L=0.5u W=1u
M7098 o6 ibias vss vss sky130_fd_pr__nfet_01v8 L=0.5u W=1u
M7099 o6 ibias vss vss sky130_fd_pr__nfet_01v8 L=0.5u W=1u
M7100 o6 ibias vss vss sky130_fd_pr__nfet_01v8 L=0.5u W=1u
M7101 o6 ibias vss vss sky130_fd_pr__nfet_01v8 L=0.5u W=1u
M7102 o6 ibias vss vss sky130_fd_pr__nfet_01v8 L=0.5u W=1u
M7103 o6 ibias vss vss sky130_fd_pr__nfet_01v8 L=0.5u W=1u
M7104 o6 ibias vss vss sky130_fd_pr__nfet_01v8 L=0.5u W=1u
M7105 o6 ibias vss vss sky130_fd_pr__nfet_01v8 L=0.5u W=1u
M7106 o6 ibias vss vss sky130_fd_pr__nfet_01v8 L=0.5u W=1u
M7107 o6 ibias vss vss sky130_fd_pr__nfet_01v8 L=0.5u W=1u
M7108 o6 ibias vss vss sky130_fd_pr__nfet_01v8 L=0.5u W=1u
M7109 o6 ibias vss vss sky130_fd_pr__nfet_01v8 L=0.5u W=1u
M7110 o6 ibias vss vss sky130_fd_pr__nfet_01v8 L=0.5u W=1u
M7111 o6 ibias vss vss sky130_fd_pr__nfet_01v8 L=0.5u W=1u
M7112 o6 ibias vss vss sky130_fd_pr__nfet_01v8 L=0.5u W=1u
M7113 o6 ibias vss vss sky130_fd_pr__nfet_01v8 L=0.5u W=1u
M7114 o6 ibias vss vss sky130_fd_pr__nfet_01v8 L=0.5u W=1u
M7115 o6 ibias vss vss sky130_fd_pr__nfet_01v8 L=0.5u W=1u
M7116 o6 ibias vss vss sky130_fd_pr__nfet_01v8 L=0.5u W=1u
M7117 o6 ibias vss vss sky130_fd_pr__nfet_01v8 L=0.5u W=1u
M7118 o6 ibias vss vss sky130_fd_pr__nfet_01v8 L=0.5u W=1u
M7119 o6 ibias vss vss sky130_fd_pr__nfet_01v8 L=0.5u W=1u
M7120 o6 ibias vss vss sky130_fd_pr__nfet_01v8 L=0.5u W=1u
M7121 o6 ibias vss vss sky130_fd_pr__nfet_01v8 L=0.5u W=1u
M7122 o6 ibias vss vss sky130_fd_pr__nfet_01v8 L=0.5u W=1u
M7123 o6 ibias vss vss sky130_fd_pr__nfet_01v8 L=0.5u W=1u
M7124 o6 ibias vss vss sky130_fd_pr__nfet_01v8 L=0.5u W=1u
M7125 o6 ibias vss vss sky130_fd_pr__nfet_01v8 L=0.5u W=1u
M7126 o6 ibias vss vss sky130_fd_pr__nfet_01v8 L=0.5u W=1u
M7127 o6 ibias vss vss sky130_fd_pr__nfet_01v8 L=0.5u W=1u
M7128 o6 ibias vss vss sky130_fd_pr__nfet_01v8 L=0.5u W=1u
M7129 o6 ibias vss vss sky130_fd_pr__nfet_01v8 L=0.5u W=1u
M7130 o6 ibias vss vss sky130_fd_pr__nfet_01v8 L=0.5u W=1u
M7131 o6 ibias vss vss sky130_fd_pr__nfet_01v8 L=0.5u W=1u
M7132 o6 ibias vss vss sky130_fd_pr__nfet_01v8 L=0.5u W=1u
M7133 o6 ibias vss vss sky130_fd_pr__nfet_01v8 L=0.5u W=1u
M7134 o6 ibias vss vss sky130_fd_pr__nfet_01v8 L=0.5u W=1u
M7135 o6 ibias vss vss sky130_fd_pr__nfet_01v8 L=0.5u W=1u
M7136 o6 ibias vss vss sky130_fd_pr__nfet_01v8 L=0.5u W=1u
M7137 o6 ibias vss vss sky130_fd_pr__nfet_01v8 L=0.5u W=1u
M7138 o6 ibias vss vss sky130_fd_pr__nfet_01v8 L=0.5u W=1u
M7139 o6 ibias vss vss sky130_fd_pr__nfet_01v8 L=0.5u W=1u
M7140 o6 ibias vss vss sky130_fd_pr__nfet_01v8 L=0.5u W=1u
M7141 o6 ibias vss vss sky130_fd_pr__nfet_01v8 L=0.5u W=1u
M7142 o6 ibias vss vss sky130_fd_pr__nfet_01v8 L=0.5u W=1u
M7143 o6 ibias vss vss sky130_fd_pr__nfet_01v8 L=0.5u W=1u
M7144 o6 ibias vss vss sky130_fd_pr__nfet_01v8 L=0.5u W=1u
M7145 o6 ibias vss vss sky130_fd_pr__nfet_01v8 L=0.5u W=1u
M7146 o6 ibias vss vss sky130_fd_pr__nfet_01v8 L=0.5u W=1u
M7147 o6 ibias vss vss sky130_fd_pr__nfet_01v8 L=0.5u W=1u
M7148 o6 ibias vss vss sky130_fd_pr__nfet_01v8 L=0.5u W=1u
M7149 o6 ibias vss vss sky130_fd_pr__nfet_01v8 L=0.5u W=1u
M7150 o6 ibias vss vss sky130_fd_pr__nfet_01v8 L=0.5u W=1u
M7151 o6 ibias vss vss sky130_fd_pr__nfet_01v8 L=0.5u W=1u
M7152 o6 ibias vss vss sky130_fd_pr__nfet_01v8 L=0.5u W=1u
M7153 o6 ibias vss vss sky130_fd_pr__nfet_01v8 L=0.5u W=1u
M7154 o6 ibias vss vss sky130_fd_pr__nfet_01v8 L=0.5u W=1u
M7155 o6 ibias vss vss sky130_fd_pr__nfet_01v8 L=0.5u W=1u
M7156 o6 ibias vss vss sky130_fd_pr__nfet_01v8 L=0.5u W=1u
M7157 o6 ibias vss vss sky130_fd_pr__nfet_01v8 L=0.5u W=1u
M7158 o6 ibias vss vss sky130_fd_pr__nfet_01v8 L=0.5u W=1u
M7159 o6 ibias vss vss sky130_fd_pr__nfet_01v8 L=0.5u W=1u
M7160 o6 ibias vss vss sky130_fd_pr__nfet_01v8 L=0.5u W=1u
M7161 o6 ibias vss vss sky130_fd_pr__nfet_01v8 L=0.5u W=1u
M7162 o6 ibias vss vss sky130_fd_pr__nfet_01v8 L=0.5u W=1u
M7163 o6 ibias vss vss sky130_fd_pr__nfet_01v8 L=0.5u W=1u
M7164 o6 ibias vss vss sky130_fd_pr__nfet_01v8 L=0.5u W=1u
M7165 o6 ibias vss vss sky130_fd_pr__nfet_01v8 L=0.5u W=1u
M7166 o6 ibias vss vss sky130_fd_pr__nfet_01v8 L=0.5u W=1u
M7167 o6 ibias vss vss sky130_fd_pr__nfet_01v8 L=0.5u W=1u
M7168 o6 ibias vss vss sky130_fd_pr__nfet_01v8 L=0.5u W=1u
M7169 o6 ibias vss vss sky130_fd_pr__nfet_01v8 L=0.5u W=1u
M7170 o6 ibias vss vss sky130_fd_pr__nfet_01v8 L=0.5u W=1u
M7171 o6 ibias vss vss sky130_fd_pr__nfet_01v8 L=0.5u W=1u
M7172 o6 ibias vss vss sky130_fd_pr__nfet_01v8 L=0.5u W=1u
M7173 o6 ibias vss vss sky130_fd_pr__nfet_01v8 L=0.5u W=1u
M7174 o6 ibias vss vss sky130_fd_pr__nfet_01v8 L=0.5u W=1u
M7175 o6 ibias vss vss sky130_fd_pr__nfet_01v8 L=0.5u W=1u
M7176 o6 ibias vss vss sky130_fd_pr__nfet_01v8 L=0.5u W=1u
M7177 o6 ibias vss vss sky130_fd_pr__nfet_01v8 L=0.5u W=1u
M7178 o6 ibias vss vss sky130_fd_pr__nfet_01v8 L=0.5u W=1u
M7179 o6 ibias vss vss sky130_fd_pr__nfet_01v8 L=0.5u W=1u
M7180 o6 ibias vss vss sky130_fd_pr__nfet_01v8 L=0.5u W=1u
M7181 o6 ibias vss vss sky130_fd_pr__nfet_01v8 L=0.5u W=1u
M7182 o6 ibias vss vss sky130_fd_pr__nfet_01v8 L=0.5u W=1u
M7183 o6 ibias vss vss sky130_fd_pr__nfet_01v8 L=0.5u W=1u
M7184 o6 ibias vss vss sky130_fd_pr__nfet_01v8 L=0.5u W=1u
M7185 o6 ibias vss vss sky130_fd_pr__nfet_01v8 L=0.5u W=1u
M7186 o6 ibias vss vss sky130_fd_pr__nfet_01v8 L=0.5u W=1u
M7187 o6 ibias vss vss sky130_fd_pr__nfet_01v8 L=0.5u W=1u
M7188 o6 ibias vss vss sky130_fd_pr__nfet_01v8 L=0.5u W=1u
M7189 o6 ibias vss vss sky130_fd_pr__nfet_01v8 L=0.5u W=1u
M7190 o6 ibias vss vss sky130_fd_pr__nfet_01v8 L=0.5u W=1u
M7191 o6 ibias vss vss sky130_fd_pr__nfet_01v8 L=0.5u W=1u
M7192 o6 ibias vss vss sky130_fd_pr__nfet_01v8 L=0.5u W=1u
M7193 o6 ibias vss vss sky130_fd_pr__nfet_01v8 L=0.5u W=1u
M7194 o6 ibias vss vss sky130_fd_pr__nfet_01v8 L=0.5u W=1u
M7195 o6 ibias vss vss sky130_fd_pr__nfet_01v8 L=0.5u W=1u
M7196 o6 ibias vss vss sky130_fd_pr__nfet_01v8 L=0.5u W=1u
M7197 o6 ibias vss vss sky130_fd_pr__nfet_01v8 L=0.5u W=1u
M7198 o6 ibias vss vss sky130_fd_pr__nfet_01v8 L=0.5u W=1u
M7199 o6 ibias vss vss sky130_fd_pr__nfet_01v8 L=0.5u W=1u
M7200 o6 ibias vss vss sky130_fd_pr__nfet_01v8 L=0.5u W=1u
M7201 o6 ibias vss vss sky130_fd_pr__nfet_01v8 L=0.5u W=1u
M7202 o6 ibias vss vss sky130_fd_pr__nfet_01v8 L=0.5u W=1u
M7203 o6 ibias vss vss sky130_fd_pr__nfet_01v8 L=0.5u W=1u
M7204 o6 ibias vss vss sky130_fd_pr__nfet_01v8 L=0.5u W=1u
M7205 o6 ibias vss vss sky130_fd_pr__nfet_01v8 L=0.5u W=1u
M7206 o6 ibias vss vss sky130_fd_pr__nfet_01v8 L=0.5u W=1u
M7207 o6 ibias vss vss sky130_fd_pr__nfet_01v8 L=0.5u W=1u
M7208 o6 ibias vss vss sky130_fd_pr__nfet_01v8 L=0.5u W=1u
M7209 o6 ibias vss vss sky130_fd_pr__nfet_01v8 L=0.5u W=1u
M7210 o6 ibias vss vss sky130_fd_pr__nfet_01v8 L=0.5u W=1u
M7211 o6 ibias vss vss sky130_fd_pr__nfet_01v8 L=0.5u W=1u
M7212 o6 ibias vss vss sky130_fd_pr__nfet_01v8 L=0.5u W=1u
M7213 o6 ibias vss vss sky130_fd_pr__nfet_01v8 L=0.5u W=1u
M7214 o6 ibias vss vss sky130_fd_pr__nfet_01v8 L=0.5u W=1u
M7215 o6 ibias vss vss sky130_fd_pr__nfet_01v8 L=0.5u W=1u
M7216 o6 ibias vss vss sky130_fd_pr__nfet_01v8 L=0.5u W=1u
M7217 o6 ibias vss vss sky130_fd_pr__nfet_01v8 L=0.5u W=1u
M7218 o6 ibias vss vss sky130_fd_pr__nfet_01v8 L=0.5u W=1u
M7219 o6 ibias vss vss sky130_fd_pr__nfet_01v8 L=0.5u W=1u
M7220 o6 ibias vss vss sky130_fd_pr__nfet_01v8 L=0.5u W=1u
M7221 o6 ibias vss vss sky130_fd_pr__nfet_01v8 L=0.5u W=1u
M7222 o6 ibias vss vss sky130_fd_pr__nfet_01v8 L=0.5u W=1u
M7223 o6 ibias vss vss sky130_fd_pr__nfet_01v8 L=0.5u W=1u
M7224 o6 ibias vss vss sky130_fd_pr__nfet_01v8 L=0.5u W=1u
M7225 o6 ibias vss vss sky130_fd_pr__nfet_01v8 L=0.5u W=1u
M7226 o6 ibias vss vss sky130_fd_pr__nfet_01v8 L=0.5u W=1u
M7227 o6 ibias vss vss sky130_fd_pr__nfet_01v8 L=0.5u W=1u
M7228 o6 ibias vss vss sky130_fd_pr__nfet_01v8 L=0.5u W=1u
M7229 o6 ibias vss vss sky130_fd_pr__nfet_01v8 L=0.5u W=1u
M7230 o6 ibias vss vss sky130_fd_pr__nfet_01v8 L=0.5u W=1u
M7231 o6 ibias vss vss sky130_fd_pr__nfet_01v8 L=0.5u W=1u
M7232 o6 ibias vss vss sky130_fd_pr__nfet_01v8 L=0.5u W=1u
M7233 o6 ibias vss vss sky130_fd_pr__nfet_01v8 L=0.5u W=1u
M7234 o6 ibias vss vss sky130_fd_pr__nfet_01v8 L=0.5u W=1u
M7235 o6 ibias vss vss sky130_fd_pr__nfet_01v8 L=0.5u W=1u
M7236 o6 ibias vss vss sky130_fd_pr__nfet_01v8 L=0.5u W=1u
M7237 o6 ibias vss vss sky130_fd_pr__nfet_01v8 L=0.5u W=1u
M7238 o6 ibias vss vss sky130_fd_pr__nfet_01v8 L=0.5u W=1u
M7239 o6 ibias vss vss sky130_fd_pr__nfet_01v8 L=0.5u W=1u
M7240 o6 ibias vss vss sky130_fd_pr__nfet_01v8 L=0.5u W=1u
M7241 o6 ibias vss vss sky130_fd_pr__nfet_01v8 L=0.5u W=1u
M7242 o6 ibias vss vss sky130_fd_pr__nfet_01v8 L=0.5u W=1u
M7243 o6 ibias vss vss sky130_fd_pr__nfet_01v8 L=0.5u W=1u
M7244 o6 ibias vss vss sky130_fd_pr__nfet_01v8 L=0.5u W=1u
M7245 o6 ibias vss vss sky130_fd_pr__nfet_01v8 L=0.5u W=1u
M7246 o6 ibias vss vss sky130_fd_pr__nfet_01v8 L=0.5u W=1u
M7247 o6 ibias vss vss sky130_fd_pr__nfet_01v8 L=0.5u W=1u
M7248 o6 ibias vss vss sky130_fd_pr__nfet_01v8 L=0.5u W=1u
M7249 o6 ibias vss vss sky130_fd_pr__nfet_01v8 L=0.5u W=1u
M7250 o6 ibias vss vss sky130_fd_pr__nfet_01v8 L=0.5u W=1u
M7251 o6 ibias vss vss sky130_fd_pr__nfet_01v8 L=0.5u W=1u
M7252 o6 ibias vss vss sky130_fd_pr__nfet_01v8 L=0.5u W=1u
M7253 o6 ibias vss vss sky130_fd_pr__nfet_01v8 L=0.5u W=1u
M7254 o6 ibias vss vss sky130_fd_pr__nfet_01v8 L=0.5u W=1u
M7255 o6 ibias vss vss sky130_fd_pr__nfet_01v8 L=0.5u W=1u
M7256 o6 ibias vss vss sky130_fd_pr__nfet_01v8 L=0.5u W=1u
M7257 o6 ibias vss vss sky130_fd_pr__nfet_01v8 L=0.5u W=1u
M7258 o6 ibias vss vss sky130_fd_pr__nfet_01v8 L=0.5u W=1u
M7259 o6 ibias vss vss sky130_fd_pr__nfet_01v8 L=0.5u W=1u
M7260 o6 ibias vss vss sky130_fd_pr__nfet_01v8 L=0.5u W=1u
M7261 o6 ibias vss vss sky130_fd_pr__nfet_01v8 L=0.5u W=1u
M7262 o6 ibias vss vss sky130_fd_pr__nfet_01v8 L=0.5u W=1u
M7263 o6 ibias vss vss sky130_fd_pr__nfet_01v8 L=0.5u W=1u
M7264 o6 ibias vss vss sky130_fd_pr__nfet_01v8 L=0.5u W=1u
M7265 o6 ibias vss vss sky130_fd_pr__nfet_01v8 L=0.5u W=1u
M7266 o6 ibias vss vss sky130_fd_pr__nfet_01v8 L=0.5u W=1u
M7267 o6 ibias vss vss sky130_fd_pr__nfet_01v8 L=0.5u W=1u
M7268 o6 ibias vss vss sky130_fd_pr__nfet_01v8 L=0.5u W=1u
M7269 o6 ibias vss vss sky130_fd_pr__nfet_01v8 L=0.5u W=1u
M7270 o6 ibias vss vss sky130_fd_pr__nfet_01v8 L=0.5u W=1u
M7271 o6 ibias vss vss sky130_fd_pr__nfet_01v8 L=0.5u W=1u
M7272 o6 ibias vss vss sky130_fd_pr__nfet_01v8 L=0.5u W=1u
M7273 o6 ibias vss vss sky130_fd_pr__nfet_01v8 L=0.5u W=1u
M7274 o6 ibias vss vss sky130_fd_pr__nfet_01v8 L=0.5u W=1u
M7275 o6 ibias vss vss sky130_fd_pr__nfet_01v8 L=0.5u W=1u
M7276 o6 ibias vss vss sky130_fd_pr__nfet_01v8 L=0.5u W=1u
M7277 o6 ibias vss vss sky130_fd_pr__nfet_01v8 L=0.5u W=1u
M7278 o6 ibias vss vss sky130_fd_pr__nfet_01v8 L=0.5u W=1u
M7279 o6 ibias vss vss sky130_fd_pr__nfet_01v8 L=0.5u W=1u
M7280 o6 ibias vss vss sky130_fd_pr__nfet_01v8 L=0.5u W=1u
M7281 o6 ibias vss vss sky130_fd_pr__nfet_01v8 L=0.5u W=1u
M7282 o6 ibias vss vss sky130_fd_pr__nfet_01v8 L=0.5u W=1u
M7283 o6 ibias vss vss sky130_fd_pr__nfet_01v8 L=0.5u W=1u
M7284 o6 ibias vss vss sky130_fd_pr__nfet_01v8 L=0.5u W=1u
M7285 o6 ibias vss vss sky130_fd_pr__nfet_01v8 L=0.5u W=1u
M7286 o6 ibias vss vss sky130_fd_pr__nfet_01v8 L=0.5u W=1u
M7287 o6 ibias vss vss sky130_fd_pr__nfet_01v8 L=0.5u W=1u
M7288 o6 ibias vss vss sky130_fd_pr__nfet_01v8 L=0.5u W=1u
M7289 o6 ibias vss vss sky130_fd_pr__nfet_01v8 L=0.5u W=1u
M7290 o6 ibias vss vss sky130_fd_pr__nfet_01v8 L=0.5u W=1u
M7291 o6 ibias vss vss sky130_fd_pr__nfet_01v8 L=0.5u W=1u
M7292 o6 ibias vss vss sky130_fd_pr__nfet_01v8 L=0.5u W=1u
M7293 o6 ibias vss vss sky130_fd_pr__nfet_01v8 L=0.5u W=1u
M7294 o6 ibias vss vss sky130_fd_pr__nfet_01v8 L=0.5u W=1u
M7295 o6 ibias vss vss sky130_fd_pr__nfet_01v8 L=0.5u W=1u
M7296 o6 ibias vss vss sky130_fd_pr__nfet_01v8 L=0.5u W=1u
M7297 o6 ibias vss vss sky130_fd_pr__nfet_01v8 L=0.5u W=1u
M7298 o6 ibias vss vss sky130_fd_pr__nfet_01v8 L=0.5u W=1u
M7299 o6 ibias vss vss sky130_fd_pr__nfet_01v8 L=0.5u W=1u
M7300 o6 ibias vss vss sky130_fd_pr__nfet_01v8 L=0.5u W=1u
M7301 o6 ibias vss vss sky130_fd_pr__nfet_01v8 L=0.5u W=1u
M7302 o6 ibias vss vss sky130_fd_pr__nfet_01v8 L=0.5u W=1u
M7303 o6 ibias vss vss sky130_fd_pr__nfet_01v8 L=0.5u W=1u
M7304 o6 ibias vss vss sky130_fd_pr__nfet_01v8 L=0.5u W=1u
M7305 o6 ibias vss vss sky130_fd_pr__nfet_01v8 L=0.5u W=1u
M7306 o6 ibias vss vss sky130_fd_pr__nfet_01v8 L=0.5u W=1u
M7307 o6 ibias vss vss sky130_fd_pr__nfet_01v8 L=0.5u W=1u
M7308 o6 ibias vss vss sky130_fd_pr__nfet_01v8 L=0.5u W=1u
M7309 o6 ibias vss vss sky130_fd_pr__nfet_01v8 L=0.5u W=1u
M7310 o6 ibias vss vss sky130_fd_pr__nfet_01v8 L=0.5u W=1u
M7311 o6 ibias vss vss sky130_fd_pr__nfet_01v8 L=0.5u W=1u
M7312 o6 ibias vss vss sky130_fd_pr__nfet_01v8 L=0.5u W=1u
M7313 o6 ibias vss vss sky130_fd_pr__nfet_01v8 L=0.5u W=1u
M7314 o6 ibias vss vss sky130_fd_pr__nfet_01v8 L=0.5u W=1u
M7315 o6 ibias vss vss sky130_fd_pr__nfet_01v8 L=0.5u W=1u
M7316 o6 ibias vss vss sky130_fd_pr__nfet_01v8 L=0.5u W=1u
M7317 o6 ibias vss vss sky130_fd_pr__nfet_01v8 L=0.5u W=1u
M7318 o6 ibias vss vss sky130_fd_pr__nfet_01v8 L=0.5u W=1u
M7319 o6 ibias vss vss sky130_fd_pr__nfet_01v8 L=0.5u W=1u
M7320 o6 ibias vss vss sky130_fd_pr__nfet_01v8 L=0.5u W=1u
M7321 o6 ibias vss vss sky130_fd_pr__nfet_01v8 L=0.5u W=1u
M7322 o6 ibias vss vss sky130_fd_pr__nfet_01v8 L=0.5u W=1u
M7323 o6 ibias vss vss sky130_fd_pr__nfet_01v8 L=0.5u W=1u
M7324 o6 ibias vss vss sky130_fd_pr__nfet_01v8 L=0.5u W=1u
M7325 o6 ibias vss vss sky130_fd_pr__nfet_01v8 L=0.5u W=1u
M7326 o6 ibias vss vss sky130_fd_pr__nfet_01v8 L=0.5u W=1u
M7327 o6 ibias vss vss sky130_fd_pr__nfet_01v8 L=0.5u W=1u
M7328 o6 ibias vss vss sky130_fd_pr__nfet_01v8 L=0.5u W=1u
M7329 o6 ibias vss vss sky130_fd_pr__nfet_01v8 L=0.5u W=1u
M7330 o6 ibias vss vss sky130_fd_pr__nfet_01v8 L=0.5u W=1u
M7331 o6 ibias vss vss sky130_fd_pr__nfet_01v8 L=0.5u W=1u
M7332 o6 ibias vss vss sky130_fd_pr__nfet_01v8 L=0.5u W=1u
M7333 o6 ibias vss vss sky130_fd_pr__nfet_01v8 L=0.5u W=1u
M7334 o6 ibias vss vss sky130_fd_pr__nfet_01v8 L=0.5u W=1u
M7335 o6 ibias vss vss sky130_fd_pr__nfet_01v8 L=0.5u W=1u
M7336 o6 ibias vss vss sky130_fd_pr__nfet_01v8 L=0.5u W=1u
M7337 o6 ibias vss vss sky130_fd_pr__nfet_01v8 L=0.5u W=1u
M7338 o6 ibias vss vss sky130_fd_pr__nfet_01v8 L=0.5u W=1u
M7339 o6 ibias vss vss sky130_fd_pr__nfet_01v8 L=0.5u W=1u
M7340 o6 ibias vss vss sky130_fd_pr__nfet_01v8 L=0.5u W=1u
M7341 o6 ibias vss vss sky130_fd_pr__nfet_01v8 L=0.5u W=1u
M7342 o6 ibias vss vss sky130_fd_pr__nfet_01v8 L=0.5u W=1u
M7343 o6 ibias vss vss sky130_fd_pr__nfet_01v8 L=0.5u W=1u
M7344 o6 ibias vss vss sky130_fd_pr__nfet_01v8 L=0.5u W=1u
M7345 o6 ibias vss vss sky130_fd_pr__nfet_01v8 L=0.5u W=1u
M7346 o6 ibias vss vss sky130_fd_pr__nfet_01v8 L=0.5u W=1u
M7347 o6 ibias vss vss sky130_fd_pr__nfet_01v8 L=0.5u W=1u
M7348 o6 ibias vss vss sky130_fd_pr__nfet_01v8 L=0.5u W=1u
M7349 o6 ibias vss vss sky130_fd_pr__nfet_01v8 L=0.5u W=1u
M7350 o6 ibias vss vss sky130_fd_pr__nfet_01v8 L=0.5u W=1u
M7351 o6 ibias vss vss sky130_fd_pr__nfet_01v8 L=0.5u W=1u
M7352 o6 ibias vss vss sky130_fd_pr__nfet_01v8 L=0.5u W=1u
M7353 o6 ibias vss vss sky130_fd_pr__nfet_01v8 L=0.5u W=1u
M7354 o6 ibias vss vss sky130_fd_pr__nfet_01v8 L=0.5u W=1u
M7355 o6 ibias vss vss sky130_fd_pr__nfet_01v8 L=0.5u W=1u
M7356 o6 ibias vss vss sky130_fd_pr__nfet_01v8 L=0.5u W=1u
M7357 o6 ibias vss vss sky130_fd_pr__nfet_01v8 L=0.5u W=1u
M7358 o6 ibias vss vss sky130_fd_pr__nfet_01v8 L=0.5u W=1u
M7359 o6 ibias vss vss sky130_fd_pr__nfet_01v8 L=0.5u W=1u
M7360 o6 ibias vss vss sky130_fd_pr__nfet_01v8 L=0.5u W=1u
M7361 o6 ibias vss vss sky130_fd_pr__nfet_01v8 L=0.5u W=1u
M7362 o6 ibias vss vss sky130_fd_pr__nfet_01v8 L=0.5u W=1u
M7363 o6 ibias vss vss sky130_fd_pr__nfet_01v8 L=0.5u W=1u
M7364 o6 ibias vss vss sky130_fd_pr__nfet_01v8 L=0.5u W=1u
M7365 o6 ibias vss vss sky130_fd_pr__nfet_01v8 L=0.5u W=1u
M7366 o6 ibias vss vss sky130_fd_pr__nfet_01v8 L=0.5u W=1u
M7367 o6 ibias vss vss sky130_fd_pr__nfet_01v8 L=0.5u W=1u
M7368 o6 ibias vss vss sky130_fd_pr__nfet_01v8 L=0.5u W=1u
M7369 o6 ibias vss vss sky130_fd_pr__nfet_01v8 L=0.5u W=1u
M7370 o6 ibias vss vss sky130_fd_pr__nfet_01v8 L=0.5u W=1u
M7371 o6 ibias vss vss sky130_fd_pr__nfet_01v8 L=0.5u W=1u
M7372 o6 ibias vss vss sky130_fd_pr__nfet_01v8 L=0.5u W=1u
M7373 o6 ibias vss vss sky130_fd_pr__nfet_01v8 L=0.5u W=1u
M7374 o6 ibias vss vss sky130_fd_pr__nfet_01v8 L=0.5u W=1u
M7375 o6 ibias vss vss sky130_fd_pr__nfet_01v8 L=0.5u W=1u
M7376 o6 ibias vss vss sky130_fd_pr__nfet_01v8 L=0.5u W=1u
M7377 o6 ibias vss vss sky130_fd_pr__nfet_01v8 L=0.5u W=1u
M7378 o6 ibias vss vss sky130_fd_pr__nfet_01v8 L=0.5u W=1u
M7379 o6 ibias vss vss sky130_fd_pr__nfet_01v8 L=0.5u W=1u
M7380 o6 ibias vss vss sky130_fd_pr__nfet_01v8 L=0.5u W=1u
M7381 o6 ibias vss vss sky130_fd_pr__nfet_01v8 L=0.5u W=1u
M7382 o6 ibias vss vss sky130_fd_pr__nfet_01v8 L=0.5u W=1u
M7383 o6 ibias vss vss sky130_fd_pr__nfet_01v8 L=0.5u W=1u
M7384 o6 ibias vss vss sky130_fd_pr__nfet_01v8 L=0.5u W=1u
M7385 o6 ibias vss vss sky130_fd_pr__nfet_01v8 L=0.5u W=1u
M7386 o6 ibias vss vss sky130_fd_pr__nfet_01v8 L=0.5u W=1u
M7387 o6 ibias vss vss sky130_fd_pr__nfet_01v8 L=0.5u W=1u
M7388 o6 ibias vss vss sky130_fd_pr__nfet_01v8 L=0.5u W=1u
M7389 o6 ibias vss vss sky130_fd_pr__nfet_01v8 L=0.5u W=1u
M7390 o6 ibias vss vss sky130_fd_pr__nfet_01v8 L=0.5u W=1u
M7391 o6 ibias vss vss sky130_fd_pr__nfet_01v8 L=0.5u W=1u
M7392 o6 ibias vss vss sky130_fd_pr__nfet_01v8 L=0.5u W=1u
M7393 o6 ibias vss vss sky130_fd_pr__nfet_01v8 L=0.5u W=1u
M7394 o6 ibias vss vss sky130_fd_pr__nfet_01v8 L=0.5u W=1u
M7395 o6 ibias vss vss sky130_fd_pr__nfet_01v8 L=0.5u W=1u
M7396 o6 ibias vss vss sky130_fd_pr__nfet_01v8 L=0.5u W=1u
M7397 o6 ibias vss vss sky130_fd_pr__nfet_01v8 L=0.5u W=1u
M7398 o6 ibias vss vss sky130_fd_pr__nfet_01v8 L=0.5u W=1u
M7399 o6 ibias vss vss sky130_fd_pr__nfet_01v8 L=0.5u W=1u
M7400 o6 ibias vss vss sky130_fd_pr__nfet_01v8 L=0.5u W=1u
M7401 o6 ibias vss vss sky130_fd_pr__nfet_01v8 L=0.5u W=1u
M7402 o6 ibias vss vss sky130_fd_pr__nfet_01v8 L=0.5u W=1u
M7403 o6 ibias vss vss sky130_fd_pr__nfet_01v8 L=0.5u W=1u
M7404 o6 ibias vss vss sky130_fd_pr__nfet_01v8 L=0.5u W=1u
M7405 o6 ibias vss vss sky130_fd_pr__nfet_01v8 L=0.5u W=1u
M7406 o6 ibias vss vss sky130_fd_pr__nfet_01v8 L=0.5u W=1u
M7407 o6 ibias vss vss sky130_fd_pr__nfet_01v8 L=0.5u W=1u
M7408 o6 ibias vss vss sky130_fd_pr__nfet_01v8 L=0.5u W=1u
M7409 o6 ibias vss vss sky130_fd_pr__nfet_01v8 L=0.5u W=1u
M7410 o6 ibias vss vss sky130_fd_pr__nfet_01v8 L=0.5u W=1u
M7411 o6 ibias vss vss sky130_fd_pr__nfet_01v8 L=0.5u W=1u
M7412 o6 ibias vss vss sky130_fd_pr__nfet_01v8 L=0.5u W=1u
M7413 o6 ibias vss vss sky130_fd_pr__nfet_01v8 L=0.5u W=1u
M7414 o6 ibias vss vss sky130_fd_pr__nfet_01v8 L=0.5u W=1u
M7415 o6 ibias vss vss sky130_fd_pr__nfet_01v8 L=0.5u W=1u
M7416 o6 ibias vss vss sky130_fd_pr__nfet_01v8 L=0.5u W=1u
M7417 o6 ibias vss vss sky130_fd_pr__nfet_01v8 L=0.5u W=1u
M7418 o6 ibias vss vss sky130_fd_pr__nfet_01v8 L=0.5u W=1u
M7419 o6 ibias vss vss sky130_fd_pr__nfet_01v8 L=0.5u W=1u
M7420 o6 ibias vss vss sky130_fd_pr__nfet_01v8 L=0.5u W=1u
M7421 o6 ibias vss vss sky130_fd_pr__nfet_01v8 L=0.5u W=1u
M7422 o6 ibias vss vss sky130_fd_pr__nfet_01v8 L=0.5u W=1u
M7423 o6 ibias vss vss sky130_fd_pr__nfet_01v8 L=0.5u W=1u
M7424 o6 ibias vss vss sky130_fd_pr__nfet_01v8 L=0.5u W=1u
M7425 o6 ibias vss vss sky130_fd_pr__nfet_01v8 L=0.5u W=1u
M7426 o6 ibias vss vss sky130_fd_pr__nfet_01v8 L=0.5u W=1u
M7427 o6 ibias vss vss sky130_fd_pr__nfet_01v8 L=0.5u W=1u
M7428 o6 ibias vss vss sky130_fd_pr__nfet_01v8 L=0.5u W=1u
M7429 o6 ibias vss vss sky130_fd_pr__nfet_01v8 L=0.5u W=1u
M7430 o6 ibias vss vss sky130_fd_pr__nfet_01v8 L=0.5u W=1u
M7431 o6 ibias vss vss sky130_fd_pr__nfet_01v8 L=0.5u W=1u
M7432 o6 ibias vss vss sky130_fd_pr__nfet_01v8 L=0.5u W=1u
M7433 o6 ibias vss vss sky130_fd_pr__nfet_01v8 L=0.5u W=1u
M7434 o6 ibias vss vss sky130_fd_pr__nfet_01v8 L=0.5u W=1u
M7435 o6 ibias vss vss sky130_fd_pr__nfet_01v8 L=0.5u W=1u
M7436 o6 ibias vss vss sky130_fd_pr__nfet_01v8 L=0.5u W=1u
M7437 o6 ibias vss vss sky130_fd_pr__nfet_01v8 L=0.5u W=1u
M7438 o6 ibias vss vss sky130_fd_pr__nfet_01v8 L=0.5u W=1u
M7439 o6 ibias vss vss sky130_fd_pr__nfet_01v8 L=0.5u W=1u
M7440 o6 ibias vss vss sky130_fd_pr__nfet_01v8 L=0.5u W=1u
M7441 o6 ibias vss vss sky130_fd_pr__nfet_01v8 L=0.5u W=1u
M7442 o6 ibias vss vss sky130_fd_pr__nfet_01v8 L=0.5u W=1u
M7443 o6 ibias vss vss sky130_fd_pr__nfet_01v8 L=0.5u W=1u
M7444 o6 ibias vss vss sky130_fd_pr__nfet_01v8 L=0.5u W=1u
M7445 o6 ibias vss vss sky130_fd_pr__nfet_01v8 L=0.5u W=1u
M7446 o6 ibias vss vss sky130_fd_pr__nfet_01v8 L=0.5u W=1u
M7447 o6 ibias vss vss sky130_fd_pr__nfet_01v8 L=0.5u W=1u
M7448 o6 ibias vss vss sky130_fd_pr__nfet_01v8 L=0.5u W=1u
M7449 o6 ibias vss vss sky130_fd_pr__nfet_01v8 L=0.5u W=1u
M7450 o6 ibias vss vss sky130_fd_pr__nfet_01v8 L=0.5u W=1u
M7451 o6 ibias vss vss sky130_fd_pr__nfet_01v8 L=0.5u W=1u
M7452 o6 ibias vss vss sky130_fd_pr__nfet_01v8 L=0.5u W=1u
M7453 o6 ibias vss vss sky130_fd_pr__nfet_01v8 L=0.5u W=1u
M7454 o6 ibias vss vss sky130_fd_pr__nfet_01v8 L=0.5u W=1u
M7455 o6 ibias vss vss sky130_fd_pr__nfet_01v8 L=0.5u W=1u
M7456 o6 ibias vss vss sky130_fd_pr__nfet_01v8 L=0.5u W=1u
M7457 o6 ibias vss vss sky130_fd_pr__nfet_01v8 L=0.5u W=1u
M7458 o6 ibias vss vss sky130_fd_pr__nfet_01v8 L=0.5u W=1u
M7459 o6 ibias vss vss sky130_fd_pr__nfet_01v8 L=0.5u W=1u
M7460 o6 ibias vss vss sky130_fd_pr__nfet_01v8 L=0.5u W=1u
M7461 o6 ibias vss vss sky130_fd_pr__nfet_01v8 L=0.5u W=1u
M7462 o6 ibias vss vss sky130_fd_pr__nfet_01v8 L=0.5u W=1u
M7463 o6 ibias vss vss sky130_fd_pr__nfet_01v8 L=0.5u W=1u
M7464 o6 ibias vss vss sky130_fd_pr__nfet_01v8 L=0.5u W=1u
M7465 o6 ibias vss vss sky130_fd_pr__nfet_01v8 L=0.5u W=1u
M7466 o6 ibias vss vss sky130_fd_pr__nfet_01v8 L=0.5u W=1u
M7467 o6 ibias vss vss sky130_fd_pr__nfet_01v8 L=0.5u W=1u
M7468 o6 ibias vss vss sky130_fd_pr__nfet_01v8 L=0.5u W=1u
M7469 o6 ibias vss vss sky130_fd_pr__nfet_01v8 L=0.5u W=1u
M7470 o6 ibias vss vss sky130_fd_pr__nfet_01v8 L=0.5u W=1u
M7471 o6 ibias vss vss sky130_fd_pr__nfet_01v8 L=0.5u W=1u
M7472 o6 ibias vss vss sky130_fd_pr__nfet_01v8 L=0.5u W=1u
M7473 o6 ibias vss vss sky130_fd_pr__nfet_01v8 L=0.5u W=1u
M7474 o6 ibias vss vss sky130_fd_pr__nfet_01v8 L=0.5u W=1u
M7475 o6 ibias vss vss sky130_fd_pr__nfet_01v8 L=0.5u W=1u
M7476 o6 ibias vss vss sky130_fd_pr__nfet_01v8 L=0.5u W=1u
M7477 o6 ibias vss vss sky130_fd_pr__nfet_01v8 L=0.5u W=1u
M7478 o6 ibias vss vss sky130_fd_pr__nfet_01v8 L=0.5u W=1u
M7479 o6 ibias vss vss sky130_fd_pr__nfet_01v8 L=0.5u W=1u
M7480 o6 ibias vss vss sky130_fd_pr__nfet_01v8 L=0.5u W=1u
M7481 o6 ibias vss vss sky130_fd_pr__nfet_01v8 L=0.5u W=1u
M7482 o6 ibias vss vss sky130_fd_pr__nfet_01v8 L=0.5u W=1u
M7483 o6 ibias vss vss sky130_fd_pr__nfet_01v8 L=0.5u W=1u
M7484 o6 ibias vss vss sky130_fd_pr__nfet_01v8 L=0.5u W=1u
M7485 o6 ibias vss vss sky130_fd_pr__nfet_01v8 L=0.5u W=1u
M7486 o6 ibias vss vss sky130_fd_pr__nfet_01v8 L=0.5u W=1u
M7487 o6 ibias vss vss sky130_fd_pr__nfet_01v8 L=0.5u W=1u
M7488 o6 ibias vss vss sky130_fd_pr__nfet_01v8 L=0.5u W=1u
M7489 o6 ibias vss vss sky130_fd_pr__nfet_01v8 L=0.5u W=1u
M7490 o6 ibias vss vss sky130_fd_pr__nfet_01v8 L=0.5u W=1u
M7491 o6 ibias vss vss sky130_fd_pr__nfet_01v8 L=0.5u W=1u
M7492 o6 ibias vss vss sky130_fd_pr__nfet_01v8 L=0.5u W=1u
M7493 o6 ibias vss vss sky130_fd_pr__nfet_01v8 L=0.5u W=1u
M7494 o6 ibias vss vss sky130_fd_pr__nfet_01v8 L=0.5u W=1u
M7495 o6 ibias vss vss sky130_fd_pr__nfet_01v8 L=0.5u W=1u
M7496 o6 ibias vss vss sky130_fd_pr__nfet_01v8 L=0.5u W=1u
M7497 o6 ibias vss vss sky130_fd_pr__nfet_01v8 L=0.5u W=1u
M7498 o6 ibias vss vss sky130_fd_pr__nfet_01v8 L=0.5u W=1u
M7499 o6 ibias vss vss sky130_fd_pr__nfet_01v8 L=0.5u W=1u
M7500 o6 ibias vss vss sky130_fd_pr__nfet_01v8 L=0.5u W=1u
M7501 o6 ibias vss vss sky130_fd_pr__nfet_01v8 L=0.5u W=1u
M7502 o6 ibias vss vss sky130_fd_pr__nfet_01v8 L=0.5u W=1u
M7503 o6 ibias vss vss sky130_fd_pr__nfet_01v8 L=0.5u W=1u
M7504 o6 ibias vss vss sky130_fd_pr__nfet_01v8 L=0.5u W=1u
M7505 o6 ibias vss vss sky130_fd_pr__nfet_01v8 L=0.5u W=1u
M7506 o6 ibias vss vss sky130_fd_pr__nfet_01v8 L=0.5u W=1u
M7507 o6 ibias vss vss sky130_fd_pr__nfet_01v8 L=0.5u W=1u
M7508 o6 ibias vss vss sky130_fd_pr__nfet_01v8 L=0.5u W=1u
M7509 o6 ibias vss vss sky130_fd_pr__nfet_01v8 L=0.5u W=1u
M7510 o6 ibias vss vss sky130_fd_pr__nfet_01v8 L=0.5u W=1u
M7511 o6 ibias vss vss sky130_fd_pr__nfet_01v8 L=0.5u W=1u
M7512 o6 ibias vss vss sky130_fd_pr__nfet_01v8 L=0.5u W=1u
M7513 o6 ibias vss vss sky130_fd_pr__nfet_01v8 L=0.5u W=1u
M7514 o6 ibias vss vss sky130_fd_pr__nfet_01v8 L=0.5u W=1u
M7515 o6 ibias vss vss sky130_fd_pr__nfet_01v8 L=0.5u W=1u
M7516 o6 ibias vss vss sky130_fd_pr__nfet_01v8 L=0.5u W=1u
M7517 o6 ibias vss vss sky130_fd_pr__nfet_01v8 L=0.5u W=1u
M7518 o6 ibias vss vss sky130_fd_pr__nfet_01v8 L=0.5u W=1u
M7519 o6 ibias vss vss sky130_fd_pr__nfet_01v8 L=0.5u W=1u
M7520 o6 ibias vss vss sky130_fd_pr__nfet_01v8 L=0.5u W=1u
M7521 o6 ibias vss vss sky130_fd_pr__nfet_01v8 L=0.5u W=1u
M7522 o6 ibias vss vss sky130_fd_pr__nfet_01v8 L=0.5u W=1u
M7523 o6 ibias vss vss sky130_fd_pr__nfet_01v8 L=0.5u W=1u
M7524 o6 ibias vss vss sky130_fd_pr__nfet_01v8 L=0.5u W=1u
M7525 o6 ibias vss vss sky130_fd_pr__nfet_01v8 L=0.5u W=1u
M7526 o6 ibias vss vss sky130_fd_pr__nfet_01v8 L=0.5u W=1u
M7527 o6 ibias vss vss sky130_fd_pr__nfet_01v8 L=0.5u W=1u
M7528 o6 ibias vss vss sky130_fd_pr__nfet_01v8 L=0.5u W=1u
M7529 o6 ibias vss vss sky130_fd_pr__nfet_01v8 L=0.5u W=1u
M7530 o6 ibias vss vss sky130_fd_pr__nfet_01v8 L=0.5u W=1u
M7531 o6 ibias vss vss sky130_fd_pr__nfet_01v8 L=0.5u W=1u
M7532 o6 ibias vss vss sky130_fd_pr__nfet_01v8 L=0.5u W=1u
M7533 o6 ibias vss vss sky130_fd_pr__nfet_01v8 L=0.5u W=1u
M7534 o6 ibias vss vss sky130_fd_pr__nfet_01v8 L=0.5u W=1u
M7535 o6 ibias vss vss sky130_fd_pr__nfet_01v8 L=0.5u W=1u
M7536 o6 ibias vss vss sky130_fd_pr__nfet_01v8 L=0.5u W=1u
M7537 o6 ibias vss vss sky130_fd_pr__nfet_01v8 L=0.5u W=1u
M7538 o6 ibias vss vss sky130_fd_pr__nfet_01v8 L=0.5u W=1u
M7539 o6 ibias vss vss sky130_fd_pr__nfet_01v8 L=0.5u W=1u
M7540 o6 ibias vss vss sky130_fd_pr__nfet_01v8 L=0.5u W=1u
M7541 o6 ibias vss vss sky130_fd_pr__nfet_01v8 L=0.5u W=1u
M7542 o6 ibias vss vss sky130_fd_pr__nfet_01v8 L=0.5u W=1u
M7543 o6 ibias vss vss sky130_fd_pr__nfet_01v8 L=0.5u W=1u
M7544 o6 ibias vss vss sky130_fd_pr__nfet_01v8 L=0.5u W=1u
M7545 o6 ibias vss vss sky130_fd_pr__nfet_01v8 L=0.5u W=1u
M7546 o6 ibias vss vss sky130_fd_pr__nfet_01v8 L=0.5u W=1u
M7547 o6 ibias vss vss sky130_fd_pr__nfet_01v8 L=0.5u W=1u
M7548 o6 ibias vss vss sky130_fd_pr__nfet_01v8 L=0.5u W=1u
M7549 o6 ibias vss vss sky130_fd_pr__nfet_01v8 L=0.5u W=1u
M7550 o6 ibias vss vss sky130_fd_pr__nfet_01v8 L=0.5u W=1u
M7551 o6 ibias vss vss sky130_fd_pr__nfet_01v8 L=0.5u W=1u
M7552 o6 ibias vss vss sky130_fd_pr__nfet_01v8 L=0.5u W=1u
M7553 o6 ibias vss vss sky130_fd_pr__nfet_01v8 L=0.5u W=1u
M7554 o6 ibias vss vss sky130_fd_pr__nfet_01v8 L=0.5u W=1u
M7555 o6 ibias vss vss sky130_fd_pr__nfet_01v8 L=0.5u W=1u
M7556 o6 ibias vss vss sky130_fd_pr__nfet_01v8 L=0.5u W=1u
M7557 o6 ibias vss vss sky130_fd_pr__nfet_01v8 L=0.5u W=1u
M7558 o6 ibias vss vss sky130_fd_pr__nfet_01v8 L=0.5u W=1u
M7559 o6 ibias vss vss sky130_fd_pr__nfet_01v8 L=0.5u W=1u
M7560 o6 ibias vss vss sky130_fd_pr__nfet_01v8 L=0.5u W=1u
M7561 o6 ibias vss vss sky130_fd_pr__nfet_01v8 L=0.5u W=1u
M7562 o6 ibias vss vss sky130_fd_pr__nfet_01v8 L=0.5u W=1u
M7563 o6 ibias vss vss sky130_fd_pr__nfet_01v8 L=0.5u W=1u
M7564 o6 ibias vss vss sky130_fd_pr__nfet_01v8 L=0.5u W=1u
M7565 o6 ibias vss vss sky130_fd_pr__nfet_01v8 L=0.5u W=1u
M7566 o6 ibias vss vss sky130_fd_pr__nfet_01v8 L=0.5u W=1u
M7567 o6 ibias vss vss sky130_fd_pr__nfet_01v8 L=0.5u W=1u
M7568 o6 ibias vss vss sky130_fd_pr__nfet_01v8 L=0.5u W=1u
M7569 o6 ibias vss vss sky130_fd_pr__nfet_01v8 L=0.5u W=1u
M7570 o6 ibias vss vss sky130_fd_pr__nfet_01v8 L=0.5u W=1u
M7571 o6 ibias vss vss sky130_fd_pr__nfet_01v8 L=0.5u W=1u
M7572 o6 ibias vss vss sky130_fd_pr__nfet_01v8 L=0.5u W=1u
M7573 o6 ibias vss vss sky130_fd_pr__nfet_01v8 L=0.5u W=1u
M7574 o6 ibias vss vss sky130_fd_pr__nfet_01v8 L=0.5u W=1u
M7575 o6 ibias vss vss sky130_fd_pr__nfet_01v8 L=0.5u W=1u
M7576 o6 ibias vss vss sky130_fd_pr__nfet_01v8 L=0.5u W=1u
M7577 o6 ibias vss vss sky130_fd_pr__nfet_01v8 L=0.5u W=1u
M7578 o6 ibias vss vss sky130_fd_pr__nfet_01v8 L=0.5u W=1u
M7579 o6 ibias vss vss sky130_fd_pr__nfet_01v8 L=0.5u W=1u
M7580 o6 ibias vss vss sky130_fd_pr__nfet_01v8 L=0.5u W=1u
M7581 o6 ibias vss vss sky130_fd_pr__nfet_01v8 L=0.5u W=1u
M7582 o6 ibias vss vss sky130_fd_pr__nfet_01v8 L=0.5u W=1u
M7583 o6 ibias vss vss sky130_fd_pr__nfet_01v8 L=0.5u W=1u
M7584 o6 ibias vss vss sky130_fd_pr__nfet_01v8 L=0.5u W=1u
M7585 o6 ibias vss vss sky130_fd_pr__nfet_01v8 L=0.5u W=1u
M7586 o6 ibias vss vss sky130_fd_pr__nfet_01v8 L=0.5u W=1u
M7587 o6 ibias vss vss sky130_fd_pr__nfet_01v8 L=0.5u W=1u
M7588 o6 ibias vss vss sky130_fd_pr__nfet_01v8 L=0.5u W=1u
M7589 o6 ibias vss vss sky130_fd_pr__nfet_01v8 L=0.5u W=1u
M7590 o6 ibias vss vss sky130_fd_pr__nfet_01v8 L=0.5u W=1u
M7591 o6 ibias vss vss sky130_fd_pr__nfet_01v8 L=0.5u W=1u
M7592 o6 ibias vss vss sky130_fd_pr__nfet_01v8 L=0.5u W=1u
M7593 o6 ibias vss vss sky130_fd_pr__nfet_01v8 L=0.5u W=1u
M7594 o6 ibias vss vss sky130_fd_pr__nfet_01v8 L=0.5u W=1u
M7595 o6 ibias vss vss sky130_fd_pr__nfet_01v8 L=0.5u W=1u
M7596 o6 ibias vss vss sky130_fd_pr__nfet_01v8 L=0.5u W=1u
M7597 o6 ibias vss vss sky130_fd_pr__nfet_01v8 L=0.5u W=1u
M7598 o6 ibias vss vss sky130_fd_pr__nfet_01v8 L=0.5u W=1u
M7599 o6 ibias vss vss sky130_fd_pr__nfet_01v8 L=0.5u W=1u
M7600 o6 ibias vss vss sky130_fd_pr__nfet_01v8 L=0.5u W=1u
M7601 o6 ibias vss vss sky130_fd_pr__nfet_01v8 L=0.5u W=1u
M7602 o6 ibias vss vss sky130_fd_pr__nfet_01v8 L=0.5u W=1u
M7603 o6 ibias vss vss sky130_fd_pr__nfet_01v8 L=0.5u W=1u
M7604 o6 ibias vss vss sky130_fd_pr__nfet_01v8 L=0.5u W=1u
M7605 o6 ibias vss vss sky130_fd_pr__nfet_01v8 L=0.5u W=1u
M7606 o6 ibias vss vss sky130_fd_pr__nfet_01v8 L=0.5u W=1u
M7607 o6 ibias vss vss sky130_fd_pr__nfet_01v8 L=0.5u W=1u
M7608 o6 ibias vss vss sky130_fd_pr__nfet_01v8 L=0.5u W=1u
M7609 o6 ibias vss vss sky130_fd_pr__nfet_01v8 L=0.5u W=1u
M7610 o6 ibias vss vss sky130_fd_pr__nfet_01v8 L=0.5u W=1u
M7611 o6 ibias vss vss sky130_fd_pr__nfet_01v8 L=0.5u W=1u
M7612 o6 ibias vss vss sky130_fd_pr__nfet_01v8 L=0.5u W=1u
M7613 o6 ibias vss vss sky130_fd_pr__nfet_01v8 L=0.5u W=1u
M7614 o6 ibias vss vss sky130_fd_pr__nfet_01v8 L=0.5u W=1u
M7615 o6 ibias vss vss sky130_fd_pr__nfet_01v8 L=0.5u W=1u
M7616 o6 ibias vss vss sky130_fd_pr__nfet_01v8 L=0.5u W=1u
M7617 o6 ibias vss vss sky130_fd_pr__nfet_01v8 L=0.5u W=1u
M7618 o6 ibias vss vss sky130_fd_pr__nfet_01v8 L=0.5u W=1u
M7619 o6 ibias vss vss sky130_fd_pr__nfet_01v8 L=0.5u W=1u
M7620 o6 ibias vss vss sky130_fd_pr__nfet_01v8 L=0.5u W=1u
M7621 o6 ibias vss vss sky130_fd_pr__nfet_01v8 L=0.5u W=1u
M7622 o6 ibias vss vss sky130_fd_pr__nfet_01v8 L=0.5u W=1u
M7623 o6 ibias vss vss sky130_fd_pr__nfet_01v8 L=0.5u W=1u
M7624 o6 ibias vss vss sky130_fd_pr__nfet_01v8 L=0.5u W=1u
M7625 o6 ibias vss vss sky130_fd_pr__nfet_01v8 L=0.5u W=1u
M7626 o6 ibias vss vss sky130_fd_pr__nfet_01v8 L=0.5u W=1u
M7627 o6 ibias vss vss sky130_fd_pr__nfet_01v8 L=0.5u W=1u
M7628 o6 ibias vss vss sky130_fd_pr__nfet_01v8 L=0.5u W=1u
M7629 o6 ibias vss vss sky130_fd_pr__nfet_01v8 L=0.5u W=1u
M7630 o6 ibias vss vss sky130_fd_pr__nfet_01v8 L=0.5u W=1u
M7631 o6 ibias vss vss sky130_fd_pr__nfet_01v8 L=0.5u W=1u
M7632 o6 ibias vss vss sky130_fd_pr__nfet_01v8 L=0.5u W=1u
M7633 o6 ibias vss vss sky130_fd_pr__nfet_01v8 L=0.5u W=1u
M7634 o6 ibias vss vss sky130_fd_pr__nfet_01v8 L=0.5u W=1u
M7635 o6 ibias vss vss sky130_fd_pr__nfet_01v8 L=0.5u W=1u
M7636 o6 ibias vss vss sky130_fd_pr__nfet_01v8 L=0.5u W=1u
M7637 o6 ibias vss vss sky130_fd_pr__nfet_01v8 L=0.5u W=1u
M7638 o6 ibias vss vss sky130_fd_pr__nfet_01v8 L=0.5u W=1u
M7639 o6 ibias vss vss sky130_fd_pr__nfet_01v8 L=0.5u W=1u
M7640 o6 ibias vss vss sky130_fd_pr__nfet_01v8 L=0.5u W=1u
M7641 o6 ibias vss vss sky130_fd_pr__nfet_01v8 L=0.5u W=1u
M7642 o6 ibias vss vss sky130_fd_pr__nfet_01v8 L=0.5u W=1u
M7643 o6 ibias vss vss sky130_fd_pr__nfet_01v8 L=0.5u W=1u
M7644 o6 ibias vss vss sky130_fd_pr__nfet_01v8 L=0.5u W=1u
M7645 o6 ibias vss vss sky130_fd_pr__nfet_01v8 L=0.5u W=1u
M7646 o6 ibias vss vss sky130_fd_pr__nfet_01v8 L=0.5u W=1u
M7647 o6 ibias vss vss sky130_fd_pr__nfet_01v8 L=0.5u W=1u
M7648 o6 ibias vss vss sky130_fd_pr__nfet_01v8 L=0.5u W=1u
M7649 o6 ibias vss vss sky130_fd_pr__nfet_01v8 L=0.5u W=1u
M7650 o6 ibias vss vss sky130_fd_pr__nfet_01v8 L=0.5u W=1u
M7651 o6 ibias vss vss sky130_fd_pr__nfet_01v8 L=0.5u W=1u
M7652 o6 ibias vss vss sky130_fd_pr__nfet_01v8 L=0.5u W=1u
M7653 o6 ibias vss vss sky130_fd_pr__nfet_01v8 L=0.5u W=1u
M7654 o6 ibias vss vss sky130_fd_pr__nfet_01v8 L=0.5u W=1u
M7655 o6 ibias vss vss sky130_fd_pr__nfet_01v8 L=0.5u W=1u
M7656 o6 ibias vss vss sky130_fd_pr__nfet_01v8 L=0.5u W=1u
M7657 o6 ibias vss vss sky130_fd_pr__nfet_01v8 L=0.5u W=1u
M7658 o6 ibias vss vss sky130_fd_pr__nfet_01v8 L=0.5u W=1u
M7659 o6 ibias vss vss sky130_fd_pr__nfet_01v8 L=0.5u W=1u
M7660 o6 ibias vss vss sky130_fd_pr__nfet_01v8 L=0.5u W=1u
M7661 o6 ibias vss vss sky130_fd_pr__nfet_01v8 L=0.5u W=1u
M7662 o6 ibias vss vss sky130_fd_pr__nfet_01v8 L=0.5u W=1u
M7663 o6 ibias vss vss sky130_fd_pr__nfet_01v8 L=0.5u W=1u
M7664 o6 ibias vss vss sky130_fd_pr__nfet_01v8 L=0.5u W=1u
M7665 o6 ibias vss vss sky130_fd_pr__nfet_01v8 L=0.5u W=1u
M7666 o6 ibias vss vss sky130_fd_pr__nfet_01v8 L=0.5u W=1u
M7667 o6 ibias vss vss sky130_fd_pr__nfet_01v8 L=0.5u W=1u
M7668 o6 ibias vss vss sky130_fd_pr__nfet_01v8 L=0.5u W=1u
M7669 o6 ibias vss vss sky130_fd_pr__nfet_01v8 L=0.5u W=1u
M7670 o6 ibias vss vss sky130_fd_pr__nfet_01v8 L=0.5u W=1u
M7671 o6 ibias vss vss sky130_fd_pr__nfet_01v8 L=0.5u W=1u
M7672 o6 ibias vss vss sky130_fd_pr__nfet_01v8 L=0.5u W=1u
M7673 o6 ibias vss vss sky130_fd_pr__nfet_01v8 L=0.5u W=1u
M7674 o6 ibias vss vss sky130_fd_pr__nfet_01v8 L=0.5u W=1u
M7675 o6 ibias vss vss sky130_fd_pr__nfet_01v8 L=0.5u W=1u
M7676 o6 ibias vss vss sky130_fd_pr__nfet_01v8 L=0.5u W=1u
M7677 o6 ibias vss vss sky130_fd_pr__nfet_01v8 L=0.5u W=1u
M7678 o6 ibias vss vss sky130_fd_pr__nfet_01v8 L=0.5u W=1u
M7679 o6 ibias vss vss sky130_fd_pr__nfet_01v8 L=0.5u W=1u
M7680 o6 ibias vss vss sky130_fd_pr__nfet_01v8 L=0.5u W=1u
M7681 o6 ibias vss vss sky130_fd_pr__nfet_01v8 L=0.5u W=1u
M7682 o6 ibias vss vss sky130_fd_pr__nfet_01v8 L=0.5u W=1u
M7683 o6 ibias vss vss sky130_fd_pr__nfet_01v8 L=0.5u W=1u
M7684 o6 ibias vss vss sky130_fd_pr__nfet_01v8 L=0.5u W=1u
M7685 o6 ibias vss vss sky130_fd_pr__nfet_01v8 L=0.5u W=1u
M7686 o6 ibias vss vss sky130_fd_pr__nfet_01v8 L=0.5u W=1u
M7687 o6 ibias vss vss sky130_fd_pr__nfet_01v8 L=0.5u W=1u
M7688 o6 ibias vss vss sky130_fd_pr__nfet_01v8 L=0.5u W=1u
M7689 o6 ibias vss vss sky130_fd_pr__nfet_01v8 L=0.5u W=1u
M7690 o6 ibias vss vss sky130_fd_pr__nfet_01v8 L=0.5u W=1u
M7691 o6 ibias vss vss sky130_fd_pr__nfet_01v8 L=0.5u W=1u
M7692 o6 ibias vss vss sky130_fd_pr__nfet_01v8 L=0.5u W=1u
M7693 o6 ibias vss vss sky130_fd_pr__nfet_01v8 L=0.5u W=1u
M7694 o6 ibias vss vss sky130_fd_pr__nfet_01v8 L=0.5u W=1u
M7695 o6 ibias vss vss sky130_fd_pr__nfet_01v8 L=0.5u W=1u
M7696 o6 ibias vss vss sky130_fd_pr__nfet_01v8 L=0.5u W=1u
M7697 o6 ibias vss vss sky130_fd_pr__nfet_01v8 L=0.5u W=1u
M7698 o6 ibias vss vss sky130_fd_pr__nfet_01v8 L=0.5u W=1u
M7699 o6 ibias vss vss sky130_fd_pr__nfet_01v8 L=0.5u W=1u
M7700 o6 ibias vss vss sky130_fd_pr__nfet_01v8 L=0.5u W=1u
M7701 o6 ibias vss vss sky130_fd_pr__nfet_01v8 L=0.5u W=1u
M7702 o6 ibias vss vss sky130_fd_pr__nfet_01v8 L=0.5u W=1u
M7703 o6 ibias vss vss sky130_fd_pr__nfet_01v8 L=0.5u W=1u
M7704 o6 ibias vss vss sky130_fd_pr__nfet_01v8 L=0.5u W=1u
M7705 o6 ibias vss vss sky130_fd_pr__nfet_01v8 L=0.5u W=1u
M7706 o6 ibias vss vss sky130_fd_pr__nfet_01v8 L=0.5u W=1u
M7707 o6 ibias vss vss sky130_fd_pr__nfet_01v8 L=0.5u W=1u
M7708 o6 ibias vss vss sky130_fd_pr__nfet_01v8 L=0.5u W=1u
M7709 o6 ibias vss vss sky130_fd_pr__nfet_01v8 L=0.5u W=1u
M7710 o6 ibias vss vss sky130_fd_pr__nfet_01v8 L=0.5u W=1u
M7711 o6 ibias vss vss sky130_fd_pr__nfet_01v8 L=0.5u W=1u
M7712 o6 ibias vss vss sky130_fd_pr__nfet_01v8 L=0.5u W=1u
M7713 o6 ibias vss vss sky130_fd_pr__nfet_01v8 L=0.5u W=1u
M7714 o6 ibias vss vss sky130_fd_pr__nfet_01v8 L=0.5u W=1u
M7715 o6 ibias vss vss sky130_fd_pr__nfet_01v8 L=0.5u W=1u
M7716 o6 ibias vss vss sky130_fd_pr__nfet_01v8 L=0.5u W=1u
M7717 o6 ibias vss vss sky130_fd_pr__nfet_01v8 L=0.5u W=1u
M7718 o6 ibias vss vss sky130_fd_pr__nfet_01v8 L=0.5u W=1u
M7719 o6 ibias vss vss sky130_fd_pr__nfet_01v8 L=0.5u W=1u
M7720 o6 ibias vss vss sky130_fd_pr__nfet_01v8 L=0.5u W=1u
M7721 o6 ibias vss vss sky130_fd_pr__nfet_01v8 L=0.5u W=1u
M7722 o6 ibias vss vss sky130_fd_pr__nfet_01v8 L=0.5u W=1u
M7723 o6 ibias vss vss sky130_fd_pr__nfet_01v8 L=0.5u W=1u
M7724 o6 ibias vss vss sky130_fd_pr__nfet_01v8 L=0.5u W=1u
M7725 o6 ibias vss vss sky130_fd_pr__nfet_01v8 L=0.5u W=1u
M7726 o6 ibias vss vss sky130_fd_pr__nfet_01v8 L=0.5u W=1u
M7727 o6 ibias vss vss sky130_fd_pr__nfet_01v8 L=0.5u W=1u
M7728 o6 ibias vss vss sky130_fd_pr__nfet_01v8 L=0.5u W=1u
M7729 o6 ibias vss vss sky130_fd_pr__nfet_01v8 L=0.5u W=1u
M7730 o6 ibias vss vss sky130_fd_pr__nfet_01v8 L=0.5u W=1u
M7731 o6 ibias vss vss sky130_fd_pr__nfet_01v8 L=0.5u W=1u
M7732 o6 ibias vss vss sky130_fd_pr__nfet_01v8 L=0.5u W=1u
M7733 o6 ibias vss vss sky130_fd_pr__nfet_01v8 L=0.5u W=1u
M7734 o6 ibias vss vss sky130_fd_pr__nfet_01v8 L=0.5u W=1u
M7735 o6 ibias vss vss sky130_fd_pr__nfet_01v8 L=0.5u W=1u
M7736 o6 ibias vss vss sky130_fd_pr__nfet_01v8 L=0.5u W=1u
M7737 o6 ibias vss vss sky130_fd_pr__nfet_01v8 L=0.5u W=1u
M7738 o6 ibias vss vss sky130_fd_pr__nfet_01v8 L=0.5u W=1u
M7739 o6 ibias vss vss sky130_fd_pr__nfet_01v8 L=0.5u W=1u
M7740 o6 ibias vss vss sky130_fd_pr__nfet_01v8 L=0.5u W=1u
M7741 o6 ibias vss vss sky130_fd_pr__nfet_01v8 L=0.5u W=1u
M7742 o6 ibias vss vss sky130_fd_pr__nfet_01v8 L=0.5u W=1u
M7743 o6 ibias vss vss sky130_fd_pr__nfet_01v8 L=0.5u W=1u
M7744 o6 ibias vss vss sky130_fd_pr__nfet_01v8 L=0.5u W=1u
M7745 o6 ibias vss vss sky130_fd_pr__nfet_01v8 L=0.5u W=1u
M7746 o6 ibias vss vss sky130_fd_pr__nfet_01v8 L=0.5u W=1u
M7747 o6 ibias vss vss sky130_fd_pr__nfet_01v8 L=0.5u W=1u
M7748 o6 ibias vss vss sky130_fd_pr__nfet_01v8 L=0.5u W=1u
M7749 o6 ibias vss vss sky130_fd_pr__nfet_01v8 L=0.5u W=1u
M7750 o6 ibias vss vss sky130_fd_pr__nfet_01v8 L=0.5u W=1u
M7751 o6 ibias vss vss sky130_fd_pr__nfet_01v8 L=0.5u W=1u
M7752 o6 ibias vss vss sky130_fd_pr__nfet_01v8 L=0.5u W=1u
M7753 o6 ibias vss vss sky130_fd_pr__nfet_01v8 L=0.5u W=1u
M7754 o6 ibias vss vss sky130_fd_pr__nfet_01v8 L=0.5u W=1u
M7755 o6 ibias vss vss sky130_fd_pr__nfet_01v8 L=0.5u W=1u
M7756 o6 ibias vss vss sky130_fd_pr__nfet_01v8 L=0.5u W=1u
M7757 o6 ibias vss vss sky130_fd_pr__nfet_01v8 L=0.5u W=1u
M7758 o6 ibias vss vss sky130_fd_pr__nfet_01v8 L=0.5u W=1u
M7759 o6 ibias vss vss sky130_fd_pr__nfet_01v8 L=0.5u W=1u
M7760 o6 ibias vss vss sky130_fd_pr__nfet_01v8 L=0.5u W=1u
M7761 o6 ibias vss vss sky130_fd_pr__nfet_01v8 L=0.5u W=1u
M7762 o6 ibias vss vss sky130_fd_pr__nfet_01v8 L=0.5u W=1u
M7763 o6 ibias vss vss sky130_fd_pr__nfet_01v8 L=0.5u W=1u
M7764 o6 ibias vss vss sky130_fd_pr__nfet_01v8 L=0.5u W=1u
M7765 o6 ibias vss vss sky130_fd_pr__nfet_01v8 L=0.5u W=1u
M7766 o6 ibias vss vss sky130_fd_pr__nfet_01v8 L=0.5u W=1u
M7767 o6 ibias vss vss sky130_fd_pr__nfet_01v8 L=0.5u W=1u
M7768 o6 ibias vss vss sky130_fd_pr__nfet_01v8 L=0.5u W=1u
M7769 o6 ibias vss vss sky130_fd_pr__nfet_01v8 L=0.5u W=1u
M7770 o6 ibias vss vss sky130_fd_pr__nfet_01v8 L=0.5u W=1u
M7771 o6 ibias vss vss sky130_fd_pr__nfet_01v8 L=0.5u W=1u
M7772 o6 ibias vss vss sky130_fd_pr__nfet_01v8 L=0.5u W=1u
M7773 o6 ibias vss vss sky130_fd_pr__nfet_01v8 L=0.5u W=1u
M7774 o6 ibias vss vss sky130_fd_pr__nfet_01v8 L=0.5u W=1u
M7775 o6 ibias vss vss sky130_fd_pr__nfet_01v8 L=0.5u W=1u
M7776 o6 ibias vss vss sky130_fd_pr__nfet_01v8 L=0.5u W=1u
M7777 o6 ibias vss vss sky130_fd_pr__nfet_01v8 L=0.5u W=1u
M7778 o6 ibias vss vss sky130_fd_pr__nfet_01v8 L=0.5u W=1u
M7779 o6 ibias vss vss sky130_fd_pr__nfet_01v8 L=0.5u W=1u
M7780 o6 ibias vss vss sky130_fd_pr__nfet_01v8 L=0.5u W=1u
M7781 o6 ibias vss vss sky130_fd_pr__nfet_01v8 L=0.5u W=1u
M7782 o6 ibias vss vss sky130_fd_pr__nfet_01v8 L=0.5u W=1u
M7783 o6 ibias vss vss sky130_fd_pr__nfet_01v8 L=0.5u W=1u
M7784 o6 ibias vss vss sky130_fd_pr__nfet_01v8 L=0.5u W=1u
M7785 o6 ibias vss vss sky130_fd_pr__nfet_01v8 L=0.5u W=1u
M7786 o6 ibias vss vss sky130_fd_pr__nfet_01v8 L=0.5u W=1u
M7787 o6 ibias vss vss sky130_fd_pr__nfet_01v8 L=0.5u W=1u
M7788 o6 ibias vss vss sky130_fd_pr__nfet_01v8 L=0.5u W=1u
M7789 o6 ibias vss vss sky130_fd_pr__nfet_01v8 L=0.5u W=1u
M7790 o6 ibias vss vss sky130_fd_pr__nfet_01v8 L=0.5u W=1u
M7791 o6 ibias vss vss sky130_fd_pr__nfet_01v8 L=0.5u W=1u
M7792 o6 ibias vss vss sky130_fd_pr__nfet_01v8 L=0.5u W=1u
M7793 o6 ibias vss vss sky130_fd_pr__nfet_01v8 L=0.5u W=1u
M7794 o6 ibias vss vss sky130_fd_pr__nfet_01v8 L=0.5u W=1u
M7795 o6 ibias vss vss sky130_fd_pr__nfet_01v8 L=0.5u W=1u
M7796 o6 ibias vss vss sky130_fd_pr__nfet_01v8 L=0.5u W=1u
M7797 o6 ibias vss vss sky130_fd_pr__nfet_01v8 L=0.5u W=1u
M7798 o6 ibias vss vss sky130_fd_pr__nfet_01v8 L=0.5u W=1u
M7799 o6 ibias vss vss sky130_fd_pr__nfet_01v8 L=0.5u W=1u
M7800 o6 ibias vss vss sky130_fd_pr__nfet_01v8 L=0.5u W=1u
M7801 o6 ibias vss vss sky130_fd_pr__nfet_01v8 L=0.5u W=1u
M7802 o6 ibias vss vss sky130_fd_pr__nfet_01v8 L=0.5u W=1u
M7803 o6 ibias vss vss sky130_fd_pr__nfet_01v8 L=0.5u W=1u
M7804 o6 ibias vss vss sky130_fd_pr__nfet_01v8 L=0.5u W=1u
M7805 o6 ibias vss vss sky130_fd_pr__nfet_01v8 L=0.5u W=1u
M7806 o6 ibias vss vss sky130_fd_pr__nfet_01v8 L=0.5u W=1u
M7807 o6 ibias vss vss sky130_fd_pr__nfet_01v8 L=0.5u W=1u
M7808 o6 ibias vss vss sky130_fd_pr__nfet_01v8 L=0.5u W=1u
M7809 o6 ibias vss vss sky130_fd_pr__nfet_01v8 L=0.5u W=1u
M7810 o6 ibias vss vss sky130_fd_pr__nfet_01v8 L=0.5u W=1u
M7811 o6 ibias vss vss sky130_fd_pr__nfet_01v8 L=0.5u W=1u
M7812 o6 ibias vss vss sky130_fd_pr__nfet_01v8 L=0.5u W=1u
M7813 o6 ibias vss vss sky130_fd_pr__nfet_01v8 L=0.5u W=1u
M7814 o6 ibias vss vss sky130_fd_pr__nfet_01v8 L=0.5u W=1u
M7815 o6 ibias vss vss sky130_fd_pr__nfet_01v8 L=0.5u W=1u
M7816 o6 ibias vss vss sky130_fd_pr__nfet_01v8 L=0.5u W=1u
M7817 o6 ibias vss vss sky130_fd_pr__nfet_01v8 L=0.5u W=1u
M7818 o6 ibias vss vss sky130_fd_pr__nfet_01v8 L=0.5u W=1u
M7819 o6 ibias vss vss sky130_fd_pr__nfet_01v8 L=0.5u W=1u
M7820 o6 ibias vss vss sky130_fd_pr__nfet_01v8 L=0.5u W=1u
M7821 o6 ibias vss vss sky130_fd_pr__nfet_01v8 L=0.5u W=1u
M7822 o6 ibias vss vss sky130_fd_pr__nfet_01v8 L=0.5u W=1u
M7823 o6 ibias vss vss sky130_fd_pr__nfet_01v8 L=0.5u W=1u
M7824 o6 ibias vss vss sky130_fd_pr__nfet_01v8 L=0.5u W=1u
M7825 o6 ibias vss vss sky130_fd_pr__nfet_01v8 L=0.5u W=1u
M7826 o6 ibias vss vss sky130_fd_pr__nfet_01v8 L=0.5u W=1u
M7827 o6 ibias vss vss sky130_fd_pr__nfet_01v8 L=0.5u W=1u
M7828 o6 ibias vss vss sky130_fd_pr__nfet_01v8 L=0.5u W=1u
M7829 o6 ibias vss vss sky130_fd_pr__nfet_01v8 L=0.5u W=1u
M7830 o6 ibias vss vss sky130_fd_pr__nfet_01v8 L=0.5u W=1u
M7831 o6 ibias vss vss sky130_fd_pr__nfet_01v8 L=0.5u W=1u
M7832 o6 ibias vss vss sky130_fd_pr__nfet_01v8 L=0.5u W=1u
M7833 o6 ibias vss vss sky130_fd_pr__nfet_01v8 L=0.5u W=1u
M7834 o6 ibias vss vss sky130_fd_pr__nfet_01v8 L=0.5u W=1u
M7835 o6 ibias vss vss sky130_fd_pr__nfet_01v8 L=0.5u W=1u
M7836 o6 ibias vss vss sky130_fd_pr__nfet_01v8 L=0.5u W=1u
M7837 o6 ibias vss vss sky130_fd_pr__nfet_01v8 L=0.5u W=1u
M7838 o6 ibias vss vss sky130_fd_pr__nfet_01v8 L=0.5u W=1u
M7839 o6 ibias vss vss sky130_fd_pr__nfet_01v8 L=0.5u W=1u
M7840 o6 ibias vss vss sky130_fd_pr__nfet_01v8 L=0.5u W=1u
M7841 o6 ibias vss vss sky130_fd_pr__nfet_01v8 L=0.5u W=1u
M7842 o6 ibias vss vss sky130_fd_pr__nfet_01v8 L=0.5u W=1u
M7843 o6 ibias vss vss sky130_fd_pr__nfet_01v8 L=0.5u W=1u
M7844 o6 ibias vss vss sky130_fd_pr__nfet_01v8 L=0.5u W=1u
M7845 o6 ibias vss vss sky130_fd_pr__nfet_01v8 L=0.5u W=1u
M7846 o6 ibias vss vss sky130_fd_pr__nfet_01v8 L=0.5u W=1u
M7847 o6 ibias vss vss sky130_fd_pr__nfet_01v8 L=0.5u W=1u
M7848 o6 ibias vss vss sky130_fd_pr__nfet_01v8 L=0.5u W=1u
M7849 o6 ibias vss vss sky130_fd_pr__nfet_01v8 L=0.5u W=1u
M7850 o6 ibias vss vss sky130_fd_pr__nfet_01v8 L=0.5u W=1u
M7851 o6 ibias vss vss sky130_fd_pr__nfet_01v8 L=0.5u W=1u
M7852 o6 ibias vss vss sky130_fd_pr__nfet_01v8 L=0.5u W=1u
M7853 o6 ibias vss vss sky130_fd_pr__nfet_01v8 L=0.5u W=1u
M7854 o6 ibias vss vss sky130_fd_pr__nfet_01v8 L=0.5u W=1u
M7855 o6 ibias vss vss sky130_fd_pr__nfet_01v8 L=0.5u W=1u
M7856 o6 ibias vss vss sky130_fd_pr__nfet_01v8 L=0.5u W=1u
M7857 o6 ibias vss vss sky130_fd_pr__nfet_01v8 L=0.5u W=1u
M7858 o6 ibias vss vss sky130_fd_pr__nfet_01v8 L=0.5u W=1u
M7859 o6 ibias vss vss sky130_fd_pr__nfet_01v8 L=0.5u W=1u
M7860 o6 ibias vss vss sky130_fd_pr__nfet_01v8 L=0.5u W=1u
M7861 o6 ibias vss vss sky130_fd_pr__nfet_01v8 L=0.5u W=1u
M7862 o6 ibias vss vss sky130_fd_pr__nfet_01v8 L=0.5u W=1u
M7863 o6 ibias vss vss sky130_fd_pr__nfet_01v8 L=0.5u W=1u
M7864 o6 ibias vss vss sky130_fd_pr__nfet_01v8 L=0.5u W=1u
M7865 o6 ibias vss vss sky130_fd_pr__nfet_01v8 L=0.5u W=1u
M7866 o6 ibias vss vss sky130_fd_pr__nfet_01v8 L=0.5u W=1u
M7867 o6 ibias vss vss sky130_fd_pr__nfet_01v8 L=0.5u W=1u
M7868 o6 ibias vss vss sky130_fd_pr__nfet_01v8 L=0.5u W=1u
M7869 o6 ibias vss vss sky130_fd_pr__nfet_01v8 L=0.5u W=1u
M7870 o6 ibias vss vss sky130_fd_pr__nfet_01v8 L=0.5u W=1u
M7871 o6 ibias vss vss sky130_fd_pr__nfet_01v8 L=0.5u W=1u
M7872 o6 ibias vss vss sky130_fd_pr__nfet_01v8 L=0.5u W=1u
M7873 o6 ibias vss vss sky130_fd_pr__nfet_01v8 L=0.5u W=1u
M7874 o6 ibias vss vss sky130_fd_pr__nfet_01v8 L=0.5u W=1u
M7875 o6 ibias vss vss sky130_fd_pr__nfet_01v8 L=0.5u W=1u
M7876 o6 ibias vss vss sky130_fd_pr__nfet_01v8 L=0.5u W=1u
M7877 o6 ibias vss vss sky130_fd_pr__nfet_01v8 L=0.5u W=1u
M7878 o6 ibias vss vss sky130_fd_pr__nfet_01v8 L=0.5u W=1u
M7879 o6 ibias vss vss sky130_fd_pr__nfet_01v8 L=0.5u W=1u
M7880 o6 ibias vss vss sky130_fd_pr__nfet_01v8 L=0.5u W=1u
M7881 o6 ibias vss vss sky130_fd_pr__nfet_01v8 L=0.5u W=1u
M7882 o6 ibias vss vss sky130_fd_pr__nfet_01v8 L=0.5u W=1u
M7883 o6 ibias vss vss sky130_fd_pr__nfet_01v8 L=0.5u W=1u
M7884 o6 ibias vss vss sky130_fd_pr__nfet_01v8 L=0.5u W=1u
M7885 o6 ibias vss vss sky130_fd_pr__nfet_01v8 L=0.5u W=1u
M7886 o6 ibias vss vss sky130_fd_pr__nfet_01v8 L=0.5u W=1u
M7887 o6 ibias vss vss sky130_fd_pr__nfet_01v8 L=0.5u W=1u
M7888 o6 ibias vss vss sky130_fd_pr__nfet_01v8 L=0.5u W=1u
M7889 o6 ibias vss vss sky130_fd_pr__nfet_01v8 L=0.5u W=1u
M7890 o6 ibias vss vss sky130_fd_pr__nfet_01v8 L=0.5u W=1u
M7891 o6 ibias vss vss sky130_fd_pr__nfet_01v8 L=0.5u W=1u
M7892 o6 ibias vss vss sky130_fd_pr__nfet_01v8 L=0.5u W=1u
M7893 o6 ibias vss vss sky130_fd_pr__nfet_01v8 L=0.5u W=1u
M7894 o6 ibias vss vss sky130_fd_pr__nfet_01v8 L=0.5u W=1u
M7895 o6 ibias vss vss sky130_fd_pr__nfet_01v8 L=0.5u W=1u
M7896 o6 ibias vss vss sky130_fd_pr__nfet_01v8 L=0.5u W=1u
M7897 o6 ibias vss vss sky130_fd_pr__nfet_01v8 L=0.5u W=1u
M7898 o6 ibias vss vss sky130_fd_pr__nfet_01v8 L=0.5u W=1u
M7899 o6 ibias vss vss sky130_fd_pr__nfet_01v8 L=0.5u W=1u
M7900 o6 ibias vss vss sky130_fd_pr__nfet_01v8 L=0.5u W=1u
M7901 o6 ibias vss vss sky130_fd_pr__nfet_01v8 L=0.5u W=1u
M7902 o6 ibias vss vss sky130_fd_pr__nfet_01v8 L=0.5u W=1u
M7903 o6 ibias vss vss sky130_fd_pr__nfet_01v8 L=0.5u W=1u
M7904 o6 ibias vss vss sky130_fd_pr__nfet_01v8 L=0.5u W=1u
M7905 o6 ibias vss vss sky130_fd_pr__nfet_01v8 L=0.5u W=1u
M7906 o6 ibias vss vss sky130_fd_pr__nfet_01v8 L=0.5u W=1u
M7907 o6 ibias vss vss sky130_fd_pr__nfet_01v8 L=0.5u W=1u
M7908 o6 ibias vss vss sky130_fd_pr__nfet_01v8 L=0.5u W=1u
M7909 o6 ibias vss vss sky130_fd_pr__nfet_01v8 L=0.5u W=1u
M7910 o6 ibias vss vss sky130_fd_pr__nfet_01v8 L=0.5u W=1u
M7911 o6 ibias vss vss sky130_fd_pr__nfet_01v8 L=0.5u W=1u
M7912 o6 ibias vss vss sky130_fd_pr__nfet_01v8 L=0.5u W=1u
M7913 o6 ibias vss vss sky130_fd_pr__nfet_01v8 L=0.5u W=1u
M7914 o6 ibias vss vss sky130_fd_pr__nfet_01v8 L=0.5u W=1u
M7915 o6 ibias vss vss sky130_fd_pr__nfet_01v8 L=0.5u W=1u
M7916 o6 ibias vss vss sky130_fd_pr__nfet_01v8 L=0.5u W=1u
M7917 o6 ibias vss vss sky130_fd_pr__nfet_01v8 L=0.5u W=1u
M7918 o6 ibias vss vss sky130_fd_pr__nfet_01v8 L=0.5u W=1u
M7919 o6 ibias vss vss sky130_fd_pr__nfet_01v8 L=0.5u W=1u
M7920 o6 ibias vss vss sky130_fd_pr__nfet_01v8 L=0.5u W=1u
M7921 o6 ibias vss vss sky130_fd_pr__nfet_01v8 L=0.5u W=1u
M7922 o6 ibias vss vss sky130_fd_pr__nfet_01v8 L=0.5u W=1u
M7923 o6 ibias vss vss sky130_fd_pr__nfet_01v8 L=0.5u W=1u
M7924 o6 ibias vss vss sky130_fd_pr__nfet_01v8 L=0.5u W=1u
M7925 o6 ibias vss vss sky130_fd_pr__nfet_01v8 L=0.5u W=1u
M7926 o6 ibias vss vss sky130_fd_pr__nfet_01v8 L=0.5u W=1u
M7927 o6 ibias vss vss sky130_fd_pr__nfet_01v8 L=0.5u W=1u
M7928 o6 ibias vss vss sky130_fd_pr__nfet_01v8 L=0.5u W=1u
M7929 o6 ibias vss vss sky130_fd_pr__nfet_01v8 L=0.5u W=1u
M7930 o6 ibias vss vss sky130_fd_pr__nfet_01v8 L=0.5u W=1u
M7931 o6 ibias vss vss sky130_fd_pr__nfet_01v8 L=0.5u W=1u
M7932 o6 ibias vss vss sky130_fd_pr__nfet_01v8 L=0.5u W=1u
M7933 o6 ibias vss vss sky130_fd_pr__nfet_01v8 L=0.5u W=1u
M7934 o6 ibias vss vss sky130_fd_pr__nfet_01v8 L=0.5u W=1u
M7935 o6 ibias vss vss sky130_fd_pr__nfet_01v8 L=0.5u W=1u
M7936 o6 ibias vss vss sky130_fd_pr__nfet_01v8 L=0.5u W=1u
M7937 o6 ibias vss vss sky130_fd_pr__nfet_01v8 L=0.5u W=1u
M7938 o6 ibias vss vss sky130_fd_pr__nfet_01v8 L=0.5u W=1u
M7939 o6 ibias vss vss sky130_fd_pr__nfet_01v8 L=0.5u W=1u
M7940 o6 ibias vss vss sky130_fd_pr__nfet_01v8 L=0.5u W=1u
M7941 o6 ibias vss vss sky130_fd_pr__nfet_01v8 L=0.5u W=1u
M7942 o6 ibias vss vss sky130_fd_pr__nfet_01v8 L=0.5u W=1u
M7943 o6 ibias vss vss sky130_fd_pr__nfet_01v8 L=0.5u W=1u
M7944 o6 ibias vss vss sky130_fd_pr__nfet_01v8 L=0.5u W=1u
M7945 o6 ibias vss vss sky130_fd_pr__nfet_01v8 L=0.5u W=1u
M7946 o6 ibias vss vss sky130_fd_pr__nfet_01v8 L=0.5u W=1u
M7947 o6 ibias vss vss sky130_fd_pr__nfet_01v8 L=0.5u W=1u
M7948 o6 ibias vss vss sky130_fd_pr__nfet_01v8 L=0.5u W=1u
M7949 o6 ibias vss vss sky130_fd_pr__nfet_01v8 L=0.5u W=1u
M7950 o6 ibias vss vss sky130_fd_pr__nfet_01v8 L=0.5u W=1u
M7951 o6 ibias vss vss sky130_fd_pr__nfet_01v8 L=0.5u W=1u
M7952 o6 ibias vss vss sky130_fd_pr__nfet_01v8 L=0.5u W=1u
M7953 o6 ibias vss vss sky130_fd_pr__nfet_01v8 L=0.5u W=1u
M7954 o6 ibias vss vss sky130_fd_pr__nfet_01v8 L=0.5u W=1u
M7955 o6 ibias vss vss sky130_fd_pr__nfet_01v8 L=0.5u W=1u
M7956 o6 ibias vss vss sky130_fd_pr__nfet_01v8 L=0.5u W=1u
M7957 o6 ibias vss vss sky130_fd_pr__nfet_01v8 L=0.5u W=1u
M7958 o6 ibias vss vss sky130_fd_pr__nfet_01v8 L=0.5u W=1u
M7959 o6 ibias vss vss sky130_fd_pr__nfet_01v8 L=0.5u W=1u
M7960 o6 ibias vss vss sky130_fd_pr__nfet_01v8 L=0.5u W=1u
M7961 o6 ibias vss vss sky130_fd_pr__nfet_01v8 L=0.5u W=1u
M7962 o6 ibias vss vss sky130_fd_pr__nfet_01v8 L=0.5u W=1u
M7963 o6 ibias vss vss sky130_fd_pr__nfet_01v8 L=0.5u W=1u
M7964 o6 ibias vss vss sky130_fd_pr__nfet_01v8 L=0.5u W=1u
M7965 o6 ibias vss vss sky130_fd_pr__nfet_01v8 L=0.5u W=1u
M7966 o6 ibias vss vss sky130_fd_pr__nfet_01v8 L=0.5u W=1u
M7967 o6 ibias vss vss sky130_fd_pr__nfet_01v8 L=0.5u W=1u
M7968 o6 ibias vss vss sky130_fd_pr__nfet_01v8 L=0.5u W=1u
M7969 o6 ibias vss vss sky130_fd_pr__nfet_01v8 L=0.5u W=1u
M7970 o6 ibias vss vss sky130_fd_pr__nfet_01v8 L=0.5u W=1u
M7971 o6 ibias vss vss sky130_fd_pr__nfet_01v8 L=0.5u W=1u
M7972 o6 ibias vss vss sky130_fd_pr__nfet_01v8 L=0.5u W=1u
M7973 o6 ibias vss vss sky130_fd_pr__nfet_01v8 L=0.5u W=1u
M7974 o6 ibias vss vss sky130_fd_pr__nfet_01v8 L=0.5u W=1u
M7975 o6 ibias vss vss sky130_fd_pr__nfet_01v8 L=0.5u W=1u
M7976 o6 ibias vss vss sky130_fd_pr__nfet_01v8 L=0.5u W=1u
M7977 o6 ibias vss vss sky130_fd_pr__nfet_01v8 L=0.5u W=1u
M7978 o6 ibias vss vss sky130_fd_pr__nfet_01v8 L=0.5u W=1u
M7979 o6 ibias vss vss sky130_fd_pr__nfet_01v8 L=0.5u W=1u
M7980 o6 ibias vss vss sky130_fd_pr__nfet_01v8 L=0.5u W=1u
M7981 o6 ibias vss vss sky130_fd_pr__nfet_01v8 L=0.5u W=1u
M7982 o6 ibias vss vss sky130_fd_pr__nfet_01v8 L=0.5u W=1u
M7983 o6 ibias vss vss sky130_fd_pr__nfet_01v8 L=0.5u W=1u
M7984 o6 ibias vss vss sky130_fd_pr__nfet_01v8 L=0.5u W=1u
M7985 o6 ibias vss vss sky130_fd_pr__nfet_01v8 L=0.5u W=1u
M7986 o6 ibias vss vss sky130_fd_pr__nfet_01v8 L=0.5u W=1u
M7987 o6 ibias vss vss sky130_fd_pr__nfet_01v8 L=0.5u W=1u
M7988 o6 ibias vss vss sky130_fd_pr__nfet_01v8 L=0.5u W=1u
M7989 o6 ibias vss vss sky130_fd_pr__nfet_01v8 L=0.5u W=1u
M7990 o6 ibias vss vss sky130_fd_pr__nfet_01v8 L=0.5u W=1u
M7991 o6 ibias vss vss sky130_fd_pr__nfet_01v8 L=0.5u W=1u
M7992 o6 ibias vss vss sky130_fd_pr__nfet_01v8 L=0.5u W=1u
M7993 o6 ibias vss vss sky130_fd_pr__nfet_01v8 L=0.5u W=1u
M7994 o6 ibias vss vss sky130_fd_pr__nfet_01v8 L=0.5u W=1u
M7995 o6 ibias vss vss sky130_fd_pr__nfet_01v8 L=0.5u W=1u
M7996 o6 ibias vss vss sky130_fd_pr__nfet_01v8 L=0.5u W=1u
M7997 o6 ibias vss vss sky130_fd_pr__nfet_01v8 L=0.5u W=1u
M7998 o6 ibias vss vss sky130_fd_pr__nfet_01v8 L=0.5u W=1u
M7999 o6 ibias vss vss sky130_fd_pr__nfet_01v8 L=0.5u W=1u
M8000 o6 ibias vss vss sky130_fd_pr__nfet_01v8 L=0.5u W=1u
M8001 o6 ibias vss vss sky130_fd_pr__nfet_01v8 L=0.5u W=1u
M8002 o6 ibias vss vss sky130_fd_pr__nfet_01v8 L=0.5u W=1u
M8003 o6 ibias vss vss sky130_fd_pr__nfet_01v8 L=0.5u W=1u
M8004 o6 ibias vss vss sky130_fd_pr__nfet_01v8 L=0.5u W=1u
M8005 o6 ibias vss vss sky130_fd_pr__nfet_01v8 L=0.5u W=1u
M8006 o6 ibias vss vss sky130_fd_pr__nfet_01v8 L=0.5u W=1u
M8007 o6 ibias vss vss sky130_fd_pr__nfet_01v8 L=0.5u W=1u
M8008 o6 ibias vss vss sky130_fd_pr__nfet_01v8 L=0.5u W=1u
M8009 o6 ibias vss vss sky130_fd_pr__nfet_01v8 L=0.5u W=1u
M8010 o6 ibias vss vss sky130_fd_pr__nfet_01v8 L=0.5u W=1u
M8011 o6 ibias vss vss sky130_fd_pr__nfet_01v8 L=0.5u W=1u
M8012 o6 ibias vss vss sky130_fd_pr__nfet_01v8 L=0.5u W=1u
M8013 o6 ibias vss vss sky130_fd_pr__nfet_01v8 L=0.5u W=1u
M8014 o6 ibias vss vss sky130_fd_pr__nfet_01v8 L=0.5u W=1u
M8015 o6 ibias vss vss sky130_fd_pr__nfet_01v8 L=0.5u W=1u
M8016 o6 ibias vss vss sky130_fd_pr__nfet_01v8 L=0.5u W=1u
M8017 o6 ibias vss vss sky130_fd_pr__nfet_01v8 L=0.5u W=1u
M8018 o6 ibias vss vss sky130_fd_pr__nfet_01v8 L=0.5u W=1u
M8019 o6 ibias vss vss sky130_fd_pr__nfet_01v8 L=0.5u W=1u
M8020 o6 ibias vss vss sky130_fd_pr__nfet_01v8 L=0.5u W=1u
M8021 o6 ibias vss vss sky130_fd_pr__nfet_01v8 L=0.5u W=1u
M8022 o6 ibias vss vss sky130_fd_pr__nfet_01v8 L=0.5u W=1u
M8023 o6 ibias vss vss sky130_fd_pr__nfet_01v8 L=0.5u W=1u
M8024 o6 ibias vss vss sky130_fd_pr__nfet_01v8 L=0.5u W=1u
M8025 o6 ibias vss vss sky130_fd_pr__nfet_01v8 L=0.5u W=1u
M8026 o6 ibias vss vss sky130_fd_pr__nfet_01v8 L=0.5u W=1u
M8027 o6 ibias vss vss sky130_fd_pr__nfet_01v8 L=0.5u W=1u
M8028 o6 ibias vss vss sky130_fd_pr__nfet_01v8 L=0.5u W=1u
M8029 o6 ibias vss vss sky130_fd_pr__nfet_01v8 L=0.5u W=1u
M8030 o6 ibias vss vss sky130_fd_pr__nfet_01v8 L=0.5u W=1u
M8031 o6 ibias vss vss sky130_fd_pr__nfet_01v8 L=0.5u W=1u
M8032 o6 ibias vss vss sky130_fd_pr__nfet_01v8 L=0.5u W=1u
M8033 o6 ibias vss vss sky130_fd_pr__nfet_01v8 L=0.5u W=1u
M8034 o6 ibias vss vss sky130_fd_pr__nfet_01v8 L=0.5u W=1u
M8035 o6 ibias vss vss sky130_fd_pr__nfet_01v8 L=0.5u W=1u
M8036 o6 ibias vss vss sky130_fd_pr__nfet_01v8 L=0.5u W=1u
M8037 o6 ibias vss vss sky130_fd_pr__nfet_01v8 L=0.5u W=1u
M8038 o6 ibias vss vss sky130_fd_pr__nfet_01v8 L=0.5u W=1u
M8039 o6 ibias vss vss sky130_fd_pr__nfet_01v8 L=0.5u W=1u
M8040 o6 ibias vss vss sky130_fd_pr__nfet_01v8 L=0.5u W=1u
M8041 o6 ibias vss vss sky130_fd_pr__nfet_01v8 L=0.5u W=1u
M8042 o6 ibias vss vss sky130_fd_pr__nfet_01v8 L=0.5u W=1u
M8043 o6 ibias vss vss sky130_fd_pr__nfet_01v8 L=0.5u W=1u
M8044 o6 ibias vss vss sky130_fd_pr__nfet_01v8 L=0.5u W=1u
M8045 o6 ibias vss vss sky130_fd_pr__nfet_01v8 L=0.5u W=1u
M8046 o6 ibias vss vss sky130_fd_pr__nfet_01v8 L=0.5u W=1u
M8047 o6 ibias vss vss sky130_fd_pr__nfet_01v8 L=0.5u W=1u
M8048 o6 ibias vss vss sky130_fd_pr__nfet_01v8 L=0.5u W=1u
M8049 o6 ibias vss vss sky130_fd_pr__nfet_01v8 L=0.5u W=1u
M8050 o6 ibias vss vss sky130_fd_pr__nfet_01v8 L=0.5u W=1u
M8051 o6 ibias vss vss sky130_fd_pr__nfet_01v8 L=0.5u W=1u
M8052 o6 ibias vss vss sky130_fd_pr__nfet_01v8 L=0.5u W=1u
M8053 o6 ibias vss vss sky130_fd_pr__nfet_01v8 L=0.5u W=1u
M8054 o6 ibias vss vss sky130_fd_pr__nfet_01v8 L=0.5u W=1u
M8055 o6 ibias vss vss sky130_fd_pr__nfet_01v8 L=0.5u W=1u
M8056 o6 ibias vss vss sky130_fd_pr__nfet_01v8 L=0.5u W=1u
M8057 o6 ibias vss vss sky130_fd_pr__nfet_01v8 L=0.5u W=1u
M8058 o6 ibias vss vss sky130_fd_pr__nfet_01v8 L=0.5u W=1u
M8059 o6 ibias vss vss sky130_fd_pr__nfet_01v8 L=0.5u W=1u
M8060 o6 ibias vss vss sky130_fd_pr__nfet_01v8 L=0.5u W=1u
M8061 o6 ibias vss vss sky130_fd_pr__nfet_01v8 L=0.5u W=1u
M8062 o6 ibias vss vss sky130_fd_pr__nfet_01v8 L=0.5u W=1u
M8063 o6 ibias vss vss sky130_fd_pr__nfet_01v8 L=0.5u W=1u
M8064 o6 ibias vss vss sky130_fd_pr__nfet_01v8 L=0.5u W=1u
M8065 o6 ibias vss vss sky130_fd_pr__nfet_01v8 L=0.5u W=1u
M8066 o6 ibias vss vss sky130_fd_pr__nfet_01v8 L=0.5u W=1u
M8067 o6 ibias vss vss sky130_fd_pr__nfet_01v8 L=0.5u W=1u
M8068 o6 ibias vss vss sky130_fd_pr__nfet_01v8 L=0.5u W=1u
M8069 o6 ibias vss vss sky130_fd_pr__nfet_01v8 L=0.5u W=1u
M8070 o6 ibias vss vss sky130_fd_pr__nfet_01v8 L=0.5u W=1u
M8071 o6 ibias vss vss sky130_fd_pr__nfet_01v8 L=0.5u W=1u
M8072 o6 ibias vss vss sky130_fd_pr__nfet_01v8 L=0.5u W=1u
M8073 o6 ibias vss vss sky130_fd_pr__nfet_01v8 L=0.5u W=1u
M8074 o6 ibias vss vss sky130_fd_pr__nfet_01v8 L=0.5u W=1u
M8075 o6 ibias vss vss sky130_fd_pr__nfet_01v8 L=0.5u W=1u
M8076 o6 ibias vss vss sky130_fd_pr__nfet_01v8 L=0.5u W=1u
M8077 o6 ibias vss vss sky130_fd_pr__nfet_01v8 L=0.5u W=1u
M8078 o6 ibias vss vss sky130_fd_pr__nfet_01v8 L=0.5u W=1u
M8079 o6 ibias vss vss sky130_fd_pr__nfet_01v8 L=0.5u W=1u
M8080 o6 ibias vss vss sky130_fd_pr__nfet_01v8 L=0.5u W=1u
M8081 o6 ibias vss vss sky130_fd_pr__nfet_01v8 L=0.5u W=1u
M8082 o6 ibias vss vss sky130_fd_pr__nfet_01v8 L=0.5u W=1u
M8083 o6 ibias vss vss sky130_fd_pr__nfet_01v8 L=0.5u W=1u
M8084 o6 ibias vss vss sky130_fd_pr__nfet_01v8 L=0.5u W=1u
M8085 o6 ibias vss vss sky130_fd_pr__nfet_01v8 L=0.5u W=1u
M8086 o6 ibias vss vss sky130_fd_pr__nfet_01v8 L=0.5u W=1u
M8087 o6 ibias vss vss sky130_fd_pr__nfet_01v8 L=0.5u W=1u
M8088 o6 ibias vss vss sky130_fd_pr__nfet_01v8 L=0.5u W=1u
M8089 o6 ibias vss vss sky130_fd_pr__nfet_01v8 L=0.5u W=1u
M8090 o6 ibias vss vss sky130_fd_pr__nfet_01v8 L=0.5u W=1u
M8091 o6 ibias vss vss sky130_fd_pr__nfet_01v8 L=0.5u W=1u
M8092 o6 ibias vss vss sky130_fd_pr__nfet_01v8 L=0.5u W=1u
M8093 o6 ibias vss vss sky130_fd_pr__nfet_01v8 L=0.5u W=1u
M8094 o6 ibias vss vss sky130_fd_pr__nfet_01v8 L=0.5u W=1u
M8095 o6 ibias vss vss sky130_fd_pr__nfet_01v8 L=0.5u W=1u
M8096 o6 ibias vss vss sky130_fd_pr__nfet_01v8 L=0.5u W=1u
M8097 o6 ibias vss vss sky130_fd_pr__nfet_01v8 L=0.5u W=1u
M8098 o6 ibias vss vss sky130_fd_pr__nfet_01v8 L=0.5u W=1u
M8099 o6 ibias vss vss sky130_fd_pr__nfet_01v8 L=0.5u W=1u
M8100 o6 ibias vss vss sky130_fd_pr__nfet_01v8 L=0.5u W=1u
M8101 o6 ibias vss vss sky130_fd_pr__nfet_01v8 L=0.5u W=1u
M8102 o6 ibias vss vss sky130_fd_pr__nfet_01v8 L=0.5u W=1u
M8103 o6 ibias vss vss sky130_fd_pr__nfet_01v8 L=0.5u W=1u
M8104 o6 ibias vss vss sky130_fd_pr__nfet_01v8 L=0.5u W=1u
M8105 o6 ibias vss vss sky130_fd_pr__nfet_01v8 L=0.5u W=1u
M8106 o6 ibias vss vss sky130_fd_pr__nfet_01v8 L=0.5u W=1u
M8107 o6 ibias vss vss sky130_fd_pr__nfet_01v8 L=0.5u W=1u
M8108 o6 ibias vss vss sky130_fd_pr__nfet_01v8 L=0.5u W=1u
M8109 o6 ibias vss vss sky130_fd_pr__nfet_01v8 L=0.5u W=1u
M8110 o6 ibias vss vss sky130_fd_pr__nfet_01v8 L=0.5u W=1u
M8111 o6 ibias vss vss sky130_fd_pr__nfet_01v8 L=0.5u W=1u
M8112 o6 ibias vss vss sky130_fd_pr__nfet_01v8 L=0.5u W=1u
M8113 o6 ibias vss vss sky130_fd_pr__nfet_01v8 L=0.5u W=1u
M8114 o6 ibias vss vss sky130_fd_pr__nfet_01v8 L=0.5u W=1u
M8115 o6 ibias vss vss sky130_fd_pr__nfet_01v8 L=0.5u W=1u
M8116 o6 ibias vss vss sky130_fd_pr__nfet_01v8 L=0.5u W=1u
M8117 o6 ibias vss vss sky130_fd_pr__nfet_01v8 L=0.5u W=1u
M8118 o6 ibias vss vss sky130_fd_pr__nfet_01v8 L=0.5u W=1u
M8119 o6 ibias vss vss sky130_fd_pr__nfet_01v8 L=0.5u W=1u
M8120 o6 ibias vss vss sky130_fd_pr__nfet_01v8 L=0.5u W=1u
M8121 o6 ibias vss vss sky130_fd_pr__nfet_01v8 L=0.5u W=1u
M8122 o6 ibias vss vss sky130_fd_pr__nfet_01v8 L=0.5u W=1u
M8123 o6 ibias vss vss sky130_fd_pr__nfet_01v8 L=0.5u W=1u
M8124 o6 ibias vss vss sky130_fd_pr__nfet_01v8 L=0.5u W=1u
M8125 o6 ibias vss vss sky130_fd_pr__nfet_01v8 L=0.5u W=1u
M8126 o6 ibias vss vss sky130_fd_pr__nfet_01v8 L=0.5u W=1u
M8127 o6 ibias vss vss sky130_fd_pr__nfet_01v8 L=0.5u W=1u
M8128 o6 ibias vss vss sky130_fd_pr__nfet_01v8 L=0.5u W=1u
M8129 o6 ibias vss vss sky130_fd_pr__nfet_01v8 L=0.5u W=1u
M8130 o6 ibias vss vss sky130_fd_pr__nfet_01v8 L=0.5u W=1u
M8131 o6 ibias vss vss sky130_fd_pr__nfet_01v8 L=0.5u W=1u
M8132 o6 ibias vss vss sky130_fd_pr__nfet_01v8 L=0.5u W=1u
M8133 o6 ibias vss vss sky130_fd_pr__nfet_01v8 L=0.5u W=1u
M8134 o6 ibias vss vss sky130_fd_pr__nfet_01v8 L=0.5u W=1u
M8135 o6 ibias vss vss sky130_fd_pr__nfet_01v8 L=0.5u W=1u
M8136 o6 ibias vss vss sky130_fd_pr__nfet_01v8 L=0.5u W=1u
M8137 o6 ibias vss vss sky130_fd_pr__nfet_01v8 L=0.5u W=1u
M8138 o6 ibias vss vss sky130_fd_pr__nfet_01v8 L=0.5u W=1u
M8139 o6 ibias vss vss sky130_fd_pr__nfet_01v8 L=0.5u W=1u
M8140 o6 ibias vss vss sky130_fd_pr__nfet_01v8 L=0.5u W=1u
M8141 o6 ibias vss vss sky130_fd_pr__nfet_01v8 L=0.5u W=1u
M8142 o6 ibias vss vss sky130_fd_pr__nfet_01v8 L=0.5u W=1u
M8143 o6 ibias vss vss sky130_fd_pr__nfet_01v8 L=0.5u W=1u
M8144 o6 ibias vss vss sky130_fd_pr__nfet_01v8 L=0.5u W=1u
M8145 o6 ibias vss vss sky130_fd_pr__nfet_01v8 L=0.5u W=1u
M8146 o6 ibias vss vss sky130_fd_pr__nfet_01v8 L=0.5u W=1u
M8147 o6 ibias vss vss sky130_fd_pr__nfet_01v8 L=0.5u W=1u
M8148 o6 ibias vss vss sky130_fd_pr__nfet_01v8 L=0.5u W=1u
M8149 o6 ibias vss vss sky130_fd_pr__nfet_01v8 L=0.5u W=1u
M8150 o6 ibias vss vss sky130_fd_pr__nfet_01v8 L=0.5u W=1u
M8151 o6 ibias vss vss sky130_fd_pr__nfet_01v8 L=0.5u W=1u
M8152 o6 ibias vss vss sky130_fd_pr__nfet_01v8 L=0.5u W=1u
M8153 o6 ibias vss vss sky130_fd_pr__nfet_01v8 L=0.5u W=1u
M8154 o6 ibias vss vss sky130_fd_pr__nfet_01v8 L=0.5u W=1u
M8155 o6 ibias vss vss sky130_fd_pr__nfet_01v8 L=0.5u W=1u
M8156 o6 ibias vss vss sky130_fd_pr__nfet_01v8 L=0.5u W=1u
M8157 o6 ibias vss vss sky130_fd_pr__nfet_01v8 L=0.5u W=1u
M8158 o6 ibias vss vss sky130_fd_pr__nfet_01v8 L=0.5u W=1u
M8159 o6 ibias vss vss sky130_fd_pr__nfet_01v8 L=0.5u W=1u
M8160 o6 ibias vss vss sky130_fd_pr__nfet_01v8 L=0.5u W=1u
M8161 o6 ibias vss vss sky130_fd_pr__nfet_01v8 L=0.5u W=1u
M8162 o6 ibias vss vss sky130_fd_pr__nfet_01v8 L=0.5u W=1u
M8163 o6 ibias vss vss sky130_fd_pr__nfet_01v8 L=0.5u W=1u
M8164 o6 ibias vss vss sky130_fd_pr__nfet_01v8 L=0.5u W=1u
M8165 o6 ibias vss vss sky130_fd_pr__nfet_01v8 L=0.5u W=1u
M8166 o6 ibias vss vss sky130_fd_pr__nfet_01v8 L=0.5u W=1u
M8167 o6 ibias vss vss sky130_fd_pr__nfet_01v8 L=0.5u W=1u
M8168 o6 ibias vss vss sky130_fd_pr__nfet_01v8 L=0.5u W=1u
M8169 o6 ibias vss vss sky130_fd_pr__nfet_01v8 L=0.5u W=1u
M8170 o6 ibias vss vss sky130_fd_pr__nfet_01v8 L=0.5u W=1u
M8171 o6 ibias vss vss sky130_fd_pr__nfet_01v8 L=0.5u W=1u
M8172 o6 ibias vss vss sky130_fd_pr__nfet_01v8 L=0.5u W=1u
M8173 o6 ibias vss vss sky130_fd_pr__nfet_01v8 L=0.5u W=1u
M8174 o6 ibias vss vss sky130_fd_pr__nfet_01v8 L=0.5u W=1u
M8175 o6 ibias vss vss sky130_fd_pr__nfet_01v8 L=0.5u W=1u
M8176 o6 ibias vss vss sky130_fd_pr__nfet_01v8 L=0.5u W=1u
M8177 o6 ibias vss vss sky130_fd_pr__nfet_01v8 L=0.5u W=1u
M8178 o6 ibias vss vss sky130_fd_pr__nfet_01v8 L=0.5u W=1u
M8179 o6 ibias vss vss sky130_fd_pr__nfet_01v8 L=0.5u W=1u
M8180 o6 ibias vss vss sky130_fd_pr__nfet_01v8 L=0.5u W=1u
M8181 o6 ibias vss vss sky130_fd_pr__nfet_01v8 L=0.5u W=1u
M8182 o6 ibias vss vss sky130_fd_pr__nfet_01v8 L=0.5u W=1u
M8183 o6 ibias vss vss sky130_fd_pr__nfet_01v8 L=0.5u W=1u
M8184 o6 ibias vss vss sky130_fd_pr__nfet_01v8 L=0.5u W=1u
M8185 o6 ibias vss vss sky130_fd_pr__nfet_01v8 L=0.5u W=1u
M8186 o6 ibias vss vss sky130_fd_pr__nfet_01v8 L=0.5u W=1u
M8187 o6 ibias vss vss sky130_fd_pr__nfet_01v8 L=0.5u W=1u
M8188 o6 ibias vss vss sky130_fd_pr__nfet_01v8 L=0.5u W=1u
M8189 o6 ibias vss vss sky130_fd_pr__nfet_01v8 L=0.5u W=1u
M8190 o6 ibias vss vss sky130_fd_pr__nfet_01v8 L=0.5u W=1u
M8191 o6 ibias vss vss sky130_fd_pr__nfet_01v8 L=0.5u W=1u
M8192 o6 ibias vss vss sky130_fd_pr__nfet_01v8 L=0.5u W=1u
M8193 o6 ibias vss vss sky130_fd_pr__nfet_01v8 L=0.5u W=1u
M8194 o6 ibias vss vss sky130_fd_pr__nfet_01v8 L=0.5u W=1u
M8195 o6 ibias vss vss sky130_fd_pr__nfet_01v8 L=0.5u W=1u
M8196 o6 ibias vss vss sky130_fd_pr__nfet_01v8 L=0.5u W=1u
M8197 o6 ibias vss vss sky130_fd_pr__nfet_01v8 L=0.5u W=1u
M8198 o6 ibias vss vss sky130_fd_pr__nfet_01v8 L=0.5u W=1u
M8199 o6 ibias vss vss sky130_fd_pr__nfet_01v8 L=0.5u W=1u
M8200 o6 ibias vss vss sky130_fd_pr__nfet_01v8 L=0.5u W=1u
M8201 o6 ibias vss vss sky130_fd_pr__nfet_01v8 L=0.5u W=1u
M8202 o6 ibias vss vss sky130_fd_pr__nfet_01v8 L=0.5u W=1u
M8203 o6 ibias vss vss sky130_fd_pr__nfet_01v8 L=0.5u W=1u
M8204 o6 ibias vss vss sky130_fd_pr__nfet_01v8 L=0.5u W=1u
M8205 o6 ibias vss vss sky130_fd_pr__nfet_01v8 L=0.5u W=1u
M8206 o6 ibias vss vss sky130_fd_pr__nfet_01v8 L=0.5u W=1u
M8207 o6 ibias vss vss sky130_fd_pr__nfet_01v8 L=0.5u W=1u
M8208 o6 ibias vss vss sky130_fd_pr__nfet_01v8 L=0.5u W=1u
M8209 o6 ibias vss vss sky130_fd_pr__nfet_01v8 L=0.5u W=1u
M8210 o6 ibias vss vss sky130_fd_pr__nfet_01v8 L=0.5u W=1u
M8211 o6 ibias vss vss sky130_fd_pr__nfet_01v8 L=0.5u W=1u
M8212 o6 ibias vss vss sky130_fd_pr__nfet_01v8 L=0.5u W=1u
M8213 o6 ibias vss vss sky130_fd_pr__nfet_01v8 L=0.5u W=1u
M8214 o6 ibias vss vss sky130_fd_pr__nfet_01v8 L=0.5u W=1u
M8215 o6 ibias vss vss sky130_fd_pr__nfet_01v8 L=0.5u W=1u
M8216 o6 ibias vss vss sky130_fd_pr__nfet_01v8 L=0.5u W=1u
M8217 o6 ibias vss vss sky130_fd_pr__nfet_01v8 L=0.5u W=1u
M8218 o6 ibias vss vss sky130_fd_pr__nfet_01v8 L=0.5u W=1u
M8219 o6 ibias vss vss sky130_fd_pr__nfet_01v8 L=0.5u W=1u
M8220 o6 ibias vss vss sky130_fd_pr__nfet_01v8 L=0.5u W=1u
M8221 o6 ibias vss vss sky130_fd_pr__nfet_01v8 L=0.5u W=1u
M8222 o6 ibias vss vss sky130_fd_pr__nfet_01v8 L=0.5u W=1u
M8223 o6 ibias vss vss sky130_fd_pr__nfet_01v8 L=0.5u W=1u
M8224 o6 ibias vss vss sky130_fd_pr__nfet_01v8 L=0.5u W=1u
M8225 o6 ibias vss vss sky130_fd_pr__nfet_01v8 L=0.5u W=1u
M8226 o6 ibias vss vss sky130_fd_pr__nfet_01v8 L=0.5u W=1u
M8227 o6 ibias vss vss sky130_fd_pr__nfet_01v8 L=0.5u W=1u
M8228 o6 ibias vss vss sky130_fd_pr__nfet_01v8 L=0.5u W=1u
M8229 o6 ibias vss vss sky130_fd_pr__nfet_01v8 L=0.5u W=1u
M8230 o6 ibias vss vss sky130_fd_pr__nfet_01v8 L=0.5u W=1u
M8231 o6 ibias vss vss sky130_fd_pr__nfet_01v8 L=0.5u W=1u
M8232 o6 ibias vss vss sky130_fd_pr__nfet_01v8 L=0.5u W=1u
M8233 o6 ibias vss vss sky130_fd_pr__nfet_01v8 L=0.5u W=1u
M8234 o6 ibias vss vss sky130_fd_pr__nfet_01v8 L=0.5u W=1u
M8235 o6 ibias vss vss sky130_fd_pr__nfet_01v8 L=0.5u W=1u
M8236 o6 ibias vss vss sky130_fd_pr__nfet_01v8 L=0.5u W=1u
M8237 o6 ibias vss vss sky130_fd_pr__nfet_01v8 L=0.5u W=1u
M8238 o6 ibias vss vss sky130_fd_pr__nfet_01v8 L=0.5u W=1u
M8239 o6 ibias vss vss sky130_fd_pr__nfet_01v8 L=0.5u W=1u
M8240 o6 ibias vss vss sky130_fd_pr__nfet_01v8 L=0.5u W=1u
M8241 o6 ibias vss vss sky130_fd_pr__nfet_01v8 L=0.5u W=1u
M8242 o6 ibias vss vss sky130_fd_pr__nfet_01v8 L=0.5u W=1u
M8243 o6 ibias vss vss sky130_fd_pr__nfet_01v8 L=0.5u W=1u
M8244 o6 ibias vss vss sky130_fd_pr__nfet_01v8 L=0.5u W=1u
M8245 o6 ibias vss vss sky130_fd_pr__nfet_01v8 L=0.5u W=1u
M8246 o6 ibias vss vss sky130_fd_pr__nfet_01v8 L=0.5u W=1u
M8247 o6 ibias vss vss sky130_fd_pr__nfet_01v8 L=0.5u W=1u
M8248 o6 ibias vss vss sky130_fd_pr__nfet_01v8 L=0.5u W=1u
M8249 o6 ibias vss vss sky130_fd_pr__nfet_01v8 L=0.5u W=1u
M8250 o6 ibias vss vss sky130_fd_pr__nfet_01v8 L=0.5u W=1u
M8251 o6 ibias vss vss sky130_fd_pr__nfet_01v8 L=0.5u W=1u
M8252 o6 ibias vss vss sky130_fd_pr__nfet_01v8 L=0.5u W=1u
M8253 o6 ibias vss vss sky130_fd_pr__nfet_01v8 L=0.5u W=1u
M8254 o6 ibias vss vss sky130_fd_pr__nfet_01v8 L=0.5u W=1u
M8255 o6 ibias vss vss sky130_fd_pr__nfet_01v8 L=0.5u W=1u
M8256 o6 ibias vss vss sky130_fd_pr__nfet_01v8 L=0.5u W=1u
M8257 o6 ibias vss vss sky130_fd_pr__nfet_01v8 L=0.5u W=1u
M8258 o6 ibias vss vss sky130_fd_pr__nfet_01v8 L=0.5u W=1u
M8259 o6 ibias vss vss sky130_fd_pr__nfet_01v8 L=0.5u W=1u
M8260 o6 ibias vss vss sky130_fd_pr__nfet_01v8 L=0.5u W=1u
M8261 o6 ibias vss vss sky130_fd_pr__nfet_01v8 L=0.5u W=1u
M8262 o6 ibias vss vss sky130_fd_pr__nfet_01v8 L=0.5u W=1u
M8263 o6 ibias vss vss sky130_fd_pr__nfet_01v8 L=0.5u W=1u
M8264 o6 ibias vss vss sky130_fd_pr__nfet_01v8 L=0.5u W=1u
M8265 o6 ibias vss vss sky130_fd_pr__nfet_01v8 L=0.5u W=1u
M8266 o6 ibias vss vss sky130_fd_pr__nfet_01v8 L=0.5u W=1u
M8267 o6 ibias vss vss sky130_fd_pr__nfet_01v8 L=0.5u W=1u
M8268 o6 ibias vss vss sky130_fd_pr__nfet_01v8 L=0.5u W=1u
M8269 o6 ibias vss vss sky130_fd_pr__nfet_01v8 L=0.5u W=1u
M8270 o6 ibias vss vss sky130_fd_pr__nfet_01v8 L=0.5u W=1u
M8271 o6 ibias vss vss sky130_fd_pr__nfet_01v8 L=0.5u W=1u
M8272 o6 ibias vss vss sky130_fd_pr__nfet_01v8 L=0.5u W=1u
M8273 o6 ibias vss vss sky130_fd_pr__nfet_01v8 L=0.5u W=1u
M8274 o6 ibias vss vss sky130_fd_pr__nfet_01v8 L=0.5u W=1u
M8275 o6 ibias vss vss sky130_fd_pr__nfet_01v8 L=0.5u W=1u
M8276 o6 ibias vss vss sky130_fd_pr__nfet_01v8 L=0.5u W=1u
M8277 o6 ibias vss vss sky130_fd_pr__nfet_01v8 L=0.5u W=1u
M8278 o6 ibias vss vss sky130_fd_pr__nfet_01v8 L=0.5u W=1u
M8279 o6 ibias vss vss sky130_fd_pr__nfet_01v8 L=0.5u W=1u
M8280 o6 ibias vss vss sky130_fd_pr__nfet_01v8 L=0.5u W=1u
M8281 o6 ibias vss vss sky130_fd_pr__nfet_01v8 L=0.5u W=1u
M8282 o6 ibias vss vss sky130_fd_pr__nfet_01v8 L=0.5u W=1u
M8283 o6 ibias vss vss sky130_fd_pr__nfet_01v8 L=0.5u W=1u
M8284 o6 ibias vss vss sky130_fd_pr__nfet_01v8 L=0.5u W=1u
M8285 o6 ibias vss vss sky130_fd_pr__nfet_01v8 L=0.5u W=1u
M8286 o6 ibias vss vss sky130_fd_pr__nfet_01v8 L=0.5u W=1u
M8287 o6 ibias vss vss sky130_fd_pr__nfet_01v8 L=0.5u W=1u
M8288 o6 ibias vss vss sky130_fd_pr__nfet_01v8 L=0.5u W=1u
M8289 o6 ibias vss vss sky130_fd_pr__nfet_01v8 L=0.5u W=1u
M8290 o6 ibias vss vss sky130_fd_pr__nfet_01v8 L=0.5u W=1u
M8291 o6 ibias vss vss sky130_fd_pr__nfet_01v8 L=0.5u W=1u
M8292 o6 ibias vss vss sky130_fd_pr__nfet_01v8 L=0.5u W=1u
M8293 o6 ibias vss vss sky130_fd_pr__nfet_01v8 L=0.5u W=1u
M8294 o6 ibias vss vss sky130_fd_pr__nfet_01v8 L=0.5u W=1u
M8295 o6 ibias vss vss sky130_fd_pr__nfet_01v8 L=0.5u W=1u
M8296 o6 ibias vss vss sky130_fd_pr__nfet_01v8 L=0.5u W=1u
M8297 o6 ibias vss vss sky130_fd_pr__nfet_01v8 L=0.5u W=1u
M8298 o6 ibias vss vss sky130_fd_pr__nfet_01v8 L=0.5u W=1u
M8299 o6 ibias vss vss sky130_fd_pr__nfet_01v8 L=0.5u W=1u
M8300 o6 ibias vss vss sky130_fd_pr__nfet_01v8 L=0.5u W=1u
M8301 o6 ibias vss vss sky130_fd_pr__nfet_01v8 L=0.5u W=1u
M8302 o6 ibias vss vss sky130_fd_pr__nfet_01v8 L=0.5u W=1u
M8303 o6 ibias vss vss sky130_fd_pr__nfet_01v8 L=0.5u W=1u
M8304 o6 ibias vss vss sky130_fd_pr__nfet_01v8 L=0.5u W=1u
M8305 o6 ibias vss vss sky130_fd_pr__nfet_01v8 L=0.5u W=1u
M8306 o6 ibias vss vss sky130_fd_pr__nfet_01v8 L=0.5u W=1u
M8307 o6 ibias vss vss sky130_fd_pr__nfet_01v8 L=0.5u W=1u
M8308 o6 ibias vss vss sky130_fd_pr__nfet_01v8 L=0.5u W=1u
M8309 o6 ibias vss vss sky130_fd_pr__nfet_01v8 L=0.5u W=1u
M8310 o6 ibias vss vss sky130_fd_pr__nfet_01v8 L=0.5u W=1u
M8311 o6 ibias vss vss sky130_fd_pr__nfet_01v8 L=0.5u W=1u
M8312 o6 ibias vss vss sky130_fd_pr__nfet_01v8 L=0.5u W=1u
M8313 o6 ibias vss vss sky130_fd_pr__nfet_01v8 L=0.5u W=1u
M8314 o6 ibias vss vss sky130_fd_pr__nfet_01v8 L=0.5u W=1u
M8315 o6 ibias vss vss sky130_fd_pr__nfet_01v8 L=0.5u W=1u
M8316 o6 ibias vss vss sky130_fd_pr__nfet_01v8 L=0.5u W=1u
M8317 o6 ibias vss vss sky130_fd_pr__nfet_01v8 L=0.5u W=1u
M8318 o6 ibias vss vss sky130_fd_pr__nfet_01v8 L=0.5u W=1u
M8319 o6 ibias vss vss sky130_fd_pr__nfet_01v8 L=0.5u W=1u
M8320 o6 ibias vss vss sky130_fd_pr__nfet_01v8 L=0.5u W=1u
M8321 o6 ibias vss vss sky130_fd_pr__nfet_01v8 L=0.5u W=1u
M8322 o6 ibias vss vss sky130_fd_pr__nfet_01v8 L=0.5u W=1u
M8323 o6 ibias vss vss sky130_fd_pr__nfet_01v8 L=0.5u W=1u
M8324 o6 ibias vss vss sky130_fd_pr__nfet_01v8 L=0.5u W=1u
M8325 o6 ibias vss vss sky130_fd_pr__nfet_01v8 L=0.5u W=1u
M8326 o6 ibias vss vss sky130_fd_pr__nfet_01v8 L=0.5u W=1u
M8327 o6 ibias vss vss sky130_fd_pr__nfet_01v8 L=0.5u W=1u
M8328 o6 ibias vss vss sky130_fd_pr__nfet_01v8 L=0.5u W=1u
M8329 o6 ibias vss vss sky130_fd_pr__nfet_01v8 L=0.5u W=1u
M8330 o6 ibias vss vss sky130_fd_pr__nfet_01v8 L=0.5u W=1u
M8331 o6 ibias vss vss sky130_fd_pr__nfet_01v8 L=0.5u W=1u
M8332 o6 ibias vss vss sky130_fd_pr__nfet_01v8 L=0.5u W=1u
M8333 o6 ibias vss vss sky130_fd_pr__nfet_01v8 L=0.5u W=1u
M8334 o6 ibias vss vss sky130_fd_pr__nfet_01v8 L=0.5u W=1u
M8335 o6 ibias vss vss sky130_fd_pr__nfet_01v8 L=0.5u W=1u
M8336 o6 ibias vss vss sky130_fd_pr__nfet_01v8 L=0.5u W=1u
M8337 o6 ibias vss vss sky130_fd_pr__nfet_01v8 L=0.5u W=1u
M8338 o6 ibias vss vss sky130_fd_pr__nfet_01v8 L=0.5u W=1u
M8339 o6 ibias vss vss sky130_fd_pr__nfet_01v8 L=0.5u W=1u
M8340 o6 ibias vss vss sky130_fd_pr__nfet_01v8 L=0.5u W=1u
M8341 o6 ibias vss vss sky130_fd_pr__nfet_01v8 L=0.5u W=1u
M8342 o6 ibias vss vss sky130_fd_pr__nfet_01v8 L=0.5u W=1u
M8343 o6 ibias vss vss sky130_fd_pr__nfet_01v8 L=0.5u W=1u
M8344 o6 ibias vss vss sky130_fd_pr__nfet_01v8 L=0.5u W=1u
M8345 o6 ibias vss vss sky130_fd_pr__nfet_01v8 L=0.5u W=1u
M8346 o6 ibias vss vss sky130_fd_pr__nfet_01v8 L=0.5u W=1u
M8347 o6 ibias vss vss sky130_fd_pr__nfet_01v8 L=0.5u W=1u
M8348 o6 ibias vss vss sky130_fd_pr__nfet_01v8 L=0.5u W=1u
M8349 o6 ibias vss vss sky130_fd_pr__nfet_01v8 L=0.5u W=1u
M8350 o6 ibias vss vss sky130_fd_pr__nfet_01v8 L=0.5u W=1u
M8351 o6 ibias vss vss sky130_fd_pr__nfet_01v8 L=0.5u W=1u
M8352 o6 ibias vss vss sky130_fd_pr__nfet_01v8 L=0.5u W=1u
M8353 o6 ibias vss vss sky130_fd_pr__nfet_01v8 L=0.5u W=1u
M8354 o6 ibias vss vss sky130_fd_pr__nfet_01v8 L=0.5u W=1u
M8355 o6 ibias vss vss sky130_fd_pr__nfet_01v8 L=0.5u W=1u
M8356 o6 ibias vss vss sky130_fd_pr__nfet_01v8 L=0.5u W=1u
M8357 o6 ibias vss vss sky130_fd_pr__nfet_01v8 L=0.5u W=1u
M8358 o6 ibias vss vss sky130_fd_pr__nfet_01v8 L=0.5u W=1u
M8359 o6 ibias vss vss sky130_fd_pr__nfet_01v8 L=0.5u W=1u
M8360 o6 ibias vss vss sky130_fd_pr__nfet_01v8 L=0.5u W=1u
M8361 o6 ibias vss vss sky130_fd_pr__nfet_01v8 L=0.5u W=1u
M8362 o6 ibias vss vss sky130_fd_pr__nfet_01v8 L=0.5u W=1u
M8363 o6 ibias vss vss sky130_fd_pr__nfet_01v8 L=0.5u W=1u
M8364 o6 ibias vss vss sky130_fd_pr__nfet_01v8 L=0.5u W=1u
M8365 o6 ibias vss vss sky130_fd_pr__nfet_01v8 L=0.5u W=1u
M8366 o6 ibias vss vss sky130_fd_pr__nfet_01v8 L=0.5u W=1u
M8367 o6 ibias vss vss sky130_fd_pr__nfet_01v8 L=0.5u W=1u
M8368 o6 ibias vss vss sky130_fd_pr__nfet_01v8 L=0.5u W=1u
M8369 o6 ibias vss vss sky130_fd_pr__nfet_01v8 L=0.5u W=1u
M8370 o6 ibias vss vss sky130_fd_pr__nfet_01v8 L=0.5u W=1u
M8371 o6 ibias vss vss sky130_fd_pr__nfet_01v8 L=0.5u W=1u
M8372 o6 ibias vss vss sky130_fd_pr__nfet_01v8 L=0.5u W=1u
M8373 o6 ibias vss vss sky130_fd_pr__nfet_01v8 L=0.5u W=1u
M8374 o6 ibias vss vss sky130_fd_pr__nfet_01v8 L=0.5u W=1u
M8375 o6 ibias vss vss sky130_fd_pr__nfet_01v8 L=0.5u W=1u
M8376 o6 ibias vss vss sky130_fd_pr__nfet_01v8 L=0.5u W=1u
M8377 o6 ibias vss vss sky130_fd_pr__nfet_01v8 L=0.5u W=1u
M8378 o6 ibias vss vss sky130_fd_pr__nfet_01v8 L=0.5u W=1u
M8379 o6 ibias vss vss sky130_fd_pr__nfet_01v8 L=0.5u W=1u
M8380 o6 ibias vss vss sky130_fd_pr__nfet_01v8 L=0.5u W=1u
M8381 o6 ibias vss vss sky130_fd_pr__nfet_01v8 L=0.5u W=1u
M8382 o6 ibias vss vss sky130_fd_pr__nfet_01v8 L=0.5u W=1u
M8383 o6 ibias vss vss sky130_fd_pr__nfet_01v8 L=0.5u W=1u
M8384 o6 ibias vss vss sky130_fd_pr__nfet_01v8 L=0.5u W=1u
M8385 o6 ibias vss vss sky130_fd_pr__nfet_01v8 L=0.5u W=1u
M8386 o6 ibias vss vss sky130_fd_pr__nfet_01v8 L=0.5u W=1u
M8387 o6 ibias vss vss sky130_fd_pr__nfet_01v8 L=0.5u W=1u
M8388 o6 ibias vss vss sky130_fd_pr__nfet_01v8 L=0.5u W=1u
M8389 o6 ibias vss vss sky130_fd_pr__nfet_01v8 L=0.5u W=1u
M8390 o6 ibias vss vss sky130_fd_pr__nfet_01v8 L=0.5u W=1u
M8391 o6 ibias vss vss sky130_fd_pr__nfet_01v8 L=0.5u W=1u
M8392 o6 ibias vss vss sky130_fd_pr__nfet_01v8 L=0.5u W=1u
M8393 o6 ibias vss vss sky130_fd_pr__nfet_01v8 L=0.5u W=1u
M8394 o6 ibias vss vss sky130_fd_pr__nfet_01v8 L=0.5u W=1u
M8395 o6 ibias vss vss sky130_fd_pr__nfet_01v8 L=0.5u W=1u
M8396 o6 ibias vss vss sky130_fd_pr__nfet_01v8 L=0.5u W=1u
M8397 o6 ibias vss vss sky130_fd_pr__nfet_01v8 L=0.5u W=1u
M8398 o6 ibias vss vss sky130_fd_pr__nfet_01v8 L=0.5u W=1u
M8399 o6 ibias vss vss sky130_fd_pr__nfet_01v8 L=0.5u W=1u
M8400 o6 ibias vss vss sky130_fd_pr__nfet_01v8 L=0.5u W=1u
M8401 o6 ibias vss vss sky130_fd_pr__nfet_01v8 L=0.5u W=1u
M8402 o6 ibias vss vss sky130_fd_pr__nfet_01v8 L=0.5u W=1u
M8403 o6 ibias vss vss sky130_fd_pr__nfet_01v8 L=0.5u W=1u
M8404 o6 ibias vss vss sky130_fd_pr__nfet_01v8 L=0.5u W=1u
M8405 o6 ibias vss vss sky130_fd_pr__nfet_01v8 L=0.5u W=1u
M8406 o6 ibias vss vss sky130_fd_pr__nfet_01v8 L=0.5u W=1u
M8407 o6 ibias vss vss sky130_fd_pr__nfet_01v8 L=0.5u W=1u
M8408 o6 ibias vss vss sky130_fd_pr__nfet_01v8 L=0.5u W=1u
M8409 o6 ibias vss vss sky130_fd_pr__nfet_01v8 L=0.5u W=1u
M8410 o6 ibias vss vss sky130_fd_pr__nfet_01v8 L=0.5u W=1u
M8411 o6 ibias vss vss sky130_fd_pr__nfet_01v8 L=0.5u W=1u
M8412 o6 ibias vss vss sky130_fd_pr__nfet_01v8 L=0.5u W=1u
M8413 o6 ibias vss vss sky130_fd_pr__nfet_01v8 L=0.5u W=1u
M8414 o6 ibias vss vss sky130_fd_pr__nfet_01v8 L=0.5u W=1u
M8415 o6 ibias vss vss sky130_fd_pr__nfet_01v8 L=0.5u W=1u
M8416 o6 ibias vss vss sky130_fd_pr__nfet_01v8 L=0.5u W=1u
M8417 o6 ibias vss vss sky130_fd_pr__nfet_01v8 L=0.5u W=1u
M8418 o6 ibias vss vss sky130_fd_pr__nfet_01v8 L=0.5u W=1u
M8419 o6 ibias vss vss sky130_fd_pr__nfet_01v8 L=0.5u W=1u
M8420 o6 ibias vss vss sky130_fd_pr__nfet_01v8 L=0.5u W=1u
M8421 o6 ibias vss vss sky130_fd_pr__nfet_01v8 L=0.5u W=1u
M8422 o6 ibias vss vss sky130_fd_pr__nfet_01v8 L=0.5u W=1u
M8423 o6 ibias vss vss sky130_fd_pr__nfet_01v8 L=0.5u W=1u
M8424 o6 ibias vss vss sky130_fd_pr__nfet_01v8 L=0.5u W=1u
M8425 o6 ibias vss vss sky130_fd_pr__nfet_01v8 L=0.5u W=1u
M8426 o6 ibias vss vss sky130_fd_pr__nfet_01v8 L=0.5u W=1u
M8427 o6 ibias vss vss sky130_fd_pr__nfet_01v8 L=0.5u W=1u
M8428 o6 ibias vss vss sky130_fd_pr__nfet_01v8 L=0.5u W=1u
M8429 o6 ibias vss vss sky130_fd_pr__nfet_01v8 L=0.5u W=1u
M8430 o6 ibias vss vss sky130_fd_pr__nfet_01v8 L=0.5u W=1u
M8431 o6 ibias vss vss sky130_fd_pr__nfet_01v8 L=0.5u W=1u
M8432 o6 ibias vss vss sky130_fd_pr__nfet_01v8 L=0.5u W=1u
M8433 o6 ibias vss vss sky130_fd_pr__nfet_01v8 L=0.5u W=1u
M8434 o6 ibias vss vss sky130_fd_pr__nfet_01v8 L=0.5u W=1u
M8435 o6 ibias vss vss sky130_fd_pr__nfet_01v8 L=0.5u W=1u
M8436 o6 ibias vss vss sky130_fd_pr__nfet_01v8 L=0.5u W=1u
M8437 o6 ibias vss vss sky130_fd_pr__nfet_01v8 L=0.5u W=1u
M8438 o6 ibias vss vss sky130_fd_pr__nfet_01v8 L=0.5u W=1u
M8439 o6 ibias vss vss sky130_fd_pr__nfet_01v8 L=0.5u W=1u
M8440 o6 ibias vss vss sky130_fd_pr__nfet_01v8 L=0.5u W=1u
M8441 o6 ibias vss vss sky130_fd_pr__nfet_01v8 L=0.5u W=1u
M8442 o6 ibias vss vss sky130_fd_pr__nfet_01v8 L=0.5u W=1u
M8443 o6 ibias vss vss sky130_fd_pr__nfet_01v8 L=0.5u W=1u
M8444 o6 ibias vss vss sky130_fd_pr__nfet_01v8 L=0.5u W=1u
M8445 o6 ibias vss vss sky130_fd_pr__nfet_01v8 L=0.5u W=1u
M8446 o6 ibias vss vss sky130_fd_pr__nfet_01v8 L=0.5u W=1u
M8447 o6 ibias vss vss sky130_fd_pr__nfet_01v8 L=0.5u W=1u
M8448 o6 ibias vss vss sky130_fd_pr__nfet_01v8 L=0.5u W=1u
M8449 o6 ibias vss vss sky130_fd_pr__nfet_01v8 L=0.5u W=1u
M8450 o6 ibias vss vss sky130_fd_pr__nfet_01v8 L=0.5u W=1u
M8451 o6 ibias vss vss sky130_fd_pr__nfet_01v8 L=0.5u W=1u
M8452 o6 ibias vss vss sky130_fd_pr__nfet_01v8 L=0.5u W=1u
M8453 o6 ibias vss vss sky130_fd_pr__nfet_01v8 L=0.5u W=1u
M8454 o6 ibias vss vss sky130_fd_pr__nfet_01v8 L=0.5u W=1u
M8455 o6 ibias vss vss sky130_fd_pr__nfet_01v8 L=0.5u W=1u
M8456 o6 ibias vss vss sky130_fd_pr__nfet_01v8 L=0.5u W=1u
M8457 o6 ibias vss vss sky130_fd_pr__nfet_01v8 L=0.5u W=1u
M8458 o6 ibias vss vss sky130_fd_pr__nfet_01v8 L=0.5u W=1u
M8459 o6 ibias vss vss sky130_fd_pr__nfet_01v8 L=0.5u W=1u
M8460 o6 ibias vss vss sky130_fd_pr__nfet_01v8 L=0.5u W=1u
M8461 o6 ibias vss vss sky130_fd_pr__nfet_01v8 L=0.5u W=1u
M8462 o6 ibias vss vss sky130_fd_pr__nfet_01v8 L=0.5u W=1u
M8463 o6 ibias vss vss sky130_fd_pr__nfet_01v8 L=0.5u W=1u
M8464 o6 ibias vss vss sky130_fd_pr__nfet_01v8 L=0.5u W=1u
M8465 o6 ibias vss vss sky130_fd_pr__nfet_01v8 L=0.5u W=1u
M8466 o6 ibias vss vss sky130_fd_pr__nfet_01v8 L=0.5u W=1u
M8467 o6 ibias vss vss sky130_fd_pr__nfet_01v8 L=0.5u W=1u
M8468 o6 ibias vss vss sky130_fd_pr__nfet_01v8 L=0.5u W=1u
M8469 o6 ibias vss vss sky130_fd_pr__nfet_01v8 L=0.5u W=1u
M8470 o6 ibias vss vss sky130_fd_pr__nfet_01v8 L=0.5u W=1u
M8471 o6 ibias vss vss sky130_fd_pr__nfet_01v8 L=0.5u W=1u
M8472 o6 ibias vss vss sky130_fd_pr__nfet_01v8 L=0.5u W=1u
M8473 o6 ibias vss vss sky130_fd_pr__nfet_01v8 L=0.5u W=1u
M8474 o6 ibias vss vss sky130_fd_pr__nfet_01v8 L=0.5u W=1u
M8475 o6 ibias vss vss sky130_fd_pr__nfet_01v8 L=0.5u W=1u
M8476 o6 ibias vss vss sky130_fd_pr__nfet_01v8 L=0.5u W=1u
M8477 o6 ibias vss vss sky130_fd_pr__nfet_01v8 L=0.5u W=1u
M8478 o6 ibias vss vss sky130_fd_pr__nfet_01v8 L=0.5u W=1u
M8479 o6 ibias vss vss sky130_fd_pr__nfet_01v8 L=0.5u W=1u
M8480 o6 ibias vss vss sky130_fd_pr__nfet_01v8 L=0.5u W=1u
M8481 o6 ibias vss vss sky130_fd_pr__nfet_01v8 L=0.5u W=1u
M8482 o6 ibias vss vss sky130_fd_pr__nfet_01v8 L=0.5u W=1u
M8483 o6 ibias vss vss sky130_fd_pr__nfet_01v8 L=0.5u W=1u
M8484 o6 ibias vss vss sky130_fd_pr__nfet_01v8 L=0.5u W=1u
M8485 o6 ibias vss vss sky130_fd_pr__nfet_01v8 L=0.5u W=1u
M8486 o6 ibias vss vss sky130_fd_pr__nfet_01v8 L=0.5u W=1u
M8487 o6 ibias vss vss sky130_fd_pr__nfet_01v8 L=0.5u W=1u
M8488 o6 ibias vss vss sky130_fd_pr__nfet_01v8 L=0.5u W=1u
M8489 o6 ibias vss vss sky130_fd_pr__nfet_01v8 L=0.5u W=1u
M8490 o6 ibias vss vss sky130_fd_pr__nfet_01v8 L=0.5u W=1u
M8491 o6 ibias vss vss sky130_fd_pr__nfet_01v8 L=0.5u W=1u
M8492 o6 ibias vss vss sky130_fd_pr__nfet_01v8 L=0.5u W=1u
M8493 o6 ibias vss vss sky130_fd_pr__nfet_01v8 L=0.5u W=1u
M8494 o6 ibias vss vss sky130_fd_pr__nfet_01v8 L=0.5u W=1u
M8495 o6 ibias vss vss sky130_fd_pr__nfet_01v8 L=0.5u W=1u
M8496 o6 ibias vss vss sky130_fd_pr__nfet_01v8 L=0.5u W=1u
M8497 o6 ibias vss vss sky130_fd_pr__nfet_01v8 L=0.5u W=1u
M8498 o6 ibias vss vss sky130_fd_pr__nfet_01v8 L=0.5u W=1u
M8499 o6 ibias vss vss sky130_fd_pr__nfet_01v8 L=0.5u W=1u
M8500 o6 ibias vss vss sky130_fd_pr__nfet_01v8 L=0.5u W=1u
M8501 o6 ibias vss vss sky130_fd_pr__nfet_01v8 L=0.5u W=1u
M8502 o6 ibias vss vss sky130_fd_pr__nfet_01v8 L=0.5u W=1u
M8503 o6 ibias vss vss sky130_fd_pr__nfet_01v8 L=0.5u W=1u
M8504 o6 ibias vss vss sky130_fd_pr__nfet_01v8 L=0.5u W=1u
M8505 o6 ibias vss vss sky130_fd_pr__nfet_01v8 L=0.5u W=1u
M8506 o6 ibias vss vss sky130_fd_pr__nfet_01v8 L=0.5u W=1u
M8507 o6 ibias vss vss sky130_fd_pr__nfet_01v8 L=0.5u W=1u
M8508 o6 ibias vss vss sky130_fd_pr__nfet_01v8 L=0.5u W=1u
M8509 o6 ibias vss vss sky130_fd_pr__nfet_01v8 L=0.5u W=1u
M8510 o6 ibias vss vss sky130_fd_pr__nfet_01v8 L=0.5u W=1u
M8511 o6 ibias vss vss sky130_fd_pr__nfet_01v8 L=0.5u W=1u
M8512 o6 ibias vss vss sky130_fd_pr__nfet_01v8 L=0.5u W=1u
M8513 o6 ibias vss vss sky130_fd_pr__nfet_01v8 L=0.5u W=1u
M8514 o6 ibias vss vss sky130_fd_pr__nfet_01v8 L=0.5u W=1u
M8515 o6 ibias vss vss sky130_fd_pr__nfet_01v8 L=0.5u W=1u
M8516 o6 ibias vss vss sky130_fd_pr__nfet_01v8 L=0.5u W=1u
M8517 o6 ibias vss vss sky130_fd_pr__nfet_01v8 L=0.5u W=1u
M8518 o6 ibias vss vss sky130_fd_pr__nfet_01v8 L=0.5u W=1u
M8519 o6 ibias vss vss sky130_fd_pr__nfet_01v8 L=0.5u W=1u
M8520 o6 ibias vss vss sky130_fd_pr__nfet_01v8 L=0.5u W=1u
M8521 o6 ibias vss vss sky130_fd_pr__nfet_01v8 L=0.5u W=1u
M8522 o6 ibias vss vss sky130_fd_pr__nfet_01v8 L=0.5u W=1u
M8523 o6 ibias vss vss sky130_fd_pr__nfet_01v8 L=0.5u W=1u
M8524 o6 ibias vss vss sky130_fd_pr__nfet_01v8 L=0.5u W=1u
M8525 o6 ibias vss vss sky130_fd_pr__nfet_01v8 L=0.5u W=1u
M8526 o6 ibias vss vss sky130_fd_pr__nfet_01v8 L=0.5u W=1u
M8527 o6 ibias vss vss sky130_fd_pr__nfet_01v8 L=0.5u W=1u
M8528 o6 ibias vss vss sky130_fd_pr__nfet_01v8 L=0.5u W=1u
M8529 o6 ibias vss vss sky130_fd_pr__nfet_01v8 L=0.5u W=1u
M8530 o6 ibias vss vss sky130_fd_pr__nfet_01v8 L=0.5u W=1u
M8531 o6 ibias vss vss sky130_fd_pr__nfet_01v8 L=0.5u W=1u
M8532 o6 ibias vss vss sky130_fd_pr__nfet_01v8 L=0.5u W=1u
M8533 o6 ibias vss vss sky130_fd_pr__nfet_01v8 L=0.5u W=1u
M8534 o6 ibias vss vss sky130_fd_pr__nfet_01v8 L=0.5u W=1u
M8535 o6 ibias vss vss sky130_fd_pr__nfet_01v8 L=0.5u W=1u
M8536 o6 ibias vss vss sky130_fd_pr__nfet_01v8 L=0.5u W=1u
M8537 o6 ibias vss vss sky130_fd_pr__nfet_01v8 L=0.5u W=1u
M8538 o6 ibias vss vss sky130_fd_pr__nfet_01v8 L=0.5u W=1u
M8539 o6 ibias vss vss sky130_fd_pr__nfet_01v8 L=0.5u W=1u
M8540 o6 ibias vss vss sky130_fd_pr__nfet_01v8 L=0.5u W=1u
M8541 o6 ibias vss vss sky130_fd_pr__nfet_01v8 L=0.5u W=1u
M8542 o6 ibias vss vss sky130_fd_pr__nfet_01v8 L=0.5u W=1u
M8543 o6 ibias vss vss sky130_fd_pr__nfet_01v8 L=0.5u W=1u
M8544 o6 ibias vss vss sky130_fd_pr__nfet_01v8 L=0.5u W=1u
M8545 o6 ibias vss vss sky130_fd_pr__nfet_01v8 L=0.5u W=1u
M8546 o6 ibias vss vss sky130_fd_pr__nfet_01v8 L=0.5u W=1u
M8547 o6 ibias vss vss sky130_fd_pr__nfet_01v8 L=0.5u W=1u
M8548 o6 ibias vss vss sky130_fd_pr__nfet_01v8 L=0.5u W=1u
M8549 o6 ibias vss vss sky130_fd_pr__nfet_01v8 L=0.5u W=1u
M8550 o6 ibias vss vss sky130_fd_pr__nfet_01v8 L=0.5u W=1u
M8551 o6 ibias vss vss sky130_fd_pr__nfet_01v8 L=0.5u W=1u
M8552 o6 ibias vss vss sky130_fd_pr__nfet_01v8 L=0.5u W=1u
M8553 o6 ibias vss vss sky130_fd_pr__nfet_01v8 L=0.5u W=1u
M8554 o6 ibias vss vss sky130_fd_pr__nfet_01v8 L=0.5u W=1u
M8555 o6 ibias vss vss sky130_fd_pr__nfet_01v8 L=0.5u W=1u
M8556 o6 ibias vss vss sky130_fd_pr__nfet_01v8 L=0.5u W=1u
M8557 o6 ibias vss vss sky130_fd_pr__nfet_01v8 L=0.5u W=1u
M8558 o6 ibias vss vss sky130_fd_pr__nfet_01v8 L=0.5u W=1u
M8559 o6 ibias vss vss sky130_fd_pr__nfet_01v8 L=0.5u W=1u
M8560 o6 ibias vss vss sky130_fd_pr__nfet_01v8 L=0.5u W=1u
M8561 o6 ibias vss vss sky130_fd_pr__nfet_01v8 L=0.5u W=1u
M8562 o6 ibias vss vss sky130_fd_pr__nfet_01v8 L=0.5u W=1u
M8563 o6 ibias vss vss sky130_fd_pr__nfet_01v8 L=0.5u W=1u
M8564 o6 ibias vss vss sky130_fd_pr__nfet_01v8 L=0.5u W=1u
M8565 o6 ibias vss vss sky130_fd_pr__nfet_01v8 L=0.5u W=1u
M8566 o6 ibias vss vss sky130_fd_pr__nfet_01v8 L=0.5u W=1u
M8567 o6 ibias vss vss sky130_fd_pr__nfet_01v8 L=0.5u W=1u
M8568 o6 ibias vss vss sky130_fd_pr__nfet_01v8 L=0.5u W=1u
M8569 o6 ibias vss vss sky130_fd_pr__nfet_01v8 L=0.5u W=1u
M8570 o6 ibias vss vss sky130_fd_pr__nfet_01v8 L=0.5u W=1u
M8571 o6 ibias vss vss sky130_fd_pr__nfet_01v8 L=0.5u W=1u
M8572 o6 ibias vss vss sky130_fd_pr__nfet_01v8 L=0.5u W=1u
M8573 o6 ibias vss vss sky130_fd_pr__nfet_01v8 L=0.5u W=1u
M8574 o6 ibias vss vss sky130_fd_pr__nfet_01v8 L=0.5u W=1u
M8575 o6 ibias vss vss sky130_fd_pr__nfet_01v8 L=0.5u W=1u
M8576 o6 ibias vss vss sky130_fd_pr__nfet_01v8 L=0.5u W=1u
M8577 o6 ibias vss vss sky130_fd_pr__nfet_01v8 L=0.5u W=1u
M8578 o6 ibias vss vss sky130_fd_pr__nfet_01v8 L=0.5u W=1u
M8579 o6 ibias vss vss sky130_fd_pr__nfet_01v8 L=0.5u W=1u
M8580 o6 ibias vss vss sky130_fd_pr__nfet_01v8 L=0.5u W=1u
M8581 o6 ibias vss vss sky130_fd_pr__nfet_01v8 L=0.5u W=1u
M8582 o6 ibias vss vss sky130_fd_pr__nfet_01v8 L=0.5u W=1u
M8583 o6 ibias vss vss sky130_fd_pr__nfet_01v8 L=0.5u W=1u
M8584 o6 ibias vss vss sky130_fd_pr__nfet_01v8 L=0.5u W=1u
M8585 o6 ibias vss vss sky130_fd_pr__nfet_01v8 L=0.5u W=1u
M8586 o6 ibias vss vss sky130_fd_pr__nfet_01v8 L=0.5u W=1u
M8587 o6 ibias vss vss sky130_fd_pr__nfet_01v8 L=0.5u W=1u
M8588 o6 ibias vss vss sky130_fd_pr__nfet_01v8 L=0.5u W=1u
M8589 o6 ibias vss vss sky130_fd_pr__nfet_01v8 L=0.5u W=1u
M8590 o6 ibias vss vss sky130_fd_pr__nfet_01v8 L=0.5u W=1u
M8591 o6 ibias vss vss sky130_fd_pr__nfet_01v8 L=0.5u W=1u
M8592 o6 ibias vss vss sky130_fd_pr__nfet_01v8 L=0.5u W=1u
M8593 o6 ibias vss vss sky130_fd_pr__nfet_01v8 L=0.5u W=1u
M8594 o6 ibias vss vss sky130_fd_pr__nfet_01v8 L=0.5u W=1u
M8595 o6 ibias vss vss sky130_fd_pr__nfet_01v8 L=0.5u W=1u
M8596 o6 ibias vss vss sky130_fd_pr__nfet_01v8 L=0.5u W=1u
M8597 o6 ibias vss vss sky130_fd_pr__nfet_01v8 L=0.5u W=1u
M8598 o6 ibias vss vss sky130_fd_pr__nfet_01v8 L=0.5u W=1u
M8599 o6 ibias vss vss sky130_fd_pr__nfet_01v8 L=0.5u W=1u
M8600 o6 ibias vss vss sky130_fd_pr__nfet_01v8 L=0.5u W=1u
M8601 o6 ibias vss vss sky130_fd_pr__nfet_01v8 L=0.5u W=1u
M8602 o6 ibias vss vss sky130_fd_pr__nfet_01v8 L=0.5u W=1u
M8603 o6 ibias vss vss sky130_fd_pr__nfet_01v8 L=0.5u W=1u
M8604 o6 ibias vss vss sky130_fd_pr__nfet_01v8 L=0.5u W=1u
M8605 o6 ibias vss vss sky130_fd_pr__nfet_01v8 L=0.5u W=1u
M8606 o6 ibias vss vss sky130_fd_pr__nfet_01v8 L=0.5u W=1u
M8607 o6 ibias vss vss sky130_fd_pr__nfet_01v8 L=0.5u W=1u
M8608 o6 ibias vss vss sky130_fd_pr__nfet_01v8 L=0.5u W=1u
M8609 o6 ibias vss vss sky130_fd_pr__nfet_01v8 L=0.5u W=1u
M8610 o6 ibias vss vss sky130_fd_pr__nfet_01v8 L=0.5u W=1u
M8611 o6 ibias vss vss sky130_fd_pr__nfet_01v8 L=0.5u W=1u
M8612 o6 ibias vss vss sky130_fd_pr__nfet_01v8 L=0.5u W=1u
M8613 o6 ibias vss vss sky130_fd_pr__nfet_01v8 L=0.5u W=1u
M8614 o6 ibias vss vss sky130_fd_pr__nfet_01v8 L=0.5u W=1u
M8615 o6 ibias vss vss sky130_fd_pr__nfet_01v8 L=0.5u W=1u
M8616 o6 ibias vss vss sky130_fd_pr__nfet_01v8 L=0.5u W=1u
M8617 o6 ibias vss vss sky130_fd_pr__nfet_01v8 L=0.5u W=1u
M8618 o6 ibias vss vss sky130_fd_pr__nfet_01v8 L=0.5u W=1u
M8619 o6 ibias vss vss sky130_fd_pr__nfet_01v8 L=0.5u W=1u
M8620 o6 ibias vss vss sky130_fd_pr__nfet_01v8 L=0.5u W=1u
M8621 o6 ibias vss vss sky130_fd_pr__nfet_01v8 L=0.5u W=1u
M8622 o6 ibias vss vss sky130_fd_pr__nfet_01v8 L=0.5u W=1u
M8623 o6 ibias vss vss sky130_fd_pr__nfet_01v8 L=0.5u W=1u
M8624 o6 ibias vss vss sky130_fd_pr__nfet_01v8 L=0.5u W=1u
M8625 o6 ibias vss vss sky130_fd_pr__nfet_01v8 L=0.5u W=1u
M8626 o6 ibias vss vss sky130_fd_pr__nfet_01v8 L=0.5u W=1u
M8627 o6 ibias vss vss sky130_fd_pr__nfet_01v8 L=0.5u W=1u
M8628 o6 ibias vss vss sky130_fd_pr__nfet_01v8 L=0.5u W=1u
M8629 o6 ibias vss vss sky130_fd_pr__nfet_01v8 L=0.5u W=1u
M8630 o6 ibias vss vss sky130_fd_pr__nfet_01v8 L=0.5u W=1u
M8631 o6 ibias vss vss sky130_fd_pr__nfet_01v8 L=0.5u W=1u
M8632 o6 ibias vss vss sky130_fd_pr__nfet_01v8 L=0.5u W=1u
M8633 o6 ibias vss vss sky130_fd_pr__nfet_01v8 L=0.5u W=1u
M8634 o6 ibias vss vss sky130_fd_pr__nfet_01v8 L=0.5u W=1u
M8635 o6 ibias vss vss sky130_fd_pr__nfet_01v8 L=0.5u W=1u
M8636 o6 ibias vss vss sky130_fd_pr__nfet_01v8 L=0.5u W=1u
M8637 o6 ibias vss vss sky130_fd_pr__nfet_01v8 L=0.5u W=1u
M8638 o6 ibias vss vss sky130_fd_pr__nfet_01v8 L=0.5u W=1u
M8639 o6 ibias vss vss sky130_fd_pr__nfet_01v8 L=0.5u W=1u
M8640 o6 ibias vss vss sky130_fd_pr__nfet_01v8 L=0.5u W=1u
M8641 o6 ibias vss vss sky130_fd_pr__nfet_01v8 L=0.5u W=1u
M8642 o6 ibias vss vss sky130_fd_pr__nfet_01v8 L=0.5u W=1u
M8643 o6 ibias vss vss sky130_fd_pr__nfet_01v8 L=0.5u W=1u
M8644 o6 ibias vss vss sky130_fd_pr__nfet_01v8 L=0.5u W=1u
M8645 o6 ibias vss vss sky130_fd_pr__nfet_01v8 L=0.5u W=1u
M8646 o6 ibias vss vss sky130_fd_pr__nfet_01v8 L=0.5u W=1u
M8647 o6 ibias vss vss sky130_fd_pr__nfet_01v8 L=0.5u W=1u
M8648 o6 ibias vss vss sky130_fd_pr__nfet_01v8 L=0.5u W=1u
M8649 o6 ibias vss vss sky130_fd_pr__nfet_01v8 L=0.5u W=1u
M8650 o6 ibias vss vss sky130_fd_pr__nfet_01v8 L=0.5u W=1u
M8651 o6 ibias vss vss sky130_fd_pr__nfet_01v8 L=0.5u W=1u
M8652 o6 ibias vss vss sky130_fd_pr__nfet_01v8 L=0.5u W=1u
M8653 o6 ibias vss vss sky130_fd_pr__nfet_01v8 L=0.5u W=1u
M8654 o6 ibias vss vss sky130_fd_pr__nfet_01v8 L=0.5u W=1u
M8655 o6 ibias vss vss sky130_fd_pr__nfet_01v8 L=0.5u W=1u
M8656 o6 ibias vss vss sky130_fd_pr__nfet_01v8 L=0.5u W=1u
M8657 o6 ibias vss vss sky130_fd_pr__nfet_01v8 L=0.5u W=1u
M8658 o6 ibias vss vss sky130_fd_pr__nfet_01v8 L=0.5u W=1u
M8659 o6 ibias vss vss sky130_fd_pr__nfet_01v8 L=0.5u W=1u
M8660 o6 ibias vss vss sky130_fd_pr__nfet_01v8 L=0.5u W=1u
M8661 o6 ibias vss vss sky130_fd_pr__nfet_01v8 L=0.5u W=1u
M8662 o6 ibias vss vss sky130_fd_pr__nfet_01v8 L=0.5u W=1u
M8663 o6 ibias vss vss sky130_fd_pr__nfet_01v8 L=0.5u W=1u
M8664 o6 ibias vss vss sky130_fd_pr__nfet_01v8 L=0.5u W=1u
M8665 o6 ibias vss vss sky130_fd_pr__nfet_01v8 L=0.5u W=1u
M8666 o6 ibias vss vss sky130_fd_pr__nfet_01v8 L=0.5u W=1u
M8667 o6 ibias vss vss sky130_fd_pr__nfet_01v8 L=0.5u W=1u
M8668 o6 ibias vss vss sky130_fd_pr__nfet_01v8 L=0.5u W=1u
M8669 o6 ibias vss vss sky130_fd_pr__nfet_01v8 L=0.5u W=1u
M8670 o6 ibias vss vss sky130_fd_pr__nfet_01v8 L=0.5u W=1u
M8671 o6 ibias vss vss sky130_fd_pr__nfet_01v8 L=0.5u W=1u
M8672 o6 ibias vss vss sky130_fd_pr__nfet_01v8 L=0.5u W=1u
M8673 o6 ibias vss vss sky130_fd_pr__nfet_01v8 L=0.5u W=1u
M8674 o6 ibias vss vss sky130_fd_pr__nfet_01v8 L=0.5u W=1u
M8675 o6 ibias vss vss sky130_fd_pr__nfet_01v8 L=0.5u W=1u
M8676 o6 ibias vss vss sky130_fd_pr__nfet_01v8 L=0.5u W=1u
M8677 o6 ibias vss vss sky130_fd_pr__nfet_01v8 L=0.5u W=1u
M8678 o6 ibias vss vss sky130_fd_pr__nfet_01v8 L=0.5u W=1u
M8679 o6 ibias vss vss sky130_fd_pr__nfet_01v8 L=0.5u W=1u
M8680 o6 ibias vss vss sky130_fd_pr__nfet_01v8 L=0.5u W=1u
M8681 o6 ibias vss vss sky130_fd_pr__nfet_01v8 L=0.5u W=1u
M8682 o6 ibias vss vss sky130_fd_pr__nfet_01v8 L=0.5u W=1u
M8683 o6 ibias vss vss sky130_fd_pr__nfet_01v8 L=0.5u W=1u
M8684 o6 ibias vss vss sky130_fd_pr__nfet_01v8 L=0.5u W=1u
M8685 o6 ibias vss vss sky130_fd_pr__nfet_01v8 L=0.5u W=1u
M8686 o6 ibias vss vss sky130_fd_pr__nfet_01v8 L=0.5u W=1u
M8687 o6 ibias vss vss sky130_fd_pr__nfet_01v8 L=0.5u W=1u
M8688 o6 ibias vss vss sky130_fd_pr__nfet_01v8 L=0.5u W=1u
M8689 o6 ibias vss vss sky130_fd_pr__nfet_01v8 L=0.5u W=1u
M8690 o6 ibias vss vss sky130_fd_pr__nfet_01v8 L=0.5u W=1u
M8691 o6 ibias vss vss sky130_fd_pr__nfet_01v8 L=0.5u W=1u
M8692 o6 ibias vss vss sky130_fd_pr__nfet_01v8 L=0.5u W=1u
M8693 o6 ibias vss vss sky130_fd_pr__nfet_01v8 L=0.5u W=1u
M8694 o6 ibias vss vss sky130_fd_pr__nfet_01v8 L=0.5u W=1u
M8695 o6 ibias vss vss sky130_fd_pr__nfet_01v8 L=0.5u W=1u
M8696 o6 ibias vss vss sky130_fd_pr__nfet_01v8 L=0.5u W=1u
M8697 o6 ibias vss vss sky130_fd_pr__nfet_01v8 L=0.5u W=1u
M8698 o6 ibias vss vss sky130_fd_pr__nfet_01v8 L=0.5u W=1u
M8699 o6 ibias vss vss sky130_fd_pr__nfet_01v8 L=0.5u W=1u
M8700 o6 ibias vss vss sky130_fd_pr__nfet_01v8 L=0.5u W=1u
M8701 o6 ibias vss vss sky130_fd_pr__nfet_01v8 L=0.5u W=1u
M8702 o6 ibias vss vss sky130_fd_pr__nfet_01v8 L=0.5u W=1u
M8703 o6 ibias vss vss sky130_fd_pr__nfet_01v8 L=0.5u W=1u
M8704 o6 ibias vss vss sky130_fd_pr__nfet_01v8 L=0.5u W=1u
M8705 o6 ibias vss vss sky130_fd_pr__nfet_01v8 L=0.5u W=1u
M8706 o6 ibias vss vss sky130_fd_pr__nfet_01v8 L=0.5u W=1u
M8707 o6 ibias vss vss sky130_fd_pr__nfet_01v8 L=0.5u W=1u
M8708 o6 ibias vss vss sky130_fd_pr__nfet_01v8 L=0.5u W=1u
M8709 o6 ibias vss vss sky130_fd_pr__nfet_01v8 L=0.5u W=1u
M8710 o6 ibias vss vss sky130_fd_pr__nfet_01v8 L=0.5u W=1u
M8711 o6 ibias vss vss sky130_fd_pr__nfet_01v8 L=0.5u W=1u
M8712 o6 ibias vss vss sky130_fd_pr__nfet_01v8 L=0.5u W=1u
M8713 o6 ibias vss vss sky130_fd_pr__nfet_01v8 L=0.5u W=1u
M8714 o6 ibias vss vss sky130_fd_pr__nfet_01v8 L=0.5u W=1u
M8715 o6 ibias vss vss sky130_fd_pr__nfet_01v8 L=0.5u W=1u
M8716 o6 ibias vss vss sky130_fd_pr__nfet_01v8 L=0.5u W=1u
M8717 o6 ibias vss vss sky130_fd_pr__nfet_01v8 L=0.5u W=1u
M8718 o6 ibias vss vss sky130_fd_pr__nfet_01v8 L=0.5u W=1u
M8719 o6 ibias vss vss sky130_fd_pr__nfet_01v8 L=0.5u W=1u
M8720 o6 ibias vss vss sky130_fd_pr__nfet_01v8 L=0.5u W=1u
M8721 o6 ibias vss vss sky130_fd_pr__nfet_01v8 L=0.5u W=1u
M8722 o6 ibias vss vss sky130_fd_pr__nfet_01v8 L=0.5u W=1u
M8723 o6 ibias vss vss sky130_fd_pr__nfet_01v8 L=0.5u W=1u
M8724 o6 ibias vss vss sky130_fd_pr__nfet_01v8 L=0.5u W=1u
M8725 o6 ibias vss vss sky130_fd_pr__nfet_01v8 L=0.5u W=1u
M8726 o6 ibias vss vss sky130_fd_pr__nfet_01v8 L=0.5u W=1u
M8727 o6 ibias vss vss sky130_fd_pr__nfet_01v8 L=0.5u W=1u
M8728 o6 ibias vss vss sky130_fd_pr__nfet_01v8 L=0.5u W=1u
M8729 o6 ibias vss vss sky130_fd_pr__nfet_01v8 L=0.5u W=1u
M8730 o6 ibias vss vss sky130_fd_pr__nfet_01v8 L=0.5u W=1u
M8731 o6 ibias vss vss sky130_fd_pr__nfet_01v8 L=0.5u W=1u
M8732 o6 ibias vss vss sky130_fd_pr__nfet_01v8 L=0.5u W=1u
M8733 o6 ibias vss vss sky130_fd_pr__nfet_01v8 L=0.5u W=1u
M8734 o6 ibias vss vss sky130_fd_pr__nfet_01v8 L=0.5u W=1u
M8735 o6 ibias vss vss sky130_fd_pr__nfet_01v8 L=0.5u W=1u
M8736 o6 ibias vss vss sky130_fd_pr__nfet_01v8 L=0.5u W=1u
M8737 o6 ibias vss vss sky130_fd_pr__nfet_01v8 L=0.5u W=1u
M8738 o6 ibias vss vss sky130_fd_pr__nfet_01v8 L=0.5u W=1u
M8739 o6 ibias vss vss sky130_fd_pr__nfet_01v8 L=0.5u W=1u
M8740 o6 ibias vss vss sky130_fd_pr__nfet_01v8 L=0.5u W=1u
M8741 o6 ibias vss vss sky130_fd_pr__nfet_01v8 L=0.5u W=1u
M8742 o6 ibias vss vss sky130_fd_pr__nfet_01v8 L=0.5u W=1u
M8743 o6 ibias vss vss sky130_fd_pr__nfet_01v8 L=0.5u W=1u
M8744 o6 ibias vss vss sky130_fd_pr__nfet_01v8 L=0.5u W=1u
M8745 o6 ibias vss vss sky130_fd_pr__nfet_01v8 L=0.5u W=1u
M8746 o6 ibias vss vss sky130_fd_pr__nfet_01v8 L=0.5u W=1u
M8747 o6 ibias vss vss sky130_fd_pr__nfet_01v8 L=0.5u W=1u
M8748 o6 ibias vss vss sky130_fd_pr__nfet_01v8 L=0.5u W=1u
M8749 o6 ibias vss vss sky130_fd_pr__nfet_01v8 L=0.5u W=1u
M8750 o6 ibias vss vss sky130_fd_pr__nfet_01v8 L=0.5u W=1u
M8751 o6 ibias vss vss sky130_fd_pr__nfet_01v8 L=0.5u W=1u
M8752 o6 ibias vss vss sky130_fd_pr__nfet_01v8 L=0.5u W=1u
M8753 o6 ibias vss vss sky130_fd_pr__nfet_01v8 L=0.5u W=1u
M8754 o6 ibias vss vss sky130_fd_pr__nfet_01v8 L=0.5u W=1u
M8755 o6 ibias vss vss sky130_fd_pr__nfet_01v8 L=0.5u W=1u
M8756 o6 ibias vss vss sky130_fd_pr__nfet_01v8 L=0.5u W=1u
M8757 o6 ibias vss vss sky130_fd_pr__nfet_01v8 L=0.5u W=1u
M8758 o6 ibias vss vss sky130_fd_pr__nfet_01v8 L=0.5u W=1u
M8759 o6 ibias vss vss sky130_fd_pr__nfet_01v8 L=0.5u W=1u
M8760 o6 ibias vss vss sky130_fd_pr__nfet_01v8 L=0.5u W=1u
M8761 o6 ibias vss vss sky130_fd_pr__nfet_01v8 L=0.5u W=1u
M8762 o6 ibias vss vss sky130_fd_pr__nfet_01v8 L=0.5u W=1u
M8763 o6 ibias vss vss sky130_fd_pr__nfet_01v8 L=0.5u W=1u
M8764 o6 ibias vss vss sky130_fd_pr__nfet_01v8 L=0.5u W=1u
M8765 o6 ibias vss vss sky130_fd_pr__nfet_01v8 L=0.5u W=1u
M8766 o6 ibias vss vss sky130_fd_pr__nfet_01v8 L=0.5u W=1u
M8767 o6 ibias vss vss sky130_fd_pr__nfet_01v8 L=0.5u W=1u
M8768 o6 ibias vss vss sky130_fd_pr__nfet_01v8 L=0.5u W=1u
M8769 o6 ibias vss vss sky130_fd_pr__nfet_01v8 L=0.5u W=1u
M8770 o6 ibias vss vss sky130_fd_pr__nfet_01v8 L=0.5u W=1u
M8771 o6 ibias vss vss sky130_fd_pr__nfet_01v8 L=0.5u W=1u
M8772 o6 ibias vss vss sky130_fd_pr__nfet_01v8 L=0.5u W=1u
M8773 o6 ibias vss vss sky130_fd_pr__nfet_01v8 L=0.5u W=1u
M8774 o6 ibias vss vss sky130_fd_pr__nfet_01v8 L=0.5u W=1u
M8775 o6 ibias vss vss sky130_fd_pr__nfet_01v8 L=0.5u W=1u
M8776 o6 ibias vss vss sky130_fd_pr__nfet_01v8 L=0.5u W=1u
M8777 o6 ibias vss vss sky130_fd_pr__nfet_01v8 L=0.5u W=1u
M8778 o6 ibias vss vss sky130_fd_pr__nfet_01v8 L=0.5u W=1u
M8779 o6 ibias vss vss sky130_fd_pr__nfet_01v8 L=0.5u W=1u
M8780 o6 ibias vss vss sky130_fd_pr__nfet_01v8 L=0.5u W=1u
M8781 o6 ibias vss vss sky130_fd_pr__nfet_01v8 L=0.5u W=1u
M8782 o6 ibias vss vss sky130_fd_pr__nfet_01v8 L=0.5u W=1u
M8783 o6 ibias vss vss sky130_fd_pr__nfet_01v8 L=0.5u W=1u
M8784 o6 ibias vss vss sky130_fd_pr__nfet_01v8 L=0.5u W=1u
M8785 o6 ibias vss vss sky130_fd_pr__nfet_01v8 L=0.5u W=1u
M8786 o6 ibias vss vss sky130_fd_pr__nfet_01v8 L=0.5u W=1u
M8787 o6 ibias vss vss sky130_fd_pr__nfet_01v8 L=0.5u W=1u
M8788 o6 ibias vss vss sky130_fd_pr__nfet_01v8 L=0.5u W=1u
M8789 o6 ibias vss vss sky130_fd_pr__nfet_01v8 L=0.5u W=1u
M8790 o6 ibias vss vss sky130_fd_pr__nfet_01v8 L=0.5u W=1u
M8791 o6 ibias vss vss sky130_fd_pr__nfet_01v8 L=0.5u W=1u
M8792 o6 ibias vss vss sky130_fd_pr__nfet_01v8 L=0.5u W=1u
M8793 o6 ibias vss vss sky130_fd_pr__nfet_01v8 L=0.5u W=1u
M8794 o6 ibias vss vss sky130_fd_pr__nfet_01v8 L=0.5u W=1u
M8795 o6 ibias vss vss sky130_fd_pr__nfet_01v8 L=0.5u W=1u
M8796 o6 ibias vss vss sky130_fd_pr__nfet_01v8 L=0.5u W=1u
M8797 o6 ibias vss vss sky130_fd_pr__nfet_01v8 L=0.5u W=1u
M8798 o6 ibias vss vss sky130_fd_pr__nfet_01v8 L=0.5u W=1u
M8799 o6 ibias vss vss sky130_fd_pr__nfet_01v8 L=0.5u W=1u
M8800 o6 ibias vss vss sky130_fd_pr__nfet_01v8 L=0.5u W=1u
M8801 o6 ibias vss vss sky130_fd_pr__nfet_01v8 L=0.5u W=1u
M8802 o6 ibias vss vss sky130_fd_pr__nfet_01v8 L=0.5u W=1u
M8803 o6 ibias vss vss sky130_fd_pr__nfet_01v8 L=0.5u W=1u
M8804 o6 ibias vss vss sky130_fd_pr__nfet_01v8 L=0.5u W=1u
M8805 o6 ibias vss vss sky130_fd_pr__nfet_01v8 L=0.5u W=1u
M8806 o6 ibias vss vss sky130_fd_pr__nfet_01v8 L=0.5u W=1u
M8807 o6 ibias vss vss sky130_fd_pr__nfet_01v8 L=0.5u W=1u
M8808 o6 ibias vss vss sky130_fd_pr__nfet_01v8 L=0.5u W=1u
M8809 o6 ibias vss vss sky130_fd_pr__nfet_01v8 L=0.5u W=1u
M8810 o6 ibias vss vss sky130_fd_pr__nfet_01v8 L=0.5u W=1u
M8811 o6 ibias vss vss sky130_fd_pr__nfet_01v8 L=0.5u W=1u
M8812 o6 ibias vss vss sky130_fd_pr__nfet_01v8 L=0.5u W=1u
M8813 o6 ibias vss vss sky130_fd_pr__nfet_01v8 L=0.5u W=1u
M8814 o6 ibias vss vss sky130_fd_pr__nfet_01v8 L=0.5u W=1u
M8815 o6 ibias vss vss sky130_fd_pr__nfet_01v8 L=0.5u W=1u
M8816 o6 ibias vss vss sky130_fd_pr__nfet_01v8 L=0.5u W=1u
M8817 o6 ibias vss vss sky130_fd_pr__nfet_01v8 L=0.5u W=1u
M8818 o6 ibias vss vss sky130_fd_pr__nfet_01v8 L=0.5u W=1u
M8819 o6 ibias vss vss sky130_fd_pr__nfet_01v8 L=0.5u W=1u
M8820 o6 ibias vss vss sky130_fd_pr__nfet_01v8 L=0.5u W=1u
M8821 o6 ibias vss vss sky130_fd_pr__nfet_01v8 L=0.5u W=1u
M8822 o6 ibias vss vss sky130_fd_pr__nfet_01v8 L=0.5u W=1u
M8823 o6 ibias vss vss sky130_fd_pr__nfet_01v8 L=0.5u W=1u
M8824 o6 ibias vss vss sky130_fd_pr__nfet_01v8 L=0.5u W=1u
M8825 o6 ibias vss vss sky130_fd_pr__nfet_01v8 L=0.5u W=1u
M8826 o6 ibias vss vss sky130_fd_pr__nfet_01v8 L=0.5u W=1u
M8827 o6 ibias vss vss sky130_fd_pr__nfet_01v8 L=0.5u W=1u
M8828 o6 ibias vss vss sky130_fd_pr__nfet_01v8 L=0.5u W=1u
M8829 o6 ibias vss vss sky130_fd_pr__nfet_01v8 L=0.5u W=1u
M8830 o6 ibias vss vss sky130_fd_pr__nfet_01v8 L=0.5u W=1u
M8831 o6 ibias vss vss sky130_fd_pr__nfet_01v8 L=0.5u W=1u
M8832 o6 ibias vss vss sky130_fd_pr__nfet_01v8 L=0.5u W=1u
M8833 o6 ibias vss vss sky130_fd_pr__nfet_01v8 L=0.5u W=1u
M8834 o6 ibias vss vss sky130_fd_pr__nfet_01v8 L=0.5u W=1u
M8835 o6 ibias vss vss sky130_fd_pr__nfet_01v8 L=0.5u W=1u
M8836 o6 ibias vss vss sky130_fd_pr__nfet_01v8 L=0.5u W=1u
M8837 o6 ibias vss vss sky130_fd_pr__nfet_01v8 L=0.5u W=1u
M8838 o6 ibias vss vss sky130_fd_pr__nfet_01v8 L=0.5u W=1u
M8839 o6 ibias vss vss sky130_fd_pr__nfet_01v8 L=0.5u W=1u
M8840 o6 ibias vss vss sky130_fd_pr__nfet_01v8 L=0.5u W=1u
M8841 o6 ibias vss vss sky130_fd_pr__nfet_01v8 L=0.5u W=1u
M8842 o6 ibias vss vss sky130_fd_pr__nfet_01v8 L=0.5u W=1u
M8843 o6 ibias vss vss sky130_fd_pr__nfet_01v8 L=0.5u W=1u
M8844 o6 ibias vss vss sky130_fd_pr__nfet_01v8 L=0.5u W=1u
M8845 o6 ibias vss vss sky130_fd_pr__nfet_01v8 L=0.5u W=1u
M8846 o6 ibias vss vss sky130_fd_pr__nfet_01v8 L=0.5u W=1u
M8847 o6 ibias vss vss sky130_fd_pr__nfet_01v8 L=0.5u W=1u
M8848 o6 ibias vss vss sky130_fd_pr__nfet_01v8 L=0.5u W=1u
M8849 o6 ibias vss vss sky130_fd_pr__nfet_01v8 L=0.5u W=1u
M8850 o6 ibias vss vss sky130_fd_pr__nfet_01v8 L=0.5u W=1u
M8851 o6 ibias vss vss sky130_fd_pr__nfet_01v8 L=0.5u W=1u
M8852 o6 ibias vss vss sky130_fd_pr__nfet_01v8 L=0.5u W=1u
M8853 o6 ibias vss vss sky130_fd_pr__nfet_01v8 L=0.5u W=1u
M8854 o6 ibias vss vss sky130_fd_pr__nfet_01v8 L=0.5u W=1u
M8855 o6 ibias vss vss sky130_fd_pr__nfet_01v8 L=0.5u W=1u
M8856 o6 ibias vss vss sky130_fd_pr__nfet_01v8 L=0.5u W=1u
M8857 o6 ibias vss vss sky130_fd_pr__nfet_01v8 L=0.5u W=1u
M8858 o6 ibias vss vss sky130_fd_pr__nfet_01v8 L=0.5u W=1u
M8859 o6 ibias vss vss sky130_fd_pr__nfet_01v8 L=0.5u W=1u
M8860 o6 ibias vss vss sky130_fd_pr__nfet_01v8 L=0.5u W=1u
M8861 o6 ibias vss vss sky130_fd_pr__nfet_01v8 L=0.5u W=1u
M8862 o6 ibias vss vss sky130_fd_pr__nfet_01v8 L=0.5u W=1u
M8863 o6 ibias vss vss sky130_fd_pr__nfet_01v8 L=0.5u W=1u
M8864 o6 ibias vss vss sky130_fd_pr__nfet_01v8 L=0.5u W=1u
M8865 o6 ibias vss vss sky130_fd_pr__nfet_01v8 L=0.5u W=1u
M8866 o6 ibias vss vss sky130_fd_pr__nfet_01v8 L=0.5u W=1u
M8867 o6 ibias vss vss sky130_fd_pr__nfet_01v8 L=0.5u W=1u
M8868 o6 ibias vss vss sky130_fd_pr__nfet_01v8 L=0.5u W=1u
M8869 o6 ibias vss vss sky130_fd_pr__nfet_01v8 L=0.5u W=1u
M8870 o6 ibias vss vss sky130_fd_pr__nfet_01v8 L=0.5u W=1u
M8871 o6 ibias vss vss sky130_fd_pr__nfet_01v8 L=0.5u W=1u
M8872 o6 ibias vss vss sky130_fd_pr__nfet_01v8 L=0.5u W=1u
M8873 o6 ibias vss vss sky130_fd_pr__nfet_01v8 L=0.5u W=1u
M8874 o6 ibias vss vss sky130_fd_pr__nfet_01v8 L=0.5u W=1u
M8875 o6 ibias vss vss sky130_fd_pr__nfet_01v8 L=0.5u W=1u
M8876 o6 ibias vss vss sky130_fd_pr__nfet_01v8 L=0.5u W=1u
M8877 o6 ibias vss vss sky130_fd_pr__nfet_01v8 L=0.5u W=1u
M8878 o6 ibias vss vss sky130_fd_pr__nfet_01v8 L=0.5u W=1u
M8879 o6 ibias vss vss sky130_fd_pr__nfet_01v8 L=0.5u W=1u
M8880 o6 ibias vss vss sky130_fd_pr__nfet_01v8 L=0.5u W=1u
M8881 o6 ibias vss vss sky130_fd_pr__nfet_01v8 L=0.5u W=1u
M8882 o6 ibias vss vss sky130_fd_pr__nfet_01v8 L=0.5u W=1u
M8883 o6 ibias vss vss sky130_fd_pr__nfet_01v8 L=0.5u W=1u
M8884 o6 ibias vss vss sky130_fd_pr__nfet_01v8 L=0.5u W=1u
M8885 o6 ibias vss vss sky130_fd_pr__nfet_01v8 L=0.5u W=1u
M8886 o6 ibias vss vss sky130_fd_pr__nfet_01v8 L=0.5u W=1u
M8887 o6 ibias vss vss sky130_fd_pr__nfet_01v8 L=0.5u W=1u
M8888 o6 ibias vss vss sky130_fd_pr__nfet_01v8 L=0.5u W=1u
M8889 o6 ibias vss vss sky130_fd_pr__nfet_01v8 L=0.5u W=1u
M8890 o6 ibias vss vss sky130_fd_pr__nfet_01v8 L=0.5u W=1u
M8891 o6 ibias vss vss sky130_fd_pr__nfet_01v8 L=0.5u W=1u
M8892 o6 ibias vss vss sky130_fd_pr__nfet_01v8 L=0.5u W=1u
M8893 o6 ibias vss vss sky130_fd_pr__nfet_01v8 L=0.5u W=1u
M8894 o6 ibias vss vss sky130_fd_pr__nfet_01v8 L=0.5u W=1u
M8895 o6 ibias vss vss sky130_fd_pr__nfet_01v8 L=0.5u W=1u
M8896 o6 ibias vss vss sky130_fd_pr__nfet_01v8 L=0.5u W=1u
M8897 o6 ibias vss vss sky130_fd_pr__nfet_01v8 L=0.5u W=1u
M8898 o6 ibias vss vss sky130_fd_pr__nfet_01v8 L=0.5u W=1u
M8899 o6 ibias vss vss sky130_fd_pr__nfet_01v8 L=0.5u W=1u
M8900 o6 ibias vss vss sky130_fd_pr__nfet_01v8 L=0.5u W=1u
M8901 o6 ibias vss vss sky130_fd_pr__nfet_01v8 L=0.5u W=1u
M8902 o6 ibias vss vss sky130_fd_pr__nfet_01v8 L=0.5u W=1u
M8903 o6 ibias vss vss sky130_fd_pr__nfet_01v8 L=0.5u W=1u
M8904 o6 ibias vss vss sky130_fd_pr__nfet_01v8 L=0.5u W=1u
M8905 o6 ibias vss vss sky130_fd_pr__nfet_01v8 L=0.5u W=1u
M8906 o6 ibias vss vss sky130_fd_pr__nfet_01v8 L=0.5u W=1u
M8907 o6 ibias vss vss sky130_fd_pr__nfet_01v8 L=0.5u W=1u
M8908 o6 ibias vss vss sky130_fd_pr__nfet_01v8 L=0.5u W=1u
M8909 o6 ibias vss vss sky130_fd_pr__nfet_01v8 L=0.5u W=1u
M8910 o6 ibias vss vss sky130_fd_pr__nfet_01v8 L=0.5u W=1u
M8911 o6 ibias vss vss sky130_fd_pr__nfet_01v8 L=0.5u W=1u
M8912 o6 ibias vss vss sky130_fd_pr__nfet_01v8 L=0.5u W=1u
M8913 o6 ibias vss vss sky130_fd_pr__nfet_01v8 L=0.5u W=1u
M8914 o6 ibias vss vss sky130_fd_pr__nfet_01v8 L=0.5u W=1u
M8915 o6 ibias vss vss sky130_fd_pr__nfet_01v8 L=0.5u W=1u
M8916 o6 ibias vss vss sky130_fd_pr__nfet_01v8 L=0.5u W=1u
M8917 o6 ibias vss vss sky130_fd_pr__nfet_01v8 L=0.5u W=1u
M8918 o6 ibias vss vss sky130_fd_pr__nfet_01v8 L=0.5u W=1u
M8919 o6 ibias vss vss sky130_fd_pr__nfet_01v8 L=0.5u W=1u
M8920 o6 ibias vss vss sky130_fd_pr__nfet_01v8 L=0.5u W=1u
M8921 o6 ibias vss vss sky130_fd_pr__nfet_01v8 L=0.5u W=1u
M8922 o6 ibias vss vss sky130_fd_pr__nfet_01v8 L=0.5u W=1u
M8923 o6 ibias vss vss sky130_fd_pr__nfet_01v8 L=0.5u W=1u
M8924 o6 ibias vss vss sky130_fd_pr__nfet_01v8 L=0.5u W=1u
M8925 o6 ibias vss vss sky130_fd_pr__nfet_01v8 L=0.5u W=1u
M8926 o6 ibias vss vss sky130_fd_pr__nfet_01v8 L=0.5u W=1u
M8927 o6 ibias vss vss sky130_fd_pr__nfet_01v8 L=0.5u W=1u
M8928 o6 ibias vss vss sky130_fd_pr__nfet_01v8 L=0.5u W=1u
M8929 o6 ibias vss vss sky130_fd_pr__nfet_01v8 L=0.5u W=1u
M8930 o6 ibias vss vss sky130_fd_pr__nfet_01v8 L=0.5u W=1u
M8931 o6 ibias vss vss sky130_fd_pr__nfet_01v8 L=0.5u W=1u
M8932 o6 ibias vss vss sky130_fd_pr__nfet_01v8 L=0.5u W=1u
M8933 o6 ibias vss vss sky130_fd_pr__nfet_01v8 L=0.5u W=1u
M8934 o6 ibias vss vss sky130_fd_pr__nfet_01v8 L=0.5u W=1u
M8935 o6 ibias vss vss sky130_fd_pr__nfet_01v8 L=0.5u W=1u
M8936 o6 ibias vss vss sky130_fd_pr__nfet_01v8 L=0.5u W=1u
M8937 o6 ibias vss vss sky130_fd_pr__nfet_01v8 L=0.5u W=1u
M8938 o6 ibias vss vss sky130_fd_pr__nfet_01v8 L=0.5u W=1u
M8939 o6 ibias vss vss sky130_fd_pr__nfet_01v8 L=0.5u W=1u
M8940 o6 ibias vss vss sky130_fd_pr__nfet_01v8 L=0.5u W=1u
M8941 o6 ibias vss vss sky130_fd_pr__nfet_01v8 L=0.5u W=1u
M8942 o6 ibias vss vss sky130_fd_pr__nfet_01v8 L=0.5u W=1u
M8943 o6 ibias vss vss sky130_fd_pr__nfet_01v8 L=0.5u W=1u
M8944 o6 ibias vss vss sky130_fd_pr__nfet_01v8 L=0.5u W=1u
M8945 o6 ibias vss vss sky130_fd_pr__nfet_01v8 L=0.5u W=1u
M8946 o6 ibias vss vss sky130_fd_pr__nfet_01v8 L=0.5u W=1u
M8947 o6 ibias vss vss sky130_fd_pr__nfet_01v8 L=0.5u W=1u
M8948 o6 ibias vss vss sky130_fd_pr__nfet_01v8 L=0.5u W=1u
M8949 o6 ibias vss vss sky130_fd_pr__nfet_01v8 L=0.5u W=1u
M8950 o6 ibias vss vss sky130_fd_pr__nfet_01v8 L=0.5u W=1u
M8951 o6 ibias vss vss sky130_fd_pr__nfet_01v8 L=0.5u W=1u
M8952 o6 ibias vss vss sky130_fd_pr__nfet_01v8 L=0.5u W=1u
M8953 o6 ibias vss vss sky130_fd_pr__nfet_01v8 L=0.5u W=1u
M8954 o6 ibias vss vss sky130_fd_pr__nfet_01v8 L=0.5u W=1u
M8955 o6 ibias vss vss sky130_fd_pr__nfet_01v8 L=0.5u W=1u
M8956 o6 ibias vss vss sky130_fd_pr__nfet_01v8 L=0.5u W=1u
M8957 o6 ibias vss vss sky130_fd_pr__nfet_01v8 L=0.5u W=1u
M8958 o6 ibias vss vss sky130_fd_pr__nfet_01v8 L=0.5u W=1u
M8959 o6 ibias vss vss sky130_fd_pr__nfet_01v8 L=0.5u W=1u
M8960 o6 ibias vss vss sky130_fd_pr__nfet_01v8 L=0.5u W=1u
M8961 o6 ibias vss vss sky130_fd_pr__nfet_01v8 L=0.5u W=1u
M8962 o6 ibias vss vss sky130_fd_pr__nfet_01v8 L=0.5u W=1u
M8963 o6 ibias vss vss sky130_fd_pr__nfet_01v8 L=0.5u W=1u
M8964 o6 ibias vss vss sky130_fd_pr__nfet_01v8 L=0.5u W=1u
M8965 o6 ibias vss vss sky130_fd_pr__nfet_01v8 L=0.5u W=1u
M8966 o6 ibias vss vss sky130_fd_pr__nfet_01v8 L=0.5u W=1u
M8967 o6 ibias vss vss sky130_fd_pr__nfet_01v8 L=0.5u W=1u
M8968 o6 ibias vss vss sky130_fd_pr__nfet_01v8 L=0.5u W=1u
M8969 o6 ibias vss vss sky130_fd_pr__nfet_01v8 L=0.5u W=1u
M8970 o6 ibias vss vss sky130_fd_pr__nfet_01v8 L=0.5u W=1u
M8971 o6 ibias vss vss sky130_fd_pr__nfet_01v8 L=0.5u W=1u
M8972 o6 ibias vss vss sky130_fd_pr__nfet_01v8 L=0.5u W=1u
M8973 o6 ibias vss vss sky130_fd_pr__nfet_01v8 L=0.5u W=1u
M8974 o6 ibias vss vss sky130_fd_pr__nfet_01v8 L=0.5u W=1u
M8975 o6 ibias vss vss sky130_fd_pr__nfet_01v8 L=0.5u W=1u
M8976 o6 ibias vss vss sky130_fd_pr__nfet_01v8 L=0.5u W=1u
M8977 o6 ibias vss vss sky130_fd_pr__nfet_01v8 L=0.5u W=1u
M8978 o6 ibias vss vss sky130_fd_pr__nfet_01v8 L=0.5u W=1u
M8979 o6 ibias vss vss sky130_fd_pr__nfet_01v8 L=0.5u W=1u
M8980 o6 ibias vss vss sky130_fd_pr__nfet_01v8 L=0.5u W=1u
M8981 o6 ibias vss vss sky130_fd_pr__nfet_01v8 L=0.5u W=1u
M8982 o6 ibias vss vss sky130_fd_pr__nfet_01v8 L=0.5u W=1u
M8983 o6 ibias vss vss sky130_fd_pr__nfet_01v8 L=0.5u W=1u
M8984 o6 ibias vss vss sky130_fd_pr__nfet_01v8 L=0.5u W=1u
M8985 o6 ibias vss vss sky130_fd_pr__nfet_01v8 L=0.5u W=1u
M8986 o6 ibias vss vss sky130_fd_pr__nfet_01v8 L=0.5u W=1u
M8987 o6 ibias vss vss sky130_fd_pr__nfet_01v8 L=0.5u W=1u
M8988 o6 ibias vss vss sky130_fd_pr__nfet_01v8 L=0.5u W=1u
M8989 o6 ibias vss vss sky130_fd_pr__nfet_01v8 L=0.5u W=1u
M8990 o6 ibias vss vss sky130_fd_pr__nfet_01v8 L=0.5u W=1u
M8991 o6 ibias vss vss sky130_fd_pr__nfet_01v8 L=0.5u W=1u
M8992 o6 ibias vss vss sky130_fd_pr__nfet_01v8 L=0.5u W=1u
M8993 o6 ibias vss vss sky130_fd_pr__nfet_01v8 L=0.5u W=1u
M8994 o6 ibias vss vss sky130_fd_pr__nfet_01v8 L=0.5u W=1u
M8995 o6 ibias vss vss sky130_fd_pr__nfet_01v8 L=0.5u W=1u
M8996 o6 ibias vss vss sky130_fd_pr__nfet_01v8 L=0.5u W=1u
M8997 o6 ibias vss vss sky130_fd_pr__nfet_01v8 L=0.5u W=1u
M8998 o6 ibias vss vss sky130_fd_pr__nfet_01v8 L=0.5u W=1u
M8999 o6 ibias vss vss sky130_fd_pr__nfet_01v8 L=0.5u W=1u
M9000 o6 ibias vss vss sky130_fd_pr__nfet_01v8 L=0.5u W=1u
M9001 o6 ibias vss vss sky130_fd_pr__nfet_01v8 L=0.5u W=1u
M9002 o6 ibias vss vss sky130_fd_pr__nfet_01v8 L=0.5u W=1u
M9003 o6 ibias vss vss sky130_fd_pr__nfet_01v8 L=0.5u W=1u
M9004 o6 ibias vss vss sky130_fd_pr__nfet_01v8 L=0.5u W=1u
M9005 o6 ibias vss vss sky130_fd_pr__nfet_01v8 L=0.5u W=1u
M9006 o6 ibias vss vss sky130_fd_pr__nfet_01v8 L=0.5u W=1u
M9007 o6 ibias vss vss sky130_fd_pr__nfet_01v8 L=0.5u W=1u
M9008 o6 ibias vss vss sky130_fd_pr__nfet_01v8 L=0.5u W=1u
M9009 o6 ibias vss vss sky130_fd_pr__nfet_01v8 L=0.5u W=1u
M9010 o6 ibias vss vss sky130_fd_pr__nfet_01v8 L=0.5u W=1u
M9011 o6 ibias vss vss sky130_fd_pr__nfet_01v8 L=0.5u W=1u
M9012 o6 ibias vss vss sky130_fd_pr__nfet_01v8 L=0.5u W=1u
M9013 o6 ibias vss vss sky130_fd_pr__nfet_01v8 L=0.5u W=1u
M9014 o6 ibias vss vss sky130_fd_pr__nfet_01v8 L=0.5u W=1u
M9015 o6 ibias vss vss sky130_fd_pr__nfet_01v8 L=0.5u W=1u
M9016 o6 ibias vss vss sky130_fd_pr__nfet_01v8 L=0.5u W=1u
M9017 o6 ibias vss vss sky130_fd_pr__nfet_01v8 L=0.5u W=1u
M9018 o6 ibias vss vss sky130_fd_pr__nfet_01v8 L=0.5u W=1u
M9019 o6 ibias vss vss sky130_fd_pr__nfet_01v8 L=0.5u W=1u
M9020 o6 ibias vss vss sky130_fd_pr__nfet_01v8 L=0.5u W=1u
M9021 o6 ibias vss vss sky130_fd_pr__nfet_01v8 L=0.5u W=1u
M9022 o6 ibias vss vss sky130_fd_pr__nfet_01v8 L=0.5u W=1u
M9023 o6 ibias vss vss sky130_fd_pr__nfet_01v8 L=0.5u W=1u
M9024 o6 ibias vss vss sky130_fd_pr__nfet_01v8 L=0.5u W=1u
M9025 o6 ibias vss vss sky130_fd_pr__nfet_01v8 L=0.5u W=1u
M9026 o6 ibias vss vss sky130_fd_pr__nfet_01v8 L=0.5u W=1u
M9027 o6 ibias vss vss sky130_fd_pr__nfet_01v8 L=0.5u W=1u
M9028 o6 ibias vss vss sky130_fd_pr__nfet_01v8 L=0.5u W=1u
M9029 o6 ibias vss vss sky130_fd_pr__nfet_01v8 L=0.5u W=1u
M9030 o6 ibias vss vss sky130_fd_pr__nfet_01v8 L=0.5u W=1u
M9031 o6 ibias vss vss sky130_fd_pr__nfet_01v8 L=0.5u W=1u
M9032 o6 ibias vss vss sky130_fd_pr__nfet_01v8 L=0.5u W=1u
M9033 o6 ibias vss vss sky130_fd_pr__nfet_01v8 L=0.5u W=1u
M9034 o6 ibias vss vss sky130_fd_pr__nfet_01v8 L=0.5u W=1u
M9035 o6 ibias vss vss sky130_fd_pr__nfet_01v8 L=0.5u W=1u
M9036 o6 ibias vss vss sky130_fd_pr__nfet_01v8 L=0.5u W=1u
M9037 o6 ibias vss vss sky130_fd_pr__nfet_01v8 L=0.5u W=1u
M9038 o6 ibias vss vss sky130_fd_pr__nfet_01v8 L=0.5u W=1u
M9039 o6 ibias vss vss sky130_fd_pr__nfet_01v8 L=0.5u W=1u
M9040 o6 ibias vss vss sky130_fd_pr__nfet_01v8 L=0.5u W=1u
M9041 o6 ibias vss vss sky130_fd_pr__nfet_01v8 L=0.5u W=1u
M9042 o6 ibias vss vss sky130_fd_pr__nfet_01v8 L=0.5u W=1u
M9043 o6 ibias vss vss sky130_fd_pr__nfet_01v8 L=0.5u W=1u
M9044 o6 ibias vss vss sky130_fd_pr__nfet_01v8 L=0.5u W=1u
M9045 o6 ibias vss vss sky130_fd_pr__nfet_01v8 L=0.5u W=1u
M9046 o6 ibias vss vss sky130_fd_pr__nfet_01v8 L=0.5u W=1u
M9047 o6 ibias vss vss sky130_fd_pr__nfet_01v8 L=0.5u W=1u
M9048 o6 ibias vss vss sky130_fd_pr__nfet_01v8 L=0.5u W=1u
M9049 o6 ibias vss vss sky130_fd_pr__nfet_01v8 L=0.5u W=1u
M9050 o6 ibias vss vss sky130_fd_pr__nfet_01v8 L=0.5u W=1u
M9051 o6 ibias vss vss sky130_fd_pr__nfet_01v8 L=0.5u W=1u
M9052 o6 ibias vss vss sky130_fd_pr__nfet_01v8 L=0.5u W=1u
M9053 o6 ibias vss vss sky130_fd_pr__nfet_01v8 L=0.5u W=1u
M9054 o6 ibias vss vss sky130_fd_pr__nfet_01v8 L=0.5u W=1u
M9055 o6 ibias vss vss sky130_fd_pr__nfet_01v8 L=0.5u W=1u
M9056 o6 ibias vss vss sky130_fd_pr__nfet_01v8 L=0.5u W=1u
M9057 o6 ibias vss vss sky130_fd_pr__nfet_01v8 L=0.5u W=1u
M9058 o6 ibias vss vss sky130_fd_pr__nfet_01v8 L=0.5u W=1u
M9059 o6 ibias vss vss sky130_fd_pr__nfet_01v8 L=0.5u W=1u
M9060 o6 ibias vss vss sky130_fd_pr__nfet_01v8 L=0.5u W=1u
M9061 o6 ibias vss vss sky130_fd_pr__nfet_01v8 L=0.5u W=1u
M9062 o6 ibias vss vss sky130_fd_pr__nfet_01v8 L=0.5u W=1u
M9063 o6 ibias vss vss sky130_fd_pr__nfet_01v8 L=0.5u W=1u
M9064 o6 ibias vss vss sky130_fd_pr__nfet_01v8 L=0.5u W=1u
M9065 o6 ibias vss vss sky130_fd_pr__nfet_01v8 L=0.5u W=1u
M9066 o6 ibias vss vss sky130_fd_pr__nfet_01v8 L=0.5u W=1u
M9067 o6 ibias vss vss sky130_fd_pr__nfet_01v8 L=0.5u W=1u
M9068 o6 ibias vss vss sky130_fd_pr__nfet_01v8 L=0.5u W=1u
M9069 o6 ibias vss vss sky130_fd_pr__nfet_01v8 L=0.5u W=1u
M9070 o6 ibias vss vss sky130_fd_pr__nfet_01v8 L=0.5u W=1u
M9071 o6 ibias vss vss sky130_fd_pr__nfet_01v8 L=0.5u W=1u
M9072 o6 ibias vss vss sky130_fd_pr__nfet_01v8 L=0.5u W=1u
M9073 o6 ibias vss vss sky130_fd_pr__nfet_01v8 L=0.5u W=1u
M9074 o6 ibias vss vss sky130_fd_pr__nfet_01v8 L=0.5u W=1u
M9075 o6 ibias vss vss sky130_fd_pr__nfet_01v8 L=0.5u W=1u
M9076 o6 ibias vss vss sky130_fd_pr__nfet_01v8 L=0.5u W=1u
M9077 o6 ibias vss vss sky130_fd_pr__nfet_01v8 L=0.5u W=1u
M9078 o6 ibias vss vss sky130_fd_pr__nfet_01v8 L=0.5u W=1u
M9079 o6 ibias vss vss sky130_fd_pr__nfet_01v8 L=0.5u W=1u
M9080 o6 ibias vss vss sky130_fd_pr__nfet_01v8 L=0.5u W=1u
M9081 o6 ibias vss vss sky130_fd_pr__nfet_01v8 L=0.5u W=1u
M9082 o6 ibias vss vss sky130_fd_pr__nfet_01v8 L=0.5u W=1u
M9083 o6 ibias vss vss sky130_fd_pr__nfet_01v8 L=0.5u W=1u
M9084 o6 ibias vss vss sky130_fd_pr__nfet_01v8 L=0.5u W=1u
M9085 o6 ibias vss vss sky130_fd_pr__nfet_01v8 L=0.5u W=1u
M9086 o6 ibias vss vss sky130_fd_pr__nfet_01v8 L=0.5u W=1u
M9087 o6 ibias vss vss sky130_fd_pr__nfet_01v8 L=0.5u W=1u
M9088 o6 ibias vss vss sky130_fd_pr__nfet_01v8 L=0.5u W=1u
M9089 o6 ibias vss vss sky130_fd_pr__nfet_01v8 L=0.5u W=1u
M9090 o6 ibias vss vss sky130_fd_pr__nfet_01v8 L=0.5u W=1u
M9091 o6 ibias vss vss sky130_fd_pr__nfet_01v8 L=0.5u W=1u
M9092 o6 ibias vss vss sky130_fd_pr__nfet_01v8 L=0.5u W=1u
M9093 o6 ibias vss vss sky130_fd_pr__nfet_01v8 L=0.5u W=1u
M9094 o6 ibias vss vss sky130_fd_pr__nfet_01v8 L=0.5u W=1u
M9095 o6 ibias vss vss sky130_fd_pr__nfet_01v8 L=0.5u W=1u
M9096 o6 ibias vss vss sky130_fd_pr__nfet_01v8 L=0.5u W=1u
M9097 o6 ibias vss vss sky130_fd_pr__nfet_01v8 L=0.5u W=1u
M9098 o6 ibias vss vss sky130_fd_pr__nfet_01v8 L=0.5u W=1u
M9099 o6 ibias vss vss sky130_fd_pr__nfet_01v8 L=0.5u W=1u
M9100 o6 ibias vss vss sky130_fd_pr__nfet_01v8 L=0.5u W=1u
M9101 o6 ibias vss vss sky130_fd_pr__nfet_01v8 L=0.5u W=1u
M9102 o6 ibias vss vss sky130_fd_pr__nfet_01v8 L=0.5u W=1u
M9103 o6 ibias vss vss sky130_fd_pr__nfet_01v8 L=0.5u W=1u
M9104 o6 ibias vss vss sky130_fd_pr__nfet_01v8 L=0.5u W=1u
M9105 o6 ibias vss vss sky130_fd_pr__nfet_01v8 L=0.5u W=1u
M9106 o6 ibias vss vss sky130_fd_pr__nfet_01v8 L=0.5u W=1u
M9107 o6 ibias vss vss sky130_fd_pr__nfet_01v8 L=0.5u W=1u
M9108 o6 ibias vss vss sky130_fd_pr__nfet_01v8 L=0.5u W=1u
M9109 o6 ibias vss vss sky130_fd_pr__nfet_01v8 L=0.5u W=1u
M9110 o6 ibias vss vss sky130_fd_pr__nfet_01v8 L=0.5u W=1u
M9111 o6 ibias vss vss sky130_fd_pr__nfet_01v8 L=0.5u W=1u
M9112 o6 ibias vss vss sky130_fd_pr__nfet_01v8 L=0.5u W=1u
M9113 o6 ibias vss vss sky130_fd_pr__nfet_01v8 L=0.5u W=1u
M9114 o6 ibias vss vss sky130_fd_pr__nfet_01v8 L=0.5u W=1u
M9115 o6 ibias vss vss sky130_fd_pr__nfet_01v8 L=0.5u W=1u
M9116 o6 ibias vss vss sky130_fd_pr__nfet_01v8 L=0.5u W=1u
M9117 o6 ibias vss vss sky130_fd_pr__nfet_01v8 L=0.5u W=1u
M9118 o6 ibias vss vss sky130_fd_pr__nfet_01v8 L=0.5u W=1u
M9119 o6 ibias vss vss sky130_fd_pr__nfet_01v8 L=0.5u W=1u
M9120 o6 ibias vss vss sky130_fd_pr__nfet_01v8 L=0.5u W=1u
M9121 o6 ibias vss vss sky130_fd_pr__nfet_01v8 L=0.5u W=1u
M9122 o6 ibias vss vss sky130_fd_pr__nfet_01v8 L=0.5u W=1u
M9123 o6 ibias vss vss sky130_fd_pr__nfet_01v8 L=0.5u W=1u
M9124 o6 ibias vss vss sky130_fd_pr__nfet_01v8 L=0.5u W=1u
M9125 o6 ibias vss vss sky130_fd_pr__nfet_01v8 L=0.5u W=1u
M9126 o6 ibias vss vss sky130_fd_pr__nfet_01v8 L=0.5u W=1u
M9127 o6 ibias vss vss sky130_fd_pr__nfet_01v8 L=0.5u W=1u
M9128 o6 ibias vss vss sky130_fd_pr__nfet_01v8 L=0.5u W=1u
M9129 o6 ibias vss vss sky130_fd_pr__nfet_01v8 L=0.5u W=1u
M9130 o6 ibias vss vss sky130_fd_pr__nfet_01v8 L=0.5u W=1u
M9131 o6 ibias vss vss sky130_fd_pr__nfet_01v8 L=0.5u W=1u
M9132 o6 ibias vss vss sky130_fd_pr__nfet_01v8 L=0.5u W=1u
M9133 o6 ibias vss vss sky130_fd_pr__nfet_01v8 L=0.5u W=1u
M9134 o6 ibias vss vss sky130_fd_pr__nfet_01v8 L=0.5u W=1u
M9135 o6 ibias vss vss sky130_fd_pr__nfet_01v8 L=0.5u W=1u
M9136 o6 ibias vss vss sky130_fd_pr__nfet_01v8 L=0.5u W=1u
M9137 o6 ibias vss vss sky130_fd_pr__nfet_01v8 L=0.5u W=1u
M9138 o6 ibias vss vss sky130_fd_pr__nfet_01v8 L=0.5u W=1u
M9139 o6 ibias vss vss sky130_fd_pr__nfet_01v8 L=0.5u W=1u
M9140 o6 ibias vss vss sky130_fd_pr__nfet_01v8 L=0.5u W=1u
M9141 o6 ibias vss vss sky130_fd_pr__nfet_01v8 L=0.5u W=1u
M9142 o6 ibias vss vss sky130_fd_pr__nfet_01v8 L=0.5u W=1u
M9143 o6 ibias vss vss sky130_fd_pr__nfet_01v8 L=0.5u W=1u
M9144 o6 ibias vss vss sky130_fd_pr__nfet_01v8 L=0.5u W=1u
M9145 o6 ibias vss vss sky130_fd_pr__nfet_01v8 L=0.5u W=1u
M9146 o6 ibias vss vss sky130_fd_pr__nfet_01v8 L=0.5u W=1u
M9147 o6 ibias vss vss sky130_fd_pr__nfet_01v8 L=0.5u W=1u
M9148 o6 ibias vss vss sky130_fd_pr__nfet_01v8 L=0.5u W=1u
M9149 o6 ibias vss vss sky130_fd_pr__nfet_01v8 L=0.5u W=1u
M9150 o6 ibias vss vss sky130_fd_pr__nfet_01v8 L=0.5u W=1u
M9151 o6 ibias vss vss sky130_fd_pr__nfet_01v8 L=0.5u W=1u
M9152 o6 ibias vss vss sky130_fd_pr__nfet_01v8 L=0.5u W=1u
M9153 o6 ibias vss vss sky130_fd_pr__nfet_01v8 L=0.5u W=1u
M9154 o6 ibias vss vss sky130_fd_pr__nfet_01v8 L=0.5u W=1u
M9155 o6 ibias vss vss sky130_fd_pr__nfet_01v8 L=0.5u W=1u
M9156 o6 ibias vss vss sky130_fd_pr__nfet_01v8 L=0.5u W=1u
M9157 o6 ibias vss vss sky130_fd_pr__nfet_01v8 L=0.5u W=1u
M9158 o6 ibias vss vss sky130_fd_pr__nfet_01v8 L=0.5u W=1u
M9159 o6 ibias vss vss sky130_fd_pr__nfet_01v8 L=0.5u W=1u
M9160 o6 ibias vss vss sky130_fd_pr__nfet_01v8 L=0.5u W=1u
M9161 o6 ibias vss vss sky130_fd_pr__nfet_01v8 L=0.5u W=1u
M9162 o6 ibias vss vss sky130_fd_pr__nfet_01v8 L=0.5u W=1u
M9163 o6 ibias vss vss sky130_fd_pr__nfet_01v8 L=0.5u W=1u
M9164 o6 ibias vss vss sky130_fd_pr__nfet_01v8 L=0.5u W=1u
M9165 o6 ibias vss vss sky130_fd_pr__nfet_01v8 L=0.5u W=1u
M9166 o6 ibias vss vss sky130_fd_pr__nfet_01v8 L=0.5u W=1u
M9167 o6 ibias vss vss sky130_fd_pr__nfet_01v8 L=0.5u W=1u
M9168 o6 ibias vss vss sky130_fd_pr__nfet_01v8 L=0.5u W=1u
M9169 o6 ibias vss vss sky130_fd_pr__nfet_01v8 L=0.5u W=1u
M9170 o6 ibias vss vss sky130_fd_pr__nfet_01v8 L=0.5u W=1u
M9171 o6 ibias vss vss sky130_fd_pr__nfet_01v8 L=0.5u W=1u
M9172 o6 ibias vss vss sky130_fd_pr__nfet_01v8 L=0.5u W=1u
M9173 o6 ibias vss vss sky130_fd_pr__nfet_01v8 L=0.5u W=1u
M9174 o6 ibias vss vss sky130_fd_pr__nfet_01v8 L=0.5u W=1u
M9175 o6 ibias vss vss sky130_fd_pr__nfet_01v8 L=0.5u W=1u
M9176 o6 ibias vss vss sky130_fd_pr__nfet_01v8 L=0.5u W=1u
M9177 o6 ibias vss vss sky130_fd_pr__nfet_01v8 L=0.5u W=1u
M9178 o6 ibias vss vss sky130_fd_pr__nfet_01v8 L=0.5u W=1u
M9179 o6 ibias vss vss sky130_fd_pr__nfet_01v8 L=0.5u W=1u
M9180 o6 ibias vss vss sky130_fd_pr__nfet_01v8 L=0.5u W=1u
M9181 o6 ibias vss vss sky130_fd_pr__nfet_01v8 L=0.5u W=1u
M9182 o6 ibias vss vss sky130_fd_pr__nfet_01v8 L=0.5u W=1u
M9183 o6 ibias vss vss sky130_fd_pr__nfet_01v8 L=0.5u W=1u
M9184 o6 ibias vss vss sky130_fd_pr__nfet_01v8 L=0.5u W=1u
M9185 o6 ibias vss vss sky130_fd_pr__nfet_01v8 L=0.5u W=1u
M9186 o6 ibias vss vss sky130_fd_pr__nfet_01v8 L=0.5u W=1u
M9187 o6 ibias vss vss sky130_fd_pr__nfet_01v8 L=0.5u W=1u
M9188 o6 ibias vss vss sky130_fd_pr__nfet_01v8 L=0.5u W=1u
M9189 o6 ibias vss vss sky130_fd_pr__nfet_01v8 L=0.5u W=1u
M9190 o6 ibias vss vss sky130_fd_pr__nfet_01v8 L=0.5u W=1u
M9191 o6 ibias vss vss sky130_fd_pr__nfet_01v8 L=0.5u W=1u
M9192 o6 ibias vss vss sky130_fd_pr__nfet_01v8 L=0.5u W=1u
M9193 o6 ibias vss vss sky130_fd_pr__nfet_01v8 L=0.5u W=1u
M9194 o6 ibias vss vss sky130_fd_pr__nfet_01v8 L=0.5u W=1u
M9195 o6 ibias vss vss sky130_fd_pr__nfet_01v8 L=0.5u W=1u
M9196 o6 ibias vss vss sky130_fd_pr__nfet_01v8 L=0.5u W=1u
M9197 o6 ibias vss vss sky130_fd_pr__nfet_01v8 L=0.5u W=1u
M9198 o6 ibias vss vss sky130_fd_pr__nfet_01v8 L=0.5u W=1u
M9199 o6 ibias vss vss sky130_fd_pr__nfet_01v8 L=0.5u W=1u
M9200 o6 ibias vss vss sky130_fd_pr__nfet_01v8 L=0.5u W=1u
M9201 o6 ibias vss vss sky130_fd_pr__nfet_01v8 L=0.5u W=1u
M9202 o6 ibias vss vss sky130_fd_pr__nfet_01v8 L=0.5u W=1u
M9203 o6 ibias vss vss sky130_fd_pr__nfet_01v8 L=0.5u W=1u
M9204 o6 ibias vss vss sky130_fd_pr__nfet_01v8 L=0.5u W=1u
M9205 o6 ibias vss vss sky130_fd_pr__nfet_01v8 L=0.5u W=1u
M9206 o6 ibias vss vss sky130_fd_pr__nfet_01v8 L=0.5u W=1u
M9207 o6 ibias vss vss sky130_fd_pr__nfet_01v8 L=0.5u W=1u
M9208 o6 ibias vss vss sky130_fd_pr__nfet_01v8 L=0.5u W=1u
M9209 o6 ibias vss vss sky130_fd_pr__nfet_01v8 L=0.5u W=1u
M9210 o6 ibias vss vss sky130_fd_pr__nfet_01v8 L=0.5u W=1u
M9211 o6 ibias vss vss sky130_fd_pr__nfet_01v8 L=0.5u W=1u
M9212 o6 ibias vss vss sky130_fd_pr__nfet_01v8 L=0.5u W=1u
M9213 o6 ibias vss vss sky130_fd_pr__nfet_01v8 L=0.5u W=1u
M9214 o6 ibias vss vss sky130_fd_pr__nfet_01v8 L=0.5u W=1u
M9215 o6 ibias vss vss sky130_fd_pr__nfet_01v8 L=0.5u W=1u
M9216 o6 ibias vss vss sky130_fd_pr__nfet_01v8 L=0.5u W=1u
M9217 o6 ibias vss vss sky130_fd_pr__nfet_01v8 L=0.5u W=1u
M9218 o6 ibias vss vss sky130_fd_pr__nfet_01v8 L=0.5u W=1u
M9219 o6 ibias vss vss sky130_fd_pr__nfet_01v8 L=0.5u W=1u
M9220 o6 ibias vss vss sky130_fd_pr__nfet_01v8 L=0.5u W=1u
M9221 o6 ibias vss vss sky130_fd_pr__nfet_01v8 L=0.5u W=1u
M9222 o6 ibias vss vss sky130_fd_pr__nfet_01v8 L=0.5u W=1u
M9223 o6 ibias vss vss sky130_fd_pr__nfet_01v8 L=0.5u W=1u
M9224 o6 ibias vss vss sky130_fd_pr__nfet_01v8 L=0.5u W=1u
M9225 o6 ibias vss vss sky130_fd_pr__nfet_01v8 L=0.5u W=1u
M9226 o6 ibias vss vss sky130_fd_pr__nfet_01v8 L=0.5u W=1u
M9227 o6 ibias vss vss sky130_fd_pr__nfet_01v8 L=0.5u W=1u
M9228 o6 ibias vss vss sky130_fd_pr__nfet_01v8 L=0.5u W=1u
M9229 o6 ibias vss vss sky130_fd_pr__nfet_01v8 L=0.5u W=1u
M9230 o6 ibias vss vss sky130_fd_pr__nfet_01v8 L=0.5u W=1u
M9231 o6 ibias vss vss sky130_fd_pr__nfet_01v8 L=0.5u W=1u
M9232 o6 ibias vss vss sky130_fd_pr__nfet_01v8 L=0.5u W=1u
M9233 o6 ibias vss vss sky130_fd_pr__nfet_01v8 L=0.5u W=1u
M9234 o6 ibias vss vss sky130_fd_pr__nfet_01v8 L=0.5u W=1u
M9235 o6 ibias vss vss sky130_fd_pr__nfet_01v8 L=0.5u W=1u
M9236 o6 ibias vss vss sky130_fd_pr__nfet_01v8 L=0.5u W=1u
M9237 o6 ibias vss vss sky130_fd_pr__nfet_01v8 L=0.5u W=1u
M9238 o6 ibias vss vss sky130_fd_pr__nfet_01v8 L=0.5u W=1u
M9239 o6 ibias vss vss sky130_fd_pr__nfet_01v8 L=0.5u W=1u
M9240 o6 ibias vss vss sky130_fd_pr__nfet_01v8 L=0.5u W=1u
M9241 o6 ibias vss vss sky130_fd_pr__nfet_01v8 L=0.5u W=1u
M9242 o6 ibias vss vss sky130_fd_pr__nfet_01v8 L=0.5u W=1u
M9243 o6 ibias vss vss sky130_fd_pr__nfet_01v8 L=0.5u W=1u
M9244 o6 ibias vss vss sky130_fd_pr__nfet_01v8 L=0.5u W=1u
M9245 o6 ibias vss vss sky130_fd_pr__nfet_01v8 L=0.5u W=1u
M9246 o6 ibias vss vss sky130_fd_pr__nfet_01v8 L=0.5u W=1u
M9247 o6 ibias vss vss sky130_fd_pr__nfet_01v8 L=0.5u W=1u
M9248 o6 ibias vss vss sky130_fd_pr__nfet_01v8 L=0.5u W=1u
M9249 o6 ibias vss vss sky130_fd_pr__nfet_01v8 L=0.5u W=1u
M9250 o6 ibias vss vss sky130_fd_pr__nfet_01v8 L=0.5u W=1u
M9251 o6 ibias vss vss sky130_fd_pr__nfet_01v8 L=0.5u W=1u
M9252 o6 ibias vss vss sky130_fd_pr__nfet_01v8 L=0.5u W=1u
M9253 o6 ibias vss vss sky130_fd_pr__nfet_01v8 L=0.5u W=1u
M9254 o6 ibias vss vss sky130_fd_pr__nfet_01v8 L=0.5u W=1u
M9255 o6 ibias vss vss sky130_fd_pr__nfet_01v8 L=0.5u W=1u
M9256 o6 ibias vss vss sky130_fd_pr__nfet_01v8 L=0.5u W=1u
M9257 o6 ibias vss vss sky130_fd_pr__nfet_01v8 L=0.5u W=1u
M9258 o6 ibias vss vss sky130_fd_pr__nfet_01v8 L=0.5u W=1u
M9259 o6 ibias vss vss sky130_fd_pr__nfet_01v8 L=0.5u W=1u
M9260 o6 ibias vss vss sky130_fd_pr__nfet_01v8 L=0.5u W=1u
M9261 o6 ibias vss vss sky130_fd_pr__nfet_01v8 L=0.5u W=1u
M9262 o6 ibias vss vss sky130_fd_pr__nfet_01v8 L=0.5u W=1u
M9263 o6 ibias vss vss sky130_fd_pr__nfet_01v8 L=0.5u W=1u
M9264 o6 ibias vss vss sky130_fd_pr__nfet_01v8 L=0.5u W=1u
M9265 o6 ibias vss vss sky130_fd_pr__nfet_01v8 L=0.5u W=1u
M9266 o6 ibias vss vss sky130_fd_pr__nfet_01v8 L=0.5u W=1u
M9267 o6 ibias vss vss sky130_fd_pr__nfet_01v8 L=0.5u W=1u
M9268 o6 ibias vss vss sky130_fd_pr__nfet_01v8 L=0.5u W=1u
M9269 o6 ibias vss vss sky130_fd_pr__nfet_01v8 L=0.5u W=1u
M9270 o6 ibias vss vss sky130_fd_pr__nfet_01v8 L=0.5u W=1u
M9271 o6 ibias vss vss sky130_fd_pr__nfet_01v8 L=0.5u W=1u
M9272 o6 ibias vss vss sky130_fd_pr__nfet_01v8 L=0.5u W=1u
M9273 o6 ibias vss vss sky130_fd_pr__nfet_01v8 L=0.5u W=1u
M9274 o6 ibias vss vss sky130_fd_pr__nfet_01v8 L=0.5u W=1u
M9275 o6 ibias vss vss sky130_fd_pr__nfet_01v8 L=0.5u W=1u
M9276 o6 ibias vss vss sky130_fd_pr__nfet_01v8 L=0.5u W=1u
M9277 o6 ibias vss vss sky130_fd_pr__nfet_01v8 L=0.5u W=1u
M9278 o6 ibias vss vss sky130_fd_pr__nfet_01v8 L=0.5u W=1u
M9279 o6 ibias vss vss sky130_fd_pr__nfet_01v8 L=0.5u W=1u
M9280 o6 ibias vss vss sky130_fd_pr__nfet_01v8 L=0.5u W=1u
M9281 o6 ibias vss vss sky130_fd_pr__nfet_01v8 L=0.5u W=1u
M9282 o6 ibias vss vss sky130_fd_pr__nfet_01v8 L=0.5u W=1u
M9283 o6 ibias vss vss sky130_fd_pr__nfet_01v8 L=0.5u W=1u
M9284 o6 ibias vss vss sky130_fd_pr__nfet_01v8 L=0.5u W=1u
M9285 o6 ibias vss vss sky130_fd_pr__nfet_01v8 L=0.5u W=1u
M9286 o6 ibias vss vss sky130_fd_pr__nfet_01v8 L=0.5u W=1u
M9287 o6 ibias vss vss sky130_fd_pr__nfet_01v8 L=0.5u W=1u
M9288 o6 ibias vss vss sky130_fd_pr__nfet_01v8 L=0.5u W=1u
M9289 o6 ibias vss vss sky130_fd_pr__nfet_01v8 L=0.5u W=1u
M9290 o6 ibias vss vss sky130_fd_pr__nfet_01v8 L=0.5u W=1u
M9291 o6 ibias vss vss sky130_fd_pr__nfet_01v8 L=0.5u W=1u
M9292 o6 ibias vss vss sky130_fd_pr__nfet_01v8 L=0.5u W=1u
M9293 o6 ibias vss vss sky130_fd_pr__nfet_01v8 L=0.5u W=1u
M9294 o6 ibias vss vss sky130_fd_pr__nfet_01v8 L=0.5u W=1u
M9295 o6 ibias vss vss sky130_fd_pr__nfet_01v8 L=0.5u W=1u
M9296 o6 ibias vss vss sky130_fd_pr__nfet_01v8 L=0.5u W=1u
M9297 o6 ibias vss vss sky130_fd_pr__nfet_01v8 L=0.5u W=1u
M9298 o6 ibias vss vss sky130_fd_pr__nfet_01v8 L=0.5u W=1u
M9299 o6 ibias vss vss sky130_fd_pr__nfet_01v8 L=0.5u W=1u
M9300 o6 ibias vss vss sky130_fd_pr__nfet_01v8 L=0.5u W=1u
M9301 o6 ibias vss vss sky130_fd_pr__nfet_01v8 L=0.5u W=1u
M9302 o6 ibias vss vss sky130_fd_pr__nfet_01v8 L=0.5u W=1u
M9303 o6 ibias vss vss sky130_fd_pr__nfet_01v8 L=0.5u W=1u
M9304 o6 ibias vss vss sky130_fd_pr__nfet_01v8 L=0.5u W=1u
M9305 o6 ibias vss vss sky130_fd_pr__nfet_01v8 L=0.5u W=1u
M9306 o6 ibias vss vss sky130_fd_pr__nfet_01v8 L=0.5u W=1u
M9307 o6 ibias vss vss sky130_fd_pr__nfet_01v8 L=0.5u W=1u
M9308 o6 ibias vss vss sky130_fd_pr__nfet_01v8 L=0.5u W=1u
M9309 o6 ibias vss vss sky130_fd_pr__nfet_01v8 L=0.5u W=1u
M9310 o6 ibias vss vss sky130_fd_pr__nfet_01v8 L=0.5u W=1u
M9311 o6 ibias vss vss sky130_fd_pr__nfet_01v8 L=0.5u W=1u
M9312 o6 ibias vss vss sky130_fd_pr__nfet_01v8 L=0.5u W=1u
M9313 o6 ibias vss vss sky130_fd_pr__nfet_01v8 L=0.5u W=1u
M9314 o6 ibias vss vss sky130_fd_pr__nfet_01v8 L=0.5u W=1u
M9315 o6 ibias vss vss sky130_fd_pr__nfet_01v8 L=0.5u W=1u
M9316 o6 ibias vss vss sky130_fd_pr__nfet_01v8 L=0.5u W=1u
M9317 o6 ibias vss vss sky130_fd_pr__nfet_01v8 L=0.5u W=1u
M9318 o6 ibias vss vss sky130_fd_pr__nfet_01v8 L=0.5u W=1u
M9319 o6 ibias vss vss sky130_fd_pr__nfet_01v8 L=0.5u W=1u
M9320 o6 ibias vss vss sky130_fd_pr__nfet_01v8 L=0.5u W=1u
M9321 o6 ibias vss vss sky130_fd_pr__nfet_01v8 L=0.5u W=1u
M9322 o6 ibias vss vss sky130_fd_pr__nfet_01v8 L=0.5u W=1u
M9323 o6 ibias vss vss sky130_fd_pr__nfet_01v8 L=0.5u W=1u
M9324 o6 ibias vss vss sky130_fd_pr__nfet_01v8 L=0.5u W=1u
M9325 o6 ibias vss vss sky130_fd_pr__nfet_01v8 L=0.5u W=1u
M9326 o6 ibias vss vss sky130_fd_pr__nfet_01v8 L=0.5u W=1u
M9327 o6 ibias vss vss sky130_fd_pr__nfet_01v8 L=0.5u W=1u
M9328 o6 ibias vss vss sky130_fd_pr__nfet_01v8 L=0.5u W=1u
M9329 o6 ibias vss vss sky130_fd_pr__nfet_01v8 L=0.5u W=1u
M9330 o6 ibias vss vss sky130_fd_pr__nfet_01v8 L=0.5u W=1u
M9331 o6 ibias vss vss sky130_fd_pr__nfet_01v8 L=0.5u W=1u
M9332 o6 ibias vss vss sky130_fd_pr__nfet_01v8 L=0.5u W=1u
M9333 o6 ibias vss vss sky130_fd_pr__nfet_01v8 L=0.5u W=1u
M9334 o6 ibias vss vss sky130_fd_pr__nfet_01v8 L=0.5u W=1u
M9335 o6 ibias vss vss sky130_fd_pr__nfet_01v8 L=0.5u W=1u
M9336 o6 ibias vss vss sky130_fd_pr__nfet_01v8 L=0.5u W=1u
M9337 o6 ibias vss vss sky130_fd_pr__nfet_01v8 L=0.5u W=1u
M9338 o6 ibias vss vss sky130_fd_pr__nfet_01v8 L=0.5u W=1u
M9339 o6 ibias vss vss sky130_fd_pr__nfet_01v8 L=0.5u W=1u
M9340 o6 ibias vss vss sky130_fd_pr__nfet_01v8 L=0.5u W=1u
M9341 o6 ibias vss vss sky130_fd_pr__nfet_01v8 L=0.5u W=1u
M9342 o6 ibias vss vss sky130_fd_pr__nfet_01v8 L=0.5u W=1u
M9343 o6 ibias vss vss sky130_fd_pr__nfet_01v8 L=0.5u W=1u
M9344 o6 ibias vss vss sky130_fd_pr__nfet_01v8 L=0.5u W=1u
M9345 o6 ibias vss vss sky130_fd_pr__nfet_01v8 L=0.5u W=1u
M9346 o6 ibias vss vss sky130_fd_pr__nfet_01v8 L=0.5u W=1u
M9347 o6 ibias vss vss sky130_fd_pr__nfet_01v8 L=0.5u W=1u
M9348 o6 ibias vss vss sky130_fd_pr__nfet_01v8 L=0.5u W=1u
M9349 o6 ibias vss vss sky130_fd_pr__nfet_01v8 L=0.5u W=1u
M9350 o6 ibias vss vss sky130_fd_pr__nfet_01v8 L=0.5u W=1u
M9351 o6 ibias vss vss sky130_fd_pr__nfet_01v8 L=0.5u W=1u
M9352 o6 ibias vss vss sky130_fd_pr__nfet_01v8 L=0.5u W=1u
M9353 o6 ibias vss vss sky130_fd_pr__nfet_01v8 L=0.5u W=1u
M9354 o6 ibias vss vss sky130_fd_pr__nfet_01v8 L=0.5u W=1u
M9355 o6 ibias vss vss sky130_fd_pr__nfet_01v8 L=0.5u W=1u
M9356 o6 ibias vss vss sky130_fd_pr__nfet_01v8 L=0.5u W=1u
M9357 o6 ibias vss vss sky130_fd_pr__nfet_01v8 L=0.5u W=1u
M9358 o6 ibias vss vss sky130_fd_pr__nfet_01v8 L=0.5u W=1u
M9359 o6 ibias vss vss sky130_fd_pr__nfet_01v8 L=0.5u W=1u
M9360 o6 ibias vss vss sky130_fd_pr__nfet_01v8 L=0.5u W=1u
M9361 o6 ibias vss vss sky130_fd_pr__nfet_01v8 L=0.5u W=1u
M9362 o6 ibias vss vss sky130_fd_pr__nfet_01v8 L=0.5u W=1u
M9363 o6 ibias vss vss sky130_fd_pr__nfet_01v8 L=0.5u W=1u
M9364 o6 ibias vss vss sky130_fd_pr__nfet_01v8 L=0.5u W=1u
M9365 o6 ibias vss vss sky130_fd_pr__nfet_01v8 L=0.5u W=1u
M9366 o6 ibias vss vss sky130_fd_pr__nfet_01v8 L=0.5u W=1u
M9367 o6 ibias vss vss sky130_fd_pr__nfet_01v8 L=0.5u W=1u
M9368 o6 ibias vss vss sky130_fd_pr__nfet_01v8 L=0.5u W=1u
M9369 o6 ibias vss vss sky130_fd_pr__nfet_01v8 L=0.5u W=1u
M9370 o6 ibias vss vss sky130_fd_pr__nfet_01v8 L=0.5u W=1u
M9371 o6 ibias vss vss sky130_fd_pr__nfet_01v8 L=0.5u W=1u
M9372 o6 ibias vss vss sky130_fd_pr__nfet_01v8 L=0.5u W=1u
M9373 o6 ibias vss vss sky130_fd_pr__nfet_01v8 L=0.5u W=1u
M9374 o6 ibias vss vss sky130_fd_pr__nfet_01v8 L=0.5u W=1u
M9375 o6 ibias vss vss sky130_fd_pr__nfet_01v8 L=0.5u W=1u
M9376 o6 ibias vss vss sky130_fd_pr__nfet_01v8 L=0.5u W=1u
M9377 o6 ibias vss vss sky130_fd_pr__nfet_01v8 L=0.5u W=1u
M9378 o6 ibias vss vss sky130_fd_pr__nfet_01v8 L=0.5u W=1u
M9379 o6 ibias vss vss sky130_fd_pr__nfet_01v8 L=0.5u W=1u
M9380 o6 ibias vss vss sky130_fd_pr__nfet_01v8 L=0.5u W=1u
M9381 o6 ibias vss vss sky130_fd_pr__nfet_01v8 L=0.5u W=1u
M9382 o6 ibias vss vss sky130_fd_pr__nfet_01v8 L=0.5u W=1u
M9383 o6 ibias vss vss sky130_fd_pr__nfet_01v8 L=0.5u W=1u
M9384 o6 ibias vss vss sky130_fd_pr__nfet_01v8 L=0.5u W=1u
M9385 o6 ibias vss vss sky130_fd_pr__nfet_01v8 L=0.5u W=1u
M9386 o6 ibias vss vss sky130_fd_pr__nfet_01v8 L=0.5u W=1u
M9387 o6 ibias vss vss sky130_fd_pr__nfet_01v8 L=0.5u W=1u
M9388 o6 ibias vss vss sky130_fd_pr__nfet_01v8 L=0.5u W=1u
M9389 o6 ibias vss vss sky130_fd_pr__nfet_01v8 L=0.5u W=1u
M9390 o6 ibias vss vss sky130_fd_pr__nfet_01v8 L=0.5u W=1u
M9391 o6 ibias vss vss sky130_fd_pr__nfet_01v8 L=0.5u W=1u
M9392 o6 ibias vss vss sky130_fd_pr__nfet_01v8 L=0.5u W=1u
M9393 o6 ibias vss vss sky130_fd_pr__nfet_01v8 L=0.5u W=1u
M9394 o6 ibias vss vss sky130_fd_pr__nfet_01v8 L=0.5u W=1u
M9395 o6 ibias vss vss sky130_fd_pr__nfet_01v8 L=0.5u W=1u
M9396 o6 ibias vss vss sky130_fd_pr__nfet_01v8 L=0.5u W=1u
M9397 o6 ibias vss vss sky130_fd_pr__nfet_01v8 L=0.5u W=1u
M9398 o6 ibias vss vss sky130_fd_pr__nfet_01v8 L=0.5u W=1u
M9399 o6 ibias vss vss sky130_fd_pr__nfet_01v8 L=0.5u W=1u
M9400 o6 ibias vss vss sky130_fd_pr__nfet_01v8 L=0.5u W=1u
M9401 o6 ibias vss vss sky130_fd_pr__nfet_01v8 L=0.5u W=1u
M9402 o6 ibias vss vss sky130_fd_pr__nfet_01v8 L=0.5u W=1u
M9403 o6 ibias vss vss sky130_fd_pr__nfet_01v8 L=0.5u W=1u
M9404 o6 ibias vss vss sky130_fd_pr__nfet_01v8 L=0.5u W=1u
M9405 o6 ibias vss vss sky130_fd_pr__nfet_01v8 L=0.5u W=1u
M9406 o6 ibias vss vss sky130_fd_pr__nfet_01v8 L=0.5u W=1u
M9407 o6 ibias vss vss sky130_fd_pr__nfet_01v8 L=0.5u W=1u
M9408 o6 ibias vss vss sky130_fd_pr__nfet_01v8 L=0.5u W=1u
M9409 o6 ibias vss vss sky130_fd_pr__nfet_01v8 L=0.5u W=1u
M9410 o6 ibias vss vss sky130_fd_pr__nfet_01v8 L=0.5u W=1u
M9411 o6 ibias vss vss sky130_fd_pr__nfet_01v8 L=0.5u W=1u
M9412 o6 ibias vss vss sky130_fd_pr__nfet_01v8 L=0.5u W=1u
M9413 o6 ibias vss vss sky130_fd_pr__nfet_01v8 L=0.5u W=1u
M9414 o6 ibias vss vss sky130_fd_pr__nfet_01v8 L=0.5u W=1u
M9415 o6 ibias vss vss sky130_fd_pr__nfet_01v8 L=0.5u W=1u
M9416 o6 ibias vss vss sky130_fd_pr__nfet_01v8 L=0.5u W=1u
M9417 o6 ibias vss vss sky130_fd_pr__nfet_01v8 L=0.5u W=1u
M9418 o6 ibias vss vss sky130_fd_pr__nfet_01v8 L=0.5u W=1u
M9419 o6 ibias vss vss sky130_fd_pr__nfet_01v8 L=0.5u W=1u
M9420 o6 ibias vss vss sky130_fd_pr__nfet_01v8 L=0.5u W=1u
M9421 o6 ibias vss vss sky130_fd_pr__nfet_01v8 L=0.5u W=1u
M9422 o6 ibias vss vss sky130_fd_pr__nfet_01v8 L=0.5u W=1u
M9423 o6 ibias vss vss sky130_fd_pr__nfet_01v8 L=0.5u W=1u
M9424 o6 ibias vss vss sky130_fd_pr__nfet_01v8 L=0.5u W=1u
M9425 o6 ibias vss vss sky130_fd_pr__nfet_01v8 L=0.5u W=1u
M9426 o6 ibias vss vss sky130_fd_pr__nfet_01v8 L=0.5u W=1u
M9427 o6 ibias vss vss sky130_fd_pr__nfet_01v8 L=0.5u W=1u
M9428 o6 ibias vss vss sky130_fd_pr__nfet_01v8 L=0.5u W=1u
M9429 o6 ibias vss vss sky130_fd_pr__nfet_01v8 L=0.5u W=1u
M9430 o6 ibias vss vss sky130_fd_pr__nfet_01v8 L=0.5u W=1u
M9431 o6 ibias vss vss sky130_fd_pr__nfet_01v8 L=0.5u W=1u
M9432 o6 ibias vss vss sky130_fd_pr__nfet_01v8 L=0.5u W=1u
M9433 o6 ibias vss vss sky130_fd_pr__nfet_01v8 L=0.5u W=1u
M9434 o6 ibias vss vss sky130_fd_pr__nfet_01v8 L=0.5u W=1u
M9435 o6 ibias vss vss sky130_fd_pr__nfet_01v8 L=0.5u W=1u
M9436 o6 ibias vss vss sky130_fd_pr__nfet_01v8 L=0.5u W=1u
M9437 o6 ibias vss vss sky130_fd_pr__nfet_01v8 L=0.5u W=1u
M9438 o6 ibias vss vss sky130_fd_pr__nfet_01v8 L=0.5u W=1u
M9439 o6 ibias vss vss sky130_fd_pr__nfet_01v8 L=0.5u W=1u
M9440 o6 ibias vss vss sky130_fd_pr__nfet_01v8 L=0.5u W=1u
M9441 o6 ibias vss vss sky130_fd_pr__nfet_01v8 L=0.5u W=1u
M9442 o6 ibias vss vss sky130_fd_pr__nfet_01v8 L=0.5u W=1u
M9443 o6 ibias vss vss sky130_fd_pr__nfet_01v8 L=0.5u W=1u
M9444 o6 ibias vss vss sky130_fd_pr__nfet_01v8 L=0.5u W=1u
M9445 o6 ibias vss vss sky130_fd_pr__nfet_01v8 L=0.5u W=1u
M9446 o6 ibias vss vss sky130_fd_pr__nfet_01v8 L=0.5u W=1u
M9447 o6 ibias vss vss sky130_fd_pr__nfet_01v8 L=0.5u W=1u
M9448 o6 ibias vss vss sky130_fd_pr__nfet_01v8 L=0.5u W=1u
M9449 o6 ibias vss vss sky130_fd_pr__nfet_01v8 L=0.5u W=1u
M9450 o6 ibias vss vss sky130_fd_pr__nfet_01v8 L=0.5u W=1u
M9451 o6 ibias vss vss sky130_fd_pr__nfet_01v8 L=0.5u W=1u
M9452 o6 ibias vss vss sky130_fd_pr__nfet_01v8 L=0.5u W=1u
M9453 o6 ibias vss vss sky130_fd_pr__nfet_01v8 L=0.5u W=1u
M9454 o6 ibias vss vss sky130_fd_pr__nfet_01v8 L=0.5u W=1u
M9455 o6 ibias vss vss sky130_fd_pr__nfet_01v8 L=0.5u W=1u
M9456 o6 ibias vss vss sky130_fd_pr__nfet_01v8 L=0.5u W=1u
M9457 o6 ibias vss vss sky130_fd_pr__nfet_01v8 L=0.5u W=1u
M9458 o6 ibias vss vss sky130_fd_pr__nfet_01v8 L=0.5u W=1u
M9459 o6 ibias vss vss sky130_fd_pr__nfet_01v8 L=0.5u W=1u
M9460 o6 ibias vss vss sky130_fd_pr__nfet_01v8 L=0.5u W=1u
M9461 o6 ibias vss vss sky130_fd_pr__nfet_01v8 L=0.5u W=1u
M9462 o6 ibias vss vss sky130_fd_pr__nfet_01v8 L=0.5u W=1u
M9463 o6 ibias vss vss sky130_fd_pr__nfet_01v8 L=0.5u W=1u
M9464 o6 ibias vss vss sky130_fd_pr__nfet_01v8 L=0.5u W=1u
M9465 o6 ibias vss vss sky130_fd_pr__nfet_01v8 L=0.5u W=1u
M9466 o6 ibias vss vss sky130_fd_pr__nfet_01v8 L=0.5u W=1u
M9467 o6 ibias vss vss sky130_fd_pr__nfet_01v8 L=0.5u W=1u
M9468 o6 ibias vss vss sky130_fd_pr__nfet_01v8 L=0.5u W=1u
M9469 o6 ibias vss vss sky130_fd_pr__nfet_01v8 L=0.5u W=1u
M9470 o6 ibias vss vss sky130_fd_pr__nfet_01v8 L=0.5u W=1u
M9471 o6 ibias vss vss sky130_fd_pr__nfet_01v8 L=0.5u W=1u
M9472 o6 ibias vss vss sky130_fd_pr__nfet_01v8 L=0.5u W=1u
M9473 o6 ibias vss vss sky130_fd_pr__nfet_01v8 L=0.5u W=1u
M9474 o6 ibias vss vss sky130_fd_pr__nfet_01v8 L=0.5u W=1u
M9475 o6 ibias vss vss sky130_fd_pr__nfet_01v8 L=0.5u W=1u
M9476 o6 ibias vss vss sky130_fd_pr__nfet_01v8 L=0.5u W=1u
M9477 o6 ibias vss vss sky130_fd_pr__nfet_01v8 L=0.5u W=1u
M9478 o6 ibias vss vss sky130_fd_pr__nfet_01v8 L=0.5u W=1u
M9479 o6 ibias vss vss sky130_fd_pr__nfet_01v8 L=0.5u W=1u
M9480 o6 ibias vss vss sky130_fd_pr__nfet_01v8 L=0.5u W=1u
M9481 o6 ibias vss vss sky130_fd_pr__nfet_01v8 L=0.5u W=1u
M9482 o6 ibias vss vss sky130_fd_pr__nfet_01v8 L=0.5u W=1u
M9483 o6 ibias vss vss sky130_fd_pr__nfet_01v8 L=0.5u W=1u
M9484 o6 ibias vss vss sky130_fd_pr__nfet_01v8 L=0.5u W=1u
M9485 o6 ibias vss vss sky130_fd_pr__nfet_01v8 L=0.5u W=1u
M9486 o6 ibias vss vss sky130_fd_pr__nfet_01v8 L=0.5u W=1u
M9487 o6 ibias vss vss sky130_fd_pr__nfet_01v8 L=0.5u W=1u
M9488 o6 ibias vss vss sky130_fd_pr__nfet_01v8 L=0.5u W=1u
M9489 o6 ibias vss vss sky130_fd_pr__nfet_01v8 L=0.5u W=1u
M9490 o6 ibias vss vss sky130_fd_pr__nfet_01v8 L=0.5u W=1u
M9491 o6 ibias vss vss sky130_fd_pr__nfet_01v8 L=0.5u W=1u
M9492 o6 ibias vss vss sky130_fd_pr__nfet_01v8 L=0.5u W=1u
M9493 o6 ibias vss vss sky130_fd_pr__nfet_01v8 L=0.5u W=1u
M9494 o6 ibias vss vss sky130_fd_pr__nfet_01v8 L=0.5u W=1u
M9495 o6 ibias vss vss sky130_fd_pr__nfet_01v8 L=0.5u W=1u
M9496 o6 ibias vss vss sky130_fd_pr__nfet_01v8 L=0.5u W=1u
M9497 o6 ibias vss vss sky130_fd_pr__nfet_01v8 L=0.5u W=1u
M9498 o6 ibias vss vss sky130_fd_pr__nfet_01v8 L=0.5u W=1u
M9499 o6 ibias vss vss sky130_fd_pr__nfet_01v8 L=0.5u W=1u
M9500 o6 ibias vss vss sky130_fd_pr__nfet_01v8 L=0.5u W=1u
M9501 o6 ibias vss vss sky130_fd_pr__nfet_01v8 L=0.5u W=1u
M9502 o6 ibias vss vss sky130_fd_pr__nfet_01v8 L=0.5u W=1u
M9503 o6 ibias vss vss sky130_fd_pr__nfet_01v8 L=0.5u W=1u
M9504 o6 ibias vss vss sky130_fd_pr__nfet_01v8 L=0.5u W=1u
M9505 o6 ibias vss vss sky130_fd_pr__nfet_01v8 L=0.5u W=1u
M9506 o6 ibias vss vss sky130_fd_pr__nfet_01v8 L=0.5u W=1u
M9507 o6 ibias vss vss sky130_fd_pr__nfet_01v8 L=0.5u W=1u
M9508 o6 ibias vss vss sky130_fd_pr__nfet_01v8 L=0.5u W=1u
M9509 o6 ibias vss vss sky130_fd_pr__nfet_01v8 L=0.5u W=1u
M9510 o6 ibias vss vss sky130_fd_pr__nfet_01v8 L=0.5u W=1u
M9511 o6 ibias vss vss sky130_fd_pr__nfet_01v8 L=0.5u W=1u
M9512 o6 ibias vss vss sky130_fd_pr__nfet_01v8 L=0.5u W=1u
M9513 o6 ibias vss vss sky130_fd_pr__nfet_01v8 L=0.5u W=1u
M9514 o6 ibias vss vss sky130_fd_pr__nfet_01v8 L=0.5u W=1u
M9515 o6 ibias vss vss sky130_fd_pr__nfet_01v8 L=0.5u W=1u
M9516 o6 ibias vss vss sky130_fd_pr__nfet_01v8 L=0.5u W=1u
M9517 o6 ibias vss vss sky130_fd_pr__nfet_01v8 L=0.5u W=1u
M9518 o6 ibias vss vss sky130_fd_pr__nfet_01v8 L=0.5u W=1u
M9519 o6 ibias vss vss sky130_fd_pr__nfet_01v8 L=0.5u W=1u
M9520 o6 ibias vss vss sky130_fd_pr__nfet_01v8 L=0.5u W=1u
M9521 o6 ibias vss vss sky130_fd_pr__nfet_01v8 L=0.5u W=1u
M9522 o6 ibias vss vss sky130_fd_pr__nfet_01v8 L=0.5u W=1u
M9523 o6 ibias vss vss sky130_fd_pr__nfet_01v8 L=0.5u W=1u
M9524 o6 ibias vss vss sky130_fd_pr__nfet_01v8 L=0.5u W=1u
M9525 o6 ibias vss vss sky130_fd_pr__nfet_01v8 L=0.5u W=1u
M9526 o6 ibias vss vss sky130_fd_pr__nfet_01v8 L=0.5u W=1u
M9527 o6 ibias vss vss sky130_fd_pr__nfet_01v8 L=0.5u W=1u
M9528 o6 ibias vss vss sky130_fd_pr__nfet_01v8 L=0.5u W=1u
M9529 o6 ibias vss vss sky130_fd_pr__nfet_01v8 L=0.5u W=1u
M9530 o6 ibias vss vss sky130_fd_pr__nfet_01v8 L=0.5u W=1u
M9531 o6 ibias vss vss sky130_fd_pr__nfet_01v8 L=0.5u W=1u
M9532 o6 ibias vss vss sky130_fd_pr__nfet_01v8 L=0.5u W=1u
M9533 o6 ibias vss vss sky130_fd_pr__nfet_01v8 L=0.5u W=1u
M9534 o6 ibias vss vss sky130_fd_pr__nfet_01v8 L=0.5u W=1u
M9535 o6 ibias vss vss sky130_fd_pr__nfet_01v8 L=0.5u W=1u
M9536 o6 ibias vss vss sky130_fd_pr__nfet_01v8 L=0.5u W=1u
M9537 o6 ibias vss vss sky130_fd_pr__nfet_01v8 L=0.5u W=1u
M9538 o6 ibias vss vss sky130_fd_pr__nfet_01v8 L=0.5u W=1u
M9539 o6 ibias vss vss sky130_fd_pr__nfet_01v8 L=0.5u W=1u
M9540 o6 ibias vss vss sky130_fd_pr__nfet_01v8 L=0.5u W=1u
M9541 o6 ibias vss vss sky130_fd_pr__nfet_01v8 L=0.5u W=1u
M9542 o6 ibias vss vss sky130_fd_pr__nfet_01v8 L=0.5u W=1u
M9543 o6 ibias vss vss sky130_fd_pr__nfet_01v8 L=0.5u W=1u
M9544 o6 ibias vss vss sky130_fd_pr__nfet_01v8 L=0.5u W=1u
M9545 o6 ibias vss vss sky130_fd_pr__nfet_01v8 L=0.5u W=1u
M9546 o6 ibias vss vss sky130_fd_pr__nfet_01v8 L=0.5u W=1u
M9547 o6 ibias vss vss sky130_fd_pr__nfet_01v8 L=0.5u W=1u
M9548 o6 ibias vss vss sky130_fd_pr__nfet_01v8 L=0.5u W=1u
M9549 o6 ibias vss vss sky130_fd_pr__nfet_01v8 L=0.5u W=1u
M9550 o6 ibias vss vss sky130_fd_pr__nfet_01v8 L=0.5u W=1u
M9551 o6 ibias vss vss sky130_fd_pr__nfet_01v8 L=0.5u W=1u
M9552 o6 ibias vss vss sky130_fd_pr__nfet_01v8 L=0.5u W=1u
M9553 o6 ibias vss vss sky130_fd_pr__nfet_01v8 L=0.5u W=1u
M9554 o6 ibias vss vss sky130_fd_pr__nfet_01v8 L=0.5u W=1u
M9555 o6 ibias vss vss sky130_fd_pr__nfet_01v8 L=0.5u W=1u
M9556 o6 ibias vss vss sky130_fd_pr__nfet_01v8 L=0.5u W=1u
M9557 o6 ibias vss vss sky130_fd_pr__nfet_01v8 L=0.5u W=1u
M9558 o6 ibias vss vss sky130_fd_pr__nfet_01v8 L=0.5u W=1u
M9559 o6 ibias vss vss sky130_fd_pr__nfet_01v8 L=0.5u W=1u
M9560 o6 ibias vss vss sky130_fd_pr__nfet_01v8 L=0.5u W=1u
M9561 o6 ibias vss vss sky130_fd_pr__nfet_01v8 L=0.5u W=1u
M9562 o6 ibias vss vss sky130_fd_pr__nfet_01v8 L=0.5u W=1u
M9563 o6 ibias vss vss sky130_fd_pr__nfet_01v8 L=0.5u W=1u
M9564 o6 ibias vss vss sky130_fd_pr__nfet_01v8 L=0.5u W=1u
M9565 o6 ibias vss vss sky130_fd_pr__nfet_01v8 L=0.5u W=1u
M9566 o6 ibias vss vss sky130_fd_pr__nfet_01v8 L=0.5u W=1u
M9567 o6 ibias vss vss sky130_fd_pr__nfet_01v8 L=0.5u W=1u
M9568 o6 ibias vss vss sky130_fd_pr__nfet_01v8 L=0.5u W=1u
M9569 o6 ibias vss vss sky130_fd_pr__nfet_01v8 L=0.5u W=1u
M9570 o6 ibias vss vss sky130_fd_pr__nfet_01v8 L=0.5u W=1u
M9571 o6 ibias vss vss sky130_fd_pr__nfet_01v8 L=0.5u W=1u
M9572 o6 ibias vss vss sky130_fd_pr__nfet_01v8 L=0.5u W=1u
M9573 o6 ibias vss vss sky130_fd_pr__nfet_01v8 L=0.5u W=1u
M9574 o6 ibias vss vss sky130_fd_pr__nfet_01v8 L=0.5u W=1u
M9575 o6 ibias vss vss sky130_fd_pr__nfet_01v8 L=0.5u W=1u
M9576 o6 ibias vss vss sky130_fd_pr__nfet_01v8 L=0.5u W=1u
M9577 o6 ibias vss vss sky130_fd_pr__nfet_01v8 L=0.5u W=1u
M9578 o6 ibias vss vss sky130_fd_pr__nfet_01v8 L=0.5u W=1u
M9579 o6 ibias vss vss sky130_fd_pr__nfet_01v8 L=0.5u W=1u
M9580 o6 ibias vss vss sky130_fd_pr__nfet_01v8 L=0.5u W=1u
M9581 o6 ibias vss vss sky130_fd_pr__nfet_01v8 L=0.5u W=1u
M9582 o6 ibias vss vss sky130_fd_pr__nfet_01v8 L=0.5u W=1u
M9583 o6 ibias vss vss sky130_fd_pr__nfet_01v8 L=0.5u W=1u
M9584 o6 ibias vss vss sky130_fd_pr__nfet_01v8 L=0.5u W=1u
M9585 o6 ibias vss vss sky130_fd_pr__nfet_01v8 L=0.5u W=1u
M9586 o6 ibias vss vss sky130_fd_pr__nfet_01v8 L=0.5u W=1u
M9587 o6 ibias vss vss sky130_fd_pr__nfet_01v8 L=0.5u W=1u
M9588 o6 ibias vss vss sky130_fd_pr__nfet_01v8 L=0.5u W=1u
M9589 o6 ibias vss vss sky130_fd_pr__nfet_01v8 L=0.5u W=1u
M9590 o6 ibias vss vss sky130_fd_pr__nfet_01v8 L=0.5u W=1u
M9591 o6 ibias vss vss sky130_fd_pr__nfet_01v8 L=0.5u W=1u
M9592 o6 ibias vss vss sky130_fd_pr__nfet_01v8 L=0.5u W=1u
M9593 o6 ibias vss vss sky130_fd_pr__nfet_01v8 L=0.5u W=1u
M9594 o6 ibias vss vss sky130_fd_pr__nfet_01v8 L=0.5u W=1u
M9595 o6 ibias vss vss sky130_fd_pr__nfet_01v8 L=0.5u W=1u
M9596 o6 ibias vss vss sky130_fd_pr__nfet_01v8 L=0.5u W=1u
M9597 o6 ibias vss vss sky130_fd_pr__nfet_01v8 L=0.5u W=1u
M9598 o6 ibias vss vss sky130_fd_pr__nfet_01v8 L=0.5u W=1u
M9599 o6 ibias vss vss sky130_fd_pr__nfet_01v8 L=0.5u W=1u
M9600 o6 ibias vss vss sky130_fd_pr__nfet_01v8 L=0.5u W=1u
M9601 o6 ibias vss vss sky130_fd_pr__nfet_01v8 L=0.5u W=1u
M9602 o6 ibias vss vss sky130_fd_pr__nfet_01v8 L=0.5u W=1u
M9603 o6 ibias vss vss sky130_fd_pr__nfet_01v8 L=0.5u W=1u
M9604 o6 ibias vss vss sky130_fd_pr__nfet_01v8 L=0.5u W=1u
M9605 o6 ibias vss vss sky130_fd_pr__nfet_01v8 L=0.5u W=1u
M9606 o6 ibias vss vss sky130_fd_pr__nfet_01v8 L=0.5u W=1u
M9607 o6 ibias vss vss sky130_fd_pr__nfet_01v8 L=0.5u W=1u
M9608 o6 ibias vss vss sky130_fd_pr__nfet_01v8 L=0.5u W=1u
M9609 o6 ibias vss vss sky130_fd_pr__nfet_01v8 L=0.5u W=1u
M9610 o6 ibias vss vss sky130_fd_pr__nfet_01v8 L=0.5u W=1u
M9611 o6 ibias vss vss sky130_fd_pr__nfet_01v8 L=0.5u W=1u
M9612 o6 ibias vss vss sky130_fd_pr__nfet_01v8 L=0.5u W=1u
M9613 o6 ibias vss vss sky130_fd_pr__nfet_01v8 L=0.5u W=1u
M9614 o6 ibias vss vss sky130_fd_pr__nfet_01v8 L=0.5u W=1u
M9615 o6 ibias vss vss sky130_fd_pr__nfet_01v8 L=0.5u W=1u
M9616 o6 ibias vss vss sky130_fd_pr__nfet_01v8 L=0.5u W=1u
M9617 o6 ibias vss vss sky130_fd_pr__nfet_01v8 L=0.5u W=1u
M9618 o6 ibias vss vss sky130_fd_pr__nfet_01v8 L=0.5u W=1u
M9619 o6 ibias vss vss sky130_fd_pr__nfet_01v8 L=0.5u W=1u
M9620 o6 ibias vss vss sky130_fd_pr__nfet_01v8 L=0.5u W=1u
M9621 o6 ibias vss vss sky130_fd_pr__nfet_01v8 L=0.5u W=1u
M9622 o6 ibias vss vss sky130_fd_pr__nfet_01v8 L=0.5u W=1u
M9623 o6 ibias vss vss sky130_fd_pr__nfet_01v8 L=0.5u W=1u
M9624 o6 ibias vss vss sky130_fd_pr__nfet_01v8 L=0.5u W=1u
M9625 o6 ibias vss vss sky130_fd_pr__nfet_01v8 L=0.5u W=1u
M9626 o6 ibias vss vss sky130_fd_pr__nfet_01v8 L=0.5u W=1u
M9627 o6 ibias vss vss sky130_fd_pr__nfet_01v8 L=0.5u W=1u
M9628 o6 ibias vss vss sky130_fd_pr__nfet_01v8 L=0.5u W=1u
M9629 o6 ibias vss vss sky130_fd_pr__nfet_01v8 L=0.5u W=1u
M9630 o6 ibias vss vss sky130_fd_pr__nfet_01v8 L=0.5u W=1u
M9631 o6 ibias vss vss sky130_fd_pr__nfet_01v8 L=0.5u W=1u
M9632 o6 ibias vss vss sky130_fd_pr__nfet_01v8 L=0.5u W=1u
M9633 o6 ibias vss vss sky130_fd_pr__nfet_01v8 L=0.5u W=1u
M9634 o6 ibias vss vss sky130_fd_pr__nfet_01v8 L=0.5u W=1u
M9635 o6 ibias vss vss sky130_fd_pr__nfet_01v8 L=0.5u W=1u
M9636 o6 ibias vss vss sky130_fd_pr__nfet_01v8 L=0.5u W=1u
M9637 o6 ibias vss vss sky130_fd_pr__nfet_01v8 L=0.5u W=1u
M9638 o6 ibias vss vss sky130_fd_pr__nfet_01v8 L=0.5u W=1u
M9639 o6 ibias vss vss sky130_fd_pr__nfet_01v8 L=0.5u W=1u
M9640 o6 ibias vss vss sky130_fd_pr__nfet_01v8 L=0.5u W=1u
M9641 o6 ibias vss vss sky130_fd_pr__nfet_01v8 L=0.5u W=1u
M9642 o6 ibias vss vss sky130_fd_pr__nfet_01v8 L=0.5u W=1u
M9643 o6 ibias vss vss sky130_fd_pr__nfet_01v8 L=0.5u W=1u
M9644 o6 ibias vss vss sky130_fd_pr__nfet_01v8 L=0.5u W=1u
M9645 o6 ibias vss vss sky130_fd_pr__nfet_01v8 L=0.5u W=1u
M9646 o6 ibias vss vss sky130_fd_pr__nfet_01v8 L=0.5u W=1u
M9647 o6 ibias vss vss sky130_fd_pr__nfet_01v8 L=0.5u W=1u
M9648 o6 ibias vss vss sky130_fd_pr__nfet_01v8 L=0.5u W=1u
M9649 o6 ibias vss vss sky130_fd_pr__nfet_01v8 L=0.5u W=1u
M9650 o6 ibias vss vss sky130_fd_pr__nfet_01v8 L=0.5u W=1u
M9651 o6 ibias vss vss sky130_fd_pr__nfet_01v8 L=0.5u W=1u
M9652 o6 ibias vss vss sky130_fd_pr__nfet_01v8 L=0.5u W=1u
M9653 o6 ibias vss vss sky130_fd_pr__nfet_01v8 L=0.5u W=1u
M9654 o6 ibias vss vss sky130_fd_pr__nfet_01v8 L=0.5u W=1u
M9655 o6 ibias vss vss sky130_fd_pr__nfet_01v8 L=0.5u W=1u
M9656 o6 ibias vss vss sky130_fd_pr__nfet_01v8 L=0.5u W=1u
M9657 o6 ibias vss vss sky130_fd_pr__nfet_01v8 L=0.5u W=1u
M9658 o6 ibias vss vss sky130_fd_pr__nfet_01v8 L=0.5u W=1u
M9659 o6 ibias vss vss sky130_fd_pr__nfet_01v8 L=0.5u W=1u
M9660 o6 ibias vss vss sky130_fd_pr__nfet_01v8 L=0.5u W=1u
M9661 o6 ibias vss vss sky130_fd_pr__nfet_01v8 L=0.5u W=1u
M9662 o6 ibias vss vss sky130_fd_pr__nfet_01v8 L=0.5u W=1u
M9663 o6 ibias vss vss sky130_fd_pr__nfet_01v8 L=0.5u W=1u
M9664 o6 ibias vss vss sky130_fd_pr__nfet_01v8 L=0.5u W=1u
M9665 o6 ibias vss vss sky130_fd_pr__nfet_01v8 L=0.5u W=1u
M9666 o6 ibias vss vss sky130_fd_pr__nfet_01v8 L=0.5u W=1u
M9667 o6 ibias vss vss sky130_fd_pr__nfet_01v8 L=0.5u W=1u
M9668 o6 ibias vss vss sky130_fd_pr__nfet_01v8 L=0.5u W=1u
M9669 o6 ibias vss vss sky130_fd_pr__nfet_01v8 L=0.5u W=1u
M9670 o6 ibias vss vss sky130_fd_pr__nfet_01v8 L=0.5u W=1u
M9671 o6 ibias vss vss sky130_fd_pr__nfet_01v8 L=0.5u W=1u
M9672 o6 ibias vss vss sky130_fd_pr__nfet_01v8 L=0.5u W=1u
M9673 o6 ibias vss vss sky130_fd_pr__nfet_01v8 L=0.5u W=1u
M9674 o6 ibias vss vss sky130_fd_pr__nfet_01v8 L=0.5u W=1u
M9675 o6 ibias vss vss sky130_fd_pr__nfet_01v8 L=0.5u W=1u
M9676 o6 ibias vss vss sky130_fd_pr__nfet_01v8 L=0.5u W=1u
M9677 o6 ibias vss vss sky130_fd_pr__nfet_01v8 L=0.5u W=1u
M9678 o6 ibias vss vss sky130_fd_pr__nfet_01v8 L=0.5u W=1u
M9679 o6 ibias vss vss sky130_fd_pr__nfet_01v8 L=0.5u W=1u
M9680 o6 ibias vss vss sky130_fd_pr__nfet_01v8 L=0.5u W=1u
M9681 o6 ibias vss vss sky130_fd_pr__nfet_01v8 L=0.5u W=1u
M9682 o6 ibias vss vss sky130_fd_pr__nfet_01v8 L=0.5u W=1u
M9683 o6 ibias vss vss sky130_fd_pr__nfet_01v8 L=0.5u W=1u
M9684 o6 ibias vss vss sky130_fd_pr__nfet_01v8 L=0.5u W=1u
M9685 o6 ibias vss vss sky130_fd_pr__nfet_01v8 L=0.5u W=1u
M9686 o6 ibias vss vss sky130_fd_pr__nfet_01v8 L=0.5u W=1u
M9687 o6 ibias vss vss sky130_fd_pr__nfet_01v8 L=0.5u W=1u
M9688 o6 ibias vss vss sky130_fd_pr__nfet_01v8 L=0.5u W=1u
M9689 o6 ibias vss vss sky130_fd_pr__nfet_01v8 L=0.5u W=1u
M9690 o6 ibias vss vss sky130_fd_pr__nfet_01v8 L=0.5u W=1u
M9691 o6 ibias vss vss sky130_fd_pr__nfet_01v8 L=0.5u W=1u
M9692 o6 ibias vss vss sky130_fd_pr__nfet_01v8 L=0.5u W=1u
M9693 o6 ibias vss vss sky130_fd_pr__nfet_01v8 L=0.5u W=1u
M9694 o6 ibias vss vss sky130_fd_pr__nfet_01v8 L=0.5u W=1u
M9695 o6 ibias vss vss sky130_fd_pr__nfet_01v8 L=0.5u W=1u
M9696 o6 ibias vss vss sky130_fd_pr__nfet_01v8 L=0.5u W=1u
M9697 o6 ibias vss vss sky130_fd_pr__nfet_01v8 L=0.5u W=1u
M9698 o6 ibias vss vss sky130_fd_pr__nfet_01v8 L=0.5u W=1u
M9699 o6 ibias vss vss sky130_fd_pr__nfet_01v8 L=0.5u W=1u
M9700 o6 ibias vss vss sky130_fd_pr__nfet_01v8 L=0.5u W=1u
M9701 o6 ibias vss vss sky130_fd_pr__nfet_01v8 L=0.5u W=1u
M9702 o6 ibias vss vss sky130_fd_pr__nfet_01v8 L=0.5u W=1u
M9703 o6 ibias vss vss sky130_fd_pr__nfet_01v8 L=0.5u W=1u
M9704 o6 ibias vss vss sky130_fd_pr__nfet_01v8 L=0.5u W=1u
M9705 o6 ibias vss vss sky130_fd_pr__nfet_01v8 L=0.5u W=1u
M9706 o6 ibias vss vss sky130_fd_pr__nfet_01v8 L=0.5u W=1u
M9707 o6 ibias vss vss sky130_fd_pr__nfet_01v8 L=0.5u W=1u
M9708 o6 ibias vss vss sky130_fd_pr__nfet_01v8 L=0.5u W=1u
M9709 o6 ibias vss vss sky130_fd_pr__nfet_01v8 L=0.5u W=1u
M9710 o6 ibias vss vss sky130_fd_pr__nfet_01v8 L=0.5u W=1u
M9711 o6 ibias vss vss sky130_fd_pr__nfet_01v8 L=0.5u W=1u
M9712 o6 ibias vss vss sky130_fd_pr__nfet_01v8 L=0.5u W=1u
M9713 o6 ibias vss vss sky130_fd_pr__nfet_01v8 L=0.5u W=1u
M9714 o6 ibias vss vss sky130_fd_pr__nfet_01v8 L=0.5u W=1u
M9715 o6 ibias vss vss sky130_fd_pr__nfet_01v8 L=0.5u W=1u
M9716 o6 ibias vss vss sky130_fd_pr__nfet_01v8 L=0.5u W=1u
M9717 o6 ibias vss vss sky130_fd_pr__nfet_01v8 L=0.5u W=1u
M9718 o6 ibias vss vss sky130_fd_pr__nfet_01v8 L=0.5u W=1u
M9719 o6 ibias vss vss sky130_fd_pr__nfet_01v8 L=0.5u W=1u
M9720 o6 ibias vss vss sky130_fd_pr__nfet_01v8 L=0.5u W=1u
M9721 o6 ibias vss vss sky130_fd_pr__nfet_01v8 L=0.5u W=1u
M9722 o6 ibias vss vss sky130_fd_pr__nfet_01v8 L=0.5u W=1u
M9723 o6 ibias vss vss sky130_fd_pr__nfet_01v8 L=0.5u W=1u
M9724 o6 ibias vss vss sky130_fd_pr__nfet_01v8 L=0.5u W=1u
M9725 o6 ibias vss vss sky130_fd_pr__nfet_01v8 L=0.5u W=1u
M9726 o6 ibias vss vss sky130_fd_pr__nfet_01v8 L=0.5u W=1u
M9727 o6 ibias vss vss sky130_fd_pr__nfet_01v8 L=0.5u W=1u
M9728 o6 ibias vss vss sky130_fd_pr__nfet_01v8 L=0.5u W=1u
M9729 o6 ibias vss vss sky130_fd_pr__nfet_01v8 L=0.5u W=1u
M9730 o6 ibias vss vss sky130_fd_pr__nfet_01v8 L=0.5u W=1u
M9731 o6 ibias vss vss sky130_fd_pr__nfet_01v8 L=0.5u W=1u
M9732 o6 ibias vss vss sky130_fd_pr__nfet_01v8 L=0.5u W=1u
M9733 o6 ibias vss vss sky130_fd_pr__nfet_01v8 L=0.5u W=1u
M9734 o6 ibias vss vss sky130_fd_pr__nfet_01v8 L=0.5u W=1u
M9735 o6 ibias vss vss sky130_fd_pr__nfet_01v8 L=0.5u W=1u
M9736 o6 ibias vss vss sky130_fd_pr__nfet_01v8 L=0.5u W=1u
M9737 o6 ibias vss vss sky130_fd_pr__nfet_01v8 L=0.5u W=1u
M9738 o6 ibias vss vss sky130_fd_pr__nfet_01v8 L=0.5u W=1u
M9739 o6 ibias vss vss sky130_fd_pr__nfet_01v8 L=0.5u W=1u
M9740 o6 ibias vss vss sky130_fd_pr__nfet_01v8 L=0.5u W=1u
M9741 o6 ibias vss vss sky130_fd_pr__nfet_01v8 L=0.5u W=1u
M9742 o6 ibias vss vss sky130_fd_pr__nfet_01v8 L=0.5u W=1u
M9743 o6 ibias vss vss sky130_fd_pr__nfet_01v8 L=0.5u W=1u
M9744 o6 ibias vss vss sky130_fd_pr__nfet_01v8 L=0.5u W=1u
M9745 o6 ibias vss vss sky130_fd_pr__nfet_01v8 L=0.5u W=1u
M9746 o6 ibias vss vss sky130_fd_pr__nfet_01v8 L=0.5u W=1u
M9747 o6 ibias vss vss sky130_fd_pr__nfet_01v8 L=0.5u W=1u
M9748 o6 ibias vss vss sky130_fd_pr__nfet_01v8 L=0.5u W=1u
M9749 o6 ibias vss vss sky130_fd_pr__nfet_01v8 L=0.5u W=1u
M9750 o6 ibias vss vss sky130_fd_pr__nfet_01v8 L=0.5u W=1u
M9751 o6 ibias vss vss sky130_fd_pr__nfet_01v8 L=0.5u W=1u
M9752 o6 ibias vss vss sky130_fd_pr__nfet_01v8 L=0.5u W=1u
M9753 o6 ibias vss vss sky130_fd_pr__nfet_01v8 L=0.5u W=1u
M9754 o6 ibias vss vss sky130_fd_pr__nfet_01v8 L=0.5u W=1u
M9755 o6 ibias vss vss sky130_fd_pr__nfet_01v8 L=0.5u W=1u
M9756 o6 ibias vss vss sky130_fd_pr__nfet_01v8 L=0.5u W=1u
M9757 o6 ibias vss vss sky130_fd_pr__nfet_01v8 L=0.5u W=1u
M9758 o6 ibias vss vss sky130_fd_pr__nfet_01v8 L=0.5u W=1u
M9759 o6 ibias vss vss sky130_fd_pr__nfet_01v8 L=0.5u W=1u
M9760 o6 ibias vss vss sky130_fd_pr__nfet_01v8 L=0.5u W=1u
M9761 o6 ibias vss vss sky130_fd_pr__nfet_01v8 L=0.5u W=1u
M9762 o6 ibias vss vss sky130_fd_pr__nfet_01v8 L=0.5u W=1u
M9763 o6 ibias vss vss sky130_fd_pr__nfet_01v8 L=0.5u W=1u
M9764 o6 ibias vss vss sky130_fd_pr__nfet_01v8 L=0.5u W=1u
M9765 o6 ibias vss vss sky130_fd_pr__nfet_01v8 L=0.5u W=1u
M9766 o6 ibias vss vss sky130_fd_pr__nfet_01v8 L=0.5u W=1u
M9767 o6 ibias vss vss sky130_fd_pr__nfet_01v8 L=0.5u W=1u
M9768 o6 ibias vss vss sky130_fd_pr__nfet_01v8 L=0.5u W=1u
M9769 o6 ibias vss vss sky130_fd_pr__nfet_01v8 L=0.5u W=1u
M9770 o6 ibias vss vss sky130_fd_pr__nfet_01v8 L=0.5u W=1u
M9771 o6 ibias vss vss sky130_fd_pr__nfet_01v8 L=0.5u W=1u
M9772 o6 ibias vss vss sky130_fd_pr__nfet_01v8 L=0.5u W=1u
M9773 o6 ibias vss vss sky130_fd_pr__nfet_01v8 L=0.5u W=1u
M9774 o6 ibias vss vss sky130_fd_pr__nfet_01v8 L=0.5u W=1u
M9775 o6 ibias vss vss sky130_fd_pr__nfet_01v8 L=0.5u W=1u
M9776 o6 ibias vss vss sky130_fd_pr__nfet_01v8 L=0.5u W=1u
M9777 o6 ibias vss vss sky130_fd_pr__nfet_01v8 L=0.5u W=1u
M9778 o6 ibias vss vss sky130_fd_pr__nfet_01v8 L=0.5u W=1u
M9779 o6 ibias vss vss sky130_fd_pr__nfet_01v8 L=0.5u W=1u
M9780 o6 ibias vss vss sky130_fd_pr__nfet_01v8 L=0.5u W=1u
M9781 o6 ibias vss vss sky130_fd_pr__nfet_01v8 L=0.5u W=1u
M9782 o6 ibias vss vss sky130_fd_pr__nfet_01v8 L=0.5u W=1u
M9783 o6 ibias vss vss sky130_fd_pr__nfet_01v8 L=0.5u W=1u
M9784 o6 ibias vss vss sky130_fd_pr__nfet_01v8 L=0.5u W=1u
M9785 o6 ibias vss vss sky130_fd_pr__nfet_01v8 L=0.5u W=1u
M9786 o6 ibias vss vss sky130_fd_pr__nfet_01v8 L=0.5u W=1u
M9787 o6 ibias vss vss sky130_fd_pr__nfet_01v8 L=0.5u W=1u
M9788 o6 ibias vss vss sky130_fd_pr__nfet_01v8 L=0.5u W=1u
M9789 o6 ibias vss vss sky130_fd_pr__nfet_01v8 L=0.5u W=1u
M9790 o6 ibias vss vss sky130_fd_pr__nfet_01v8 L=0.5u W=1u
M9791 o6 ibias vss vss sky130_fd_pr__nfet_01v8 L=0.5u W=1u
M9792 o6 ibias vss vss sky130_fd_pr__nfet_01v8 L=0.5u W=1u
M9793 o6 ibias vss vss sky130_fd_pr__nfet_01v8 L=0.5u W=1u
M9794 o6 ibias vss vss sky130_fd_pr__nfet_01v8 L=0.5u W=1u
M9795 o6 ibias vss vss sky130_fd_pr__nfet_01v8 L=0.5u W=1u
M9796 o6 ibias vss vss sky130_fd_pr__nfet_01v8 L=0.5u W=1u
M9797 o6 ibias vss vss sky130_fd_pr__nfet_01v8 L=0.5u W=1u
M9798 o6 ibias vss vss sky130_fd_pr__nfet_01v8 L=0.5u W=1u
M9799 o6 ibias vss vss sky130_fd_pr__nfet_01v8 L=0.5u W=1u
M9800 o6 ibias vss vss sky130_fd_pr__nfet_01v8 L=0.5u W=1u
M9801 o6 ibias vss vss sky130_fd_pr__nfet_01v8 L=0.5u W=1u
M9802 o6 ibias vss vss sky130_fd_pr__nfet_01v8 L=0.5u W=1u
M9803 o6 ibias vss vss sky130_fd_pr__nfet_01v8 L=0.5u W=1u
M9804 o6 ibias vss vss sky130_fd_pr__nfet_01v8 L=0.5u W=1u
M9805 o6 ibias vss vss sky130_fd_pr__nfet_01v8 L=0.5u W=1u
M9806 o6 ibias vss vss sky130_fd_pr__nfet_01v8 L=0.5u W=1u
M9807 o6 ibias vss vss sky130_fd_pr__nfet_01v8 L=0.5u W=1u
M9808 o6 ibias vss vss sky130_fd_pr__nfet_01v8 L=0.5u W=1u
M9809 o6 ibias vss vss sky130_fd_pr__nfet_01v8 L=0.5u W=1u
M9810 o6 ibias vss vss sky130_fd_pr__nfet_01v8 L=0.5u W=1u
M9811 o6 ibias vss vss sky130_fd_pr__nfet_01v8 L=0.5u W=1u
M9812 o6 ibias vss vss sky130_fd_pr__nfet_01v8 L=0.5u W=1u
M9813 o6 ibias vss vss sky130_fd_pr__nfet_01v8 L=0.5u W=1u
M9814 o6 ibias vss vss sky130_fd_pr__nfet_01v8 L=0.5u W=1u
M9815 o6 ibias vss vss sky130_fd_pr__nfet_01v8 L=0.5u W=1u
M9816 o6 ibias vss vss sky130_fd_pr__nfet_01v8 L=0.5u W=1u
M9817 o6 ibias vss vss sky130_fd_pr__nfet_01v8 L=0.5u W=1u
M9818 o6 ibias vss vss sky130_fd_pr__nfet_01v8 L=0.5u W=1u
M9819 o6 ibias vss vss sky130_fd_pr__nfet_01v8 L=0.5u W=1u
M9820 o6 ibias vss vss sky130_fd_pr__nfet_01v8 L=0.5u W=1u
M9821 o6 ibias vss vss sky130_fd_pr__nfet_01v8 L=0.5u W=1u
M9822 o6 ibias vss vss sky130_fd_pr__nfet_01v8 L=0.5u W=1u
M9823 o6 ibias vss vss sky130_fd_pr__nfet_01v8 L=0.5u W=1u
M9824 o6 ibias vss vss sky130_fd_pr__nfet_01v8 L=0.5u W=1u
M9825 o6 ibias vss vss sky130_fd_pr__nfet_01v8 L=0.5u W=1u
M9826 o6 ibias vss vss sky130_fd_pr__nfet_01v8 L=0.5u W=1u
M9827 o6 ibias vss vss sky130_fd_pr__nfet_01v8 L=0.5u W=1u
M9828 o6 ibias vss vss sky130_fd_pr__nfet_01v8 L=0.5u W=1u
M9829 o6 ibias vss vss sky130_fd_pr__nfet_01v8 L=0.5u W=1u
M9830 o6 ibias vss vss sky130_fd_pr__nfet_01v8 L=0.5u W=1u
M9831 o6 ibias vss vss sky130_fd_pr__nfet_01v8 L=0.5u W=1u
M9832 o6 ibias vss vss sky130_fd_pr__nfet_01v8 L=0.5u W=1u
M9833 o6 ibias vss vss sky130_fd_pr__nfet_01v8 L=0.5u W=1u
M9834 o6 ibias vss vss sky130_fd_pr__nfet_01v8 L=0.5u W=1u
M9835 o6 ibias vss vss sky130_fd_pr__nfet_01v8 L=0.5u W=1u
M9836 o6 ibias vss vss sky130_fd_pr__nfet_01v8 L=0.5u W=1u
M9837 o6 ibias vss vss sky130_fd_pr__nfet_01v8 L=0.5u W=1u
M9838 o6 ibias vss vss sky130_fd_pr__nfet_01v8 L=0.5u W=1u
M9839 o6 ibias vss vss sky130_fd_pr__nfet_01v8 L=0.5u W=1u
M9840 o6 ibias vss vss sky130_fd_pr__nfet_01v8 L=0.5u W=1u
M9841 o6 ibias vss vss sky130_fd_pr__nfet_01v8 L=0.5u W=1u
M9842 o6 ibias vss vss sky130_fd_pr__nfet_01v8 L=0.5u W=1u
M9843 o6 ibias vss vss sky130_fd_pr__nfet_01v8 L=0.5u W=1u
M9844 o6 ibias vss vss sky130_fd_pr__nfet_01v8 L=0.5u W=1u
M9845 o6 ibias vss vss sky130_fd_pr__nfet_01v8 L=0.5u W=1u
M9846 o6 ibias vss vss sky130_fd_pr__nfet_01v8 L=0.5u W=1u
M9847 o6 ibias vss vss sky130_fd_pr__nfet_01v8 L=0.5u W=1u
M9848 o6 ibias vss vss sky130_fd_pr__nfet_01v8 L=0.5u W=1u
M9849 o6 ibias vss vss sky130_fd_pr__nfet_01v8 L=0.5u W=1u
M9850 o6 ibias vss vss sky130_fd_pr__nfet_01v8 L=0.5u W=1u
M9851 o6 ibias vss vss sky130_fd_pr__nfet_01v8 L=0.5u W=1u
M9852 o6 ibias vss vss sky130_fd_pr__nfet_01v8 L=0.5u W=1u
M9853 o6 ibias vss vss sky130_fd_pr__nfet_01v8 L=0.5u W=1u
M9854 o6 ibias vss vss sky130_fd_pr__nfet_01v8 L=0.5u W=1u
M9855 o6 ibias vss vss sky130_fd_pr__nfet_01v8 L=0.5u W=1u
M9856 o6 ibias vss vss sky130_fd_pr__nfet_01v8 L=0.5u W=1u
M9857 o6 ibias vss vss sky130_fd_pr__nfet_01v8 L=0.5u W=1u
M9858 o6 ibias vss vss sky130_fd_pr__nfet_01v8 L=0.5u W=1u
M9859 o6 ibias vss vss sky130_fd_pr__nfet_01v8 L=0.5u W=1u
M9860 o6 ibias vss vss sky130_fd_pr__nfet_01v8 L=0.5u W=1u
M9861 o6 ibias vss vss sky130_fd_pr__nfet_01v8 L=0.5u W=1u
M9862 o6 ibias vss vss sky130_fd_pr__nfet_01v8 L=0.5u W=1u
M9863 o6 ibias vss vss sky130_fd_pr__nfet_01v8 L=0.5u W=1u
M9864 o6 ibias vss vss sky130_fd_pr__nfet_01v8 L=0.5u W=1u
M9865 o6 ibias vss vss sky130_fd_pr__nfet_01v8 L=0.5u W=1u
M9866 o6 ibias vss vss sky130_fd_pr__nfet_01v8 L=0.5u W=1u
M9867 o6 ibias vss vss sky130_fd_pr__nfet_01v8 L=0.5u W=1u
M9868 o6 ibias vss vss sky130_fd_pr__nfet_01v8 L=0.5u W=1u
M9869 o6 ibias vss vss sky130_fd_pr__nfet_01v8 L=0.5u W=1u
M9870 o6 ibias vss vss sky130_fd_pr__nfet_01v8 L=0.5u W=1u
M9871 o6 ibias vss vss sky130_fd_pr__nfet_01v8 L=0.5u W=1u
M9872 o6 ibias vss vss sky130_fd_pr__nfet_01v8 L=0.5u W=1u
M9873 o6 ibias vss vss sky130_fd_pr__nfet_01v8 L=0.5u W=1u
M9874 o6 ibias vss vss sky130_fd_pr__nfet_01v8 L=0.5u W=1u
M9875 o6 ibias vss vss sky130_fd_pr__nfet_01v8 L=0.5u W=1u
M9876 o6 ibias vss vss sky130_fd_pr__nfet_01v8 L=0.5u W=1u
M9877 o6 ibias vss vss sky130_fd_pr__nfet_01v8 L=0.5u W=1u
M9878 o6 ibias vss vss sky130_fd_pr__nfet_01v8 L=0.5u W=1u
M9879 o6 ibias vss vss sky130_fd_pr__nfet_01v8 L=0.5u W=1u
M9880 o6 ibias vss vss sky130_fd_pr__nfet_01v8 L=0.5u W=1u
M9881 o6 ibias vss vss sky130_fd_pr__nfet_01v8 L=0.5u W=1u
M9882 o6 ibias vss vss sky130_fd_pr__nfet_01v8 L=0.5u W=1u
M9883 o6 ibias vss vss sky130_fd_pr__nfet_01v8 L=0.5u W=1u
M9884 o6 ibias vss vss sky130_fd_pr__nfet_01v8 L=0.5u W=1u
M9885 o6 ibias vss vss sky130_fd_pr__nfet_01v8 L=0.5u W=1u
M9886 o6 ibias vss vss sky130_fd_pr__nfet_01v8 L=0.5u W=1u
M9887 o6 ibias vss vss sky130_fd_pr__nfet_01v8 L=0.5u W=1u
M9888 o6 ibias vss vss sky130_fd_pr__nfet_01v8 L=0.5u W=1u
M9889 o6 ibias vss vss sky130_fd_pr__nfet_01v8 L=0.5u W=1u
M9890 o6 ibias vss vss sky130_fd_pr__nfet_01v8 L=0.5u W=1u
M9891 o6 ibias vss vss sky130_fd_pr__nfet_01v8 L=0.5u W=1u
M9892 o6 ibias vss vss sky130_fd_pr__nfet_01v8 L=0.5u W=1u
M9893 o6 ibias vss vss sky130_fd_pr__nfet_01v8 L=0.5u W=1u
M9894 o6 ibias vss vss sky130_fd_pr__nfet_01v8 L=0.5u W=1u
M9895 o6 ibias vss vss sky130_fd_pr__nfet_01v8 L=0.5u W=1u
M9896 o6 ibias vss vss sky130_fd_pr__nfet_01v8 L=0.5u W=1u
M9897 o6 ibias vss vss sky130_fd_pr__nfet_01v8 L=0.5u W=1u
M9898 o6 ibias vss vss sky130_fd_pr__nfet_01v8 L=0.5u W=1u
M9899 o6 ibias vss vss sky130_fd_pr__nfet_01v8 L=0.5u W=1u
M9900 o6 ibias vss vss sky130_fd_pr__nfet_01v8 L=0.5u W=1u
M9901 o6 ibias vss vss sky130_fd_pr__nfet_01v8 L=0.5u W=1u
M9902 o6 ibias vss vss sky130_fd_pr__nfet_01v8 L=0.5u W=1u
M9903 o6 ibias vss vss sky130_fd_pr__nfet_01v8 L=0.5u W=1u
M9904 o6 ibias vss vss sky130_fd_pr__nfet_01v8 L=0.5u W=1u
M9905 o6 ibias vss vss sky130_fd_pr__nfet_01v8 L=0.5u W=1u
M9906 o6 ibias vss vss sky130_fd_pr__nfet_01v8 L=0.5u W=1u
M9907 o6 ibias vss vss sky130_fd_pr__nfet_01v8 L=0.5u W=1u
M9908 o6 ibias vss vss sky130_fd_pr__nfet_01v8 L=0.5u W=1u
M9909 o6 ibias vss vss sky130_fd_pr__nfet_01v8 L=0.5u W=1u
M9910 o6 ibias vss vss sky130_fd_pr__nfet_01v8 L=0.5u W=1u
M9911 o6 ibias vss vss sky130_fd_pr__nfet_01v8 L=0.5u W=1u
M9912 o6 ibias vss vss sky130_fd_pr__nfet_01v8 L=0.5u W=1u
M9913 o6 ibias vss vss sky130_fd_pr__nfet_01v8 L=0.5u W=1u
M9914 o6 ibias vss vss sky130_fd_pr__nfet_01v8 L=0.5u W=1u
M9915 o6 ibias vss vss sky130_fd_pr__nfet_01v8 L=0.5u W=1u
M9916 o6 ibias vss vss sky130_fd_pr__nfet_01v8 L=0.5u W=1u
M9917 o6 ibias vss vss sky130_fd_pr__nfet_01v8 L=0.5u W=1u
M9918 o6 ibias vss vss sky130_fd_pr__nfet_01v8 L=0.5u W=1u
M9919 o6 ibias vss vss sky130_fd_pr__nfet_01v8 L=0.5u W=1u
M9920 o6 ibias vss vss sky130_fd_pr__nfet_01v8 L=0.5u W=1u
M9921 o6 ibias vss vss sky130_fd_pr__nfet_01v8 L=0.5u W=1u
M9922 o6 ibias vss vss sky130_fd_pr__nfet_01v8 L=0.5u W=1u
M9923 o6 ibias vss vss sky130_fd_pr__nfet_01v8 L=0.5u W=1u
M9924 o6 ibias vss vss sky130_fd_pr__nfet_01v8 L=0.5u W=1u
M9925 o6 ibias vss vss sky130_fd_pr__nfet_01v8 L=0.5u W=1u
M9926 o6 ibias vss vss sky130_fd_pr__nfet_01v8 L=0.5u W=1u
M9927 o6 ibias vss vss sky130_fd_pr__nfet_01v8 L=0.5u W=1u
M9928 o6 ibias vss vss sky130_fd_pr__nfet_01v8 L=0.5u W=1u
M9929 o6 ibias vss vss sky130_fd_pr__nfet_01v8 L=0.5u W=1u
M9930 o6 ibias vss vss sky130_fd_pr__nfet_01v8 L=0.5u W=1u
M9931 o6 ibias vss vss sky130_fd_pr__nfet_01v8 L=0.5u W=1u
M9932 o6 ibias vss vss sky130_fd_pr__nfet_01v8 L=0.5u W=1u
M9933 o6 ibias vss vss sky130_fd_pr__nfet_01v8 L=0.5u W=1u
M9934 o6 ibias vss vss sky130_fd_pr__nfet_01v8 L=0.5u W=1u
M9935 o6 ibias vss vss sky130_fd_pr__nfet_01v8 L=0.5u W=1u
M9936 o6 ibias vss vss sky130_fd_pr__nfet_01v8 L=0.5u W=1u
M9937 o6 ibias vss vss sky130_fd_pr__nfet_01v8 L=0.5u W=1u
M9938 o6 ibias vss vss sky130_fd_pr__nfet_01v8 L=0.5u W=1u
M9939 o6 ibias vss vss sky130_fd_pr__nfet_01v8 L=0.5u W=1u
M9940 o6 ibias vss vss sky130_fd_pr__nfet_01v8 L=0.5u W=1u
M9941 o6 ibias vss vss sky130_fd_pr__nfet_01v8 L=0.5u W=1u
M9942 o6 ibias vss vss sky130_fd_pr__nfet_01v8 L=0.5u W=1u
M9943 o6 ibias vss vss sky130_fd_pr__nfet_01v8 L=0.5u W=1u
M9944 o6 ibias vss vss sky130_fd_pr__nfet_01v8 L=0.5u W=1u
M9945 o6 ibias vss vss sky130_fd_pr__nfet_01v8 L=0.5u W=1u
M9946 o6 ibias vss vss sky130_fd_pr__nfet_01v8 L=0.5u W=1u
M9947 o6 ibias vss vss sky130_fd_pr__nfet_01v8 L=0.5u W=1u
M9948 o6 ibias vss vss sky130_fd_pr__nfet_01v8 L=0.5u W=1u
M9949 o6 ibias vss vss sky130_fd_pr__nfet_01v8 L=0.5u W=1u
M9950 o6 ibias vss vss sky130_fd_pr__nfet_01v8 L=0.5u W=1u
M9951 o6 ibias vss vss sky130_fd_pr__nfet_01v8 L=0.5u W=1u
M9952 o6 ibias vss vss sky130_fd_pr__nfet_01v8 L=0.5u W=1u
M9953 o6 ibias vss vss sky130_fd_pr__nfet_01v8 L=0.5u W=1u
M9954 o6 ibias vss vss sky130_fd_pr__nfet_01v8 L=0.5u W=1u
M9955 o6 ibias vss vss sky130_fd_pr__nfet_01v8 L=0.5u W=1u
M9956 o6 ibias vss vss sky130_fd_pr__nfet_01v8 L=0.5u W=1u
M9957 o6 ibias vss vss sky130_fd_pr__nfet_01v8 L=0.5u W=1u
M9958 o6 ibias vss vss sky130_fd_pr__nfet_01v8 L=0.5u W=1u
M9959 o6 ibias vss vss sky130_fd_pr__nfet_01v8 L=0.5u W=1u
M9960 o6 ibias vss vss sky130_fd_pr__nfet_01v8 L=0.5u W=1u
M9961 o6 ibias vss vss sky130_fd_pr__nfet_01v8 L=0.5u W=1u
M9962 o6 ibias vss vss sky130_fd_pr__nfet_01v8 L=0.5u W=1u
M9963 o6 ibias vss vss sky130_fd_pr__nfet_01v8 L=0.5u W=1u
M9964 o6 ibias vss vss sky130_fd_pr__nfet_01v8 L=0.5u W=1u
M9965 o6 ibias vss vss sky130_fd_pr__nfet_01v8 L=0.5u W=1u
M9966 o6 ibias vss vss sky130_fd_pr__nfet_01v8 L=0.5u W=1u
M9967 o6 ibias vss vss sky130_fd_pr__nfet_01v8 L=0.5u W=1u
M9968 o6 ibias vss vss sky130_fd_pr__nfet_01v8 L=0.5u W=1u
M9969 o6 ibias vss vss sky130_fd_pr__nfet_01v8 L=0.5u W=1u
M9970 o6 ibias vss vss sky130_fd_pr__nfet_01v8 L=0.5u W=1u
M9971 o6 ibias vss vss sky130_fd_pr__nfet_01v8 L=0.5u W=1u
M9972 o6 ibias vss vss sky130_fd_pr__nfet_01v8 L=0.5u W=1u
M9973 o6 ibias vss vss sky130_fd_pr__nfet_01v8 L=0.5u W=1u
M9974 o6 ibias vss vss sky130_fd_pr__nfet_01v8 L=0.5u W=1u
M9975 o6 ibias vss vss sky130_fd_pr__nfet_01v8 L=0.5u W=1u
M9976 o6 ibias vss vss sky130_fd_pr__nfet_01v8 L=0.5u W=1u
M9977 o6 ibias vss vss sky130_fd_pr__nfet_01v8 L=0.5u W=1u
M9978 o6 ibias vss vss sky130_fd_pr__nfet_01v8 L=0.5u W=1u
M9979 o6 ibias vss vss sky130_fd_pr__nfet_01v8 L=0.5u W=1u
M9980 o6 ibias vss vss sky130_fd_pr__nfet_01v8 L=0.5u W=1u
M9981 o6 ibias vss vss sky130_fd_pr__nfet_01v8 L=0.5u W=1u
M9982 o6 ibias vss vss sky130_fd_pr__nfet_01v8 L=0.5u W=1u
M9983 o6 ibias vss vss sky130_fd_pr__nfet_01v8 L=0.5u W=1u
M9984 o6 ibias vss vss sky130_fd_pr__nfet_01v8 L=0.5u W=1u
M9985 o6 ibias vss vss sky130_fd_pr__nfet_01v8 L=0.5u W=1u
M9986 o6 ibias vss vss sky130_fd_pr__nfet_01v8 L=0.5u W=1u
M9987 o6 ibias vss vss sky130_fd_pr__nfet_01v8 L=0.5u W=1u
M9988 o6 ibias vss vss sky130_fd_pr__nfet_01v8 L=0.5u W=1u
M9989 o6 ibias vss vss sky130_fd_pr__nfet_01v8 L=0.5u W=1u
M9990 o6 ibias vss vss sky130_fd_pr__nfet_01v8 L=0.5u W=1u
M9991 o6 ibias vss vss sky130_fd_pr__nfet_01v8 L=0.5u W=1u
M9992 o6 ibias vss vss sky130_fd_pr__nfet_01v8 L=0.5u W=1u
M9993 o6 ibias vss vss sky130_fd_pr__nfet_01v8 L=0.5u W=1u
M9994 o6 ibias vss vss sky130_fd_pr__nfet_01v8 L=0.5u W=1u
M9995 o6 ibias vss vss sky130_fd_pr__nfet_01v8 L=0.5u W=1u
M9996 o6 ibias vss vss sky130_fd_pr__nfet_01v8 L=0.5u W=1u
M9997 o6 ibias vss vss sky130_fd_pr__nfet_01v8 L=0.5u W=1u
M9998 o6 ibias vss vss sky130_fd_pr__nfet_01v8 L=0.5u W=1u
M9999 o6 ibias vss vss sky130_fd_pr__nfet_01v8 L=0.5u W=1u
M10000 o6 ibias vss vss sky130_fd_pr__nfet_01v8 L=0.5u W=1u
M10001 o6 ibias vss vss sky130_fd_pr__nfet_01v8 L=0.5u W=1u
M10002 o6 ibias vss vss sky130_fd_pr__nfet_01v8 L=0.5u W=1u
M10003 o6 ibias vss vss sky130_fd_pr__nfet_01v8 L=0.5u W=1u
M10004 o6 ibias vss vss sky130_fd_pr__nfet_01v8 L=0.5u W=1u
M10005 o6 ibias vss vss sky130_fd_pr__nfet_01v8 L=0.5u W=1u
M10006 o6 ibias vss vss sky130_fd_pr__nfet_01v8 L=0.5u W=1u
M10007 o6 ibias vss vss sky130_fd_pr__nfet_01v8 L=0.5u W=1u
M10008 o6 ibias vss vss sky130_fd_pr__nfet_01v8 L=0.5u W=1u
M10009 o6 ibias vss vss sky130_fd_pr__nfet_01v8 L=0.5u W=1u
M10010 o6 ibias vss vss sky130_fd_pr__nfet_01v8 L=0.5u W=1u
M10011 o6 ibias vss vss sky130_fd_pr__nfet_01v8 L=0.5u W=1u
M10012 o6 ibias vss vss sky130_fd_pr__nfet_01v8 L=0.5u W=1u
M10013 o6 ibias vss vss sky130_fd_pr__nfet_01v8 L=0.5u W=1u
M10014 o6 ibias vss vss sky130_fd_pr__nfet_01v8 L=0.5u W=1u
M10015 o6 ibias vss vss sky130_fd_pr__nfet_01v8 L=0.5u W=1u
M10016 o6 ibias vss vss sky130_fd_pr__nfet_01v8 L=0.5u W=1u
M10017 o6 ibias vss vss sky130_fd_pr__nfet_01v8 L=0.5u W=1u
M10018 o6 ibias vss vss sky130_fd_pr__nfet_01v8 L=0.5u W=1u
M10019 o6 ibias vss vss sky130_fd_pr__nfet_01v8 L=0.5u W=1u
M10020 o6 ibias vss vss sky130_fd_pr__nfet_01v8 L=0.5u W=1u
M10021 o6 ibias vss vss sky130_fd_pr__nfet_01v8 L=0.5u W=1u
M10022 o6 ibias vss vss sky130_fd_pr__nfet_01v8 L=0.5u W=1u
M10023 o6 ibias vss vss sky130_fd_pr__nfet_01v8 L=0.5u W=1u
M10024 o6 ibias vss vss sky130_fd_pr__nfet_01v8 L=0.5u W=1u
M10025 o6 ibias vss vss sky130_fd_pr__nfet_01v8 L=0.5u W=1u
M10026 o6 ibias vss vss sky130_fd_pr__nfet_01v8 L=0.5u W=1u
M10027 o6 ibias vss vss sky130_fd_pr__nfet_01v8 L=0.5u W=1u
M10028 o6 ibias vss vss sky130_fd_pr__nfet_01v8 L=0.5u W=1u
M10029 o6 ibias vss vss sky130_fd_pr__nfet_01v8 L=0.5u W=1u
M10030 o6 ibias vss vss sky130_fd_pr__nfet_01v8 L=0.5u W=1u
M10031 o6 ibias vss vss sky130_fd_pr__nfet_01v8 L=0.5u W=1u
M10032 o6 ibias vss vss sky130_fd_pr__nfet_01v8 L=0.5u W=1u
M10033 o6 ibias vss vss sky130_fd_pr__nfet_01v8 L=0.5u W=1u
M10034 o6 ibias vss vss sky130_fd_pr__nfet_01v8 L=0.5u W=1u
M10035 o6 ibias vss vss sky130_fd_pr__nfet_01v8 L=0.5u W=1u
M10036 o6 ibias vss vss sky130_fd_pr__nfet_01v8 L=0.5u W=1u
M10037 o6 ibias vss vss sky130_fd_pr__nfet_01v8 L=0.5u W=1u
M10038 o6 ibias vss vss sky130_fd_pr__nfet_01v8 L=0.5u W=1u
M10039 o6 ibias vss vss sky130_fd_pr__nfet_01v8 L=0.5u W=1u
M10040 o6 ibias vss vss sky130_fd_pr__nfet_01v8 L=0.5u W=1u
M10041 o6 ibias vss vss sky130_fd_pr__nfet_01v8 L=0.5u W=1u
M10042 o6 ibias vss vss sky130_fd_pr__nfet_01v8 L=0.5u W=1u
M10043 o6 ibias vss vss sky130_fd_pr__nfet_01v8 L=0.5u W=1u
M10044 o6 ibias vss vss sky130_fd_pr__nfet_01v8 L=0.5u W=1u
M10045 o6 ibias vss vss sky130_fd_pr__nfet_01v8 L=0.5u W=1u
M10046 o6 ibias vss vss sky130_fd_pr__nfet_01v8 L=0.5u W=1u
M10047 o6 ibias vss vss sky130_fd_pr__nfet_01v8 L=0.5u W=1u
M10048 o6 ibias vss vss sky130_fd_pr__nfet_01v8 L=0.5u W=1u
M10049 o6 ibias vss vss sky130_fd_pr__nfet_01v8 L=0.5u W=1u
M10050 o6 ibias vss vss sky130_fd_pr__nfet_01v8 L=0.5u W=1u
M10051 o6 ibias vss vss sky130_fd_pr__nfet_01v8 L=0.5u W=1u
M10052 o6 ibias vss vss sky130_fd_pr__nfet_01v8 L=0.5u W=1u
M10053 o6 ibias vss vss sky130_fd_pr__nfet_01v8 L=0.5u W=1u
M10054 o6 ibias vss vss sky130_fd_pr__nfet_01v8 L=0.5u W=1u
M10055 o6 ibias vss vss sky130_fd_pr__nfet_01v8 L=0.5u W=1u
M10056 o6 ibias vss vss sky130_fd_pr__nfet_01v8 L=0.5u W=1u
M10057 o6 ibias vss vss sky130_fd_pr__nfet_01v8 L=0.5u W=1u
M10058 o6 ibias vss vss sky130_fd_pr__nfet_01v8 L=0.5u W=1u
M10059 o6 ibias vss vss sky130_fd_pr__nfet_01v8 L=0.5u W=1u
M10060 o6 ibias vss vss sky130_fd_pr__nfet_01v8 L=0.5u W=1u
M10061 o6 ibias vss vss sky130_fd_pr__nfet_01v8 L=0.5u W=1u
M10062 o6 ibias vss vss sky130_fd_pr__nfet_01v8 L=0.5u W=1u
M10063 o6 ibias vss vss sky130_fd_pr__nfet_01v8 L=0.5u W=1u
M10064 o6 ibias vss vss sky130_fd_pr__nfet_01v8 L=0.5u W=1u
M10065 o6 ibias vss vss sky130_fd_pr__nfet_01v8 L=0.5u W=1u
M10066 o6 ibias vss vss sky130_fd_pr__nfet_01v8 L=0.5u W=1u
M10067 o6 ibias vss vss sky130_fd_pr__nfet_01v8 L=0.5u W=1u
M10068 o6 ibias vss vss sky130_fd_pr__nfet_01v8 L=0.5u W=1u
M10069 o6 ibias vss vss sky130_fd_pr__nfet_01v8 L=0.5u W=1u
M10070 o6 ibias vss vss sky130_fd_pr__nfet_01v8 L=0.5u W=1u
M10071 o6 ibias vss vss sky130_fd_pr__nfet_01v8 L=0.5u W=1u
M10072 o6 ibias vss vss sky130_fd_pr__nfet_01v8 L=0.5u W=1u
M10073 o6 ibias vss vss sky130_fd_pr__nfet_01v8 L=0.5u W=1u
M10074 o6 ibias vss vss sky130_fd_pr__nfet_01v8 L=0.5u W=1u
M10075 o6 ibias vss vss sky130_fd_pr__nfet_01v8 L=0.5u W=1u
M10076 o6 ibias vss vss sky130_fd_pr__nfet_01v8 L=0.5u W=1u
M10077 o6 ibias vss vss sky130_fd_pr__nfet_01v8 L=0.5u W=1u
M10078 o6 ibias vss vss sky130_fd_pr__nfet_01v8 L=0.5u W=1u
M10079 o6 ibias vss vss sky130_fd_pr__nfet_01v8 L=0.5u W=1u
M10080 o6 ibias vss vss sky130_fd_pr__nfet_01v8 L=0.5u W=1u
M10081 o6 ibias vss vss sky130_fd_pr__nfet_01v8 L=0.5u W=1u
M10082 o6 ibias vss vss sky130_fd_pr__nfet_01v8 L=0.5u W=1u
M10083 o6 ibias vss vss sky130_fd_pr__nfet_01v8 L=0.5u W=1u
M10084 o6 ibias vss vss sky130_fd_pr__nfet_01v8 L=0.5u W=1u
M10085 o6 ibias vss vss sky130_fd_pr__nfet_01v8 L=0.5u W=1u
M10086 o6 ibias vss vss sky130_fd_pr__nfet_01v8 L=0.5u W=1u
M10087 o6 ibias vss vss sky130_fd_pr__nfet_01v8 L=0.5u W=1u
M10088 o6 ibias vss vss sky130_fd_pr__nfet_01v8 L=0.5u W=1u
M10089 o6 ibias vss vss sky130_fd_pr__nfet_01v8 L=0.5u W=1u
M10090 o6 ibias vss vss sky130_fd_pr__nfet_01v8 L=0.5u W=1u
M10091 o6 ibias vss vss sky130_fd_pr__nfet_01v8 L=0.5u W=1u
M10092 o6 ibias vss vss sky130_fd_pr__nfet_01v8 L=0.5u W=1u
M10093 o6 ibias vss vss sky130_fd_pr__nfet_01v8 L=0.5u W=1u
M10094 o6 ibias vss vss sky130_fd_pr__nfet_01v8 L=0.5u W=1u
M10095 o6 ibias vss vss sky130_fd_pr__nfet_01v8 L=0.5u W=1u
M10096 o6 ibias vss vss sky130_fd_pr__nfet_01v8 L=0.5u W=1u
M10097 o6 ibias vss vss sky130_fd_pr__nfet_01v8 L=0.5u W=1u
M10098 o6 ibias vss vss sky130_fd_pr__nfet_01v8 L=0.5u W=1u
M10099 o6 ibias vss vss sky130_fd_pr__nfet_01v8 L=0.5u W=1u
M10100 o6 ibias vss vss sky130_fd_pr__nfet_01v8 L=0.5u W=1u
M10101 o6 ibias vss vss sky130_fd_pr__nfet_01v8 L=0.5u W=1u
M10102 o6 ibias vss vss sky130_fd_pr__nfet_01v8 L=0.5u W=1u
M10103 o6 ibias vss vss sky130_fd_pr__nfet_01v8 L=0.5u W=1u
M10104 o6 ibias vss vss sky130_fd_pr__nfet_01v8 L=0.5u W=1u
M10105 o6 ibias vss vss sky130_fd_pr__nfet_01v8 L=0.5u W=1u
M10106 o6 ibias vss vss sky130_fd_pr__nfet_01v8 L=0.5u W=1u
M10107 o6 ibias vss vss sky130_fd_pr__nfet_01v8 L=0.5u W=1u
M10108 o6 ibias vss vss sky130_fd_pr__nfet_01v8 L=0.5u W=1u
M10109 o6 ibias vss vss sky130_fd_pr__nfet_01v8 L=0.5u W=1u
M10110 o6 ibias vss vss sky130_fd_pr__nfet_01v8 L=0.5u W=1u
M10111 o6 ibias vss vss sky130_fd_pr__nfet_01v8 L=0.5u W=1u
M10112 o6 ibias vss vss sky130_fd_pr__nfet_01v8 L=0.5u W=1u
M10113 o6 ibias vss vss sky130_fd_pr__nfet_01v8 L=0.5u W=1u
M10114 o6 ibias vss vss sky130_fd_pr__nfet_01v8 L=0.5u W=1u
M10115 o6 ibias vss vss sky130_fd_pr__nfet_01v8 L=0.5u W=1u
M10116 o6 ibias vss vss sky130_fd_pr__nfet_01v8 L=0.5u W=1u
M10117 o6 ibias vss vss sky130_fd_pr__nfet_01v8 L=0.5u W=1u
M10118 o6 ibias vss vss sky130_fd_pr__nfet_01v8 L=0.5u W=1u
M10119 o6 ibias vss vss sky130_fd_pr__nfet_01v8 L=0.5u W=1u
M10120 o6 ibias vss vss sky130_fd_pr__nfet_01v8 L=0.5u W=1u
M10121 o6 ibias vss vss sky130_fd_pr__nfet_01v8 L=0.5u W=1u
M10122 o6 ibias vss vss sky130_fd_pr__nfet_01v8 L=0.5u W=1u
M10123 o6 ibias vss vss sky130_fd_pr__nfet_01v8 L=0.5u W=1u
M10124 o6 ibias vss vss sky130_fd_pr__nfet_01v8 L=0.5u W=1u
M10125 o6 ibias vss vss sky130_fd_pr__nfet_01v8 L=0.5u W=1u
M10126 o6 ibias vss vss sky130_fd_pr__nfet_01v8 L=0.5u W=1u
M10127 o6 ibias vss vss sky130_fd_pr__nfet_01v8 L=0.5u W=1u
M10128 o6 ibias vss vss sky130_fd_pr__nfet_01v8 L=0.5u W=1u
M10129 o6 ibias vss vss sky130_fd_pr__nfet_01v8 L=0.5u W=1u
M10130 o6 ibias vss vss sky130_fd_pr__nfet_01v8 L=0.5u W=1u
M10131 o6 ibias vss vss sky130_fd_pr__nfet_01v8 L=0.5u W=1u
M10132 o6 ibias vss vss sky130_fd_pr__nfet_01v8 L=0.5u W=1u
M10133 o6 ibias vss vss sky130_fd_pr__nfet_01v8 L=0.5u W=1u
M10134 o6 ibias vss vss sky130_fd_pr__nfet_01v8 L=0.5u W=1u
M10135 o6 ibias vss vss sky130_fd_pr__nfet_01v8 L=0.5u W=1u
M10136 o6 ibias vss vss sky130_fd_pr__nfet_01v8 L=0.5u W=1u
M10137 o6 ibias vss vss sky130_fd_pr__nfet_01v8 L=0.5u W=1u
M10138 o6 ibias vss vss sky130_fd_pr__nfet_01v8 L=0.5u W=1u
M10139 o6 ibias vss vss sky130_fd_pr__nfet_01v8 L=0.5u W=1u
M10140 o6 ibias vss vss sky130_fd_pr__nfet_01v8 L=0.5u W=1u
M10141 o6 ibias vss vss sky130_fd_pr__nfet_01v8 L=0.5u W=1u
M10142 o6 ibias vss vss sky130_fd_pr__nfet_01v8 L=0.5u W=1u
M10143 o6 ibias vss vss sky130_fd_pr__nfet_01v8 L=0.5u W=1u
M10144 o6 ibias vss vss sky130_fd_pr__nfet_01v8 L=0.5u W=1u
M10145 o6 ibias vss vss sky130_fd_pr__nfet_01v8 L=0.5u W=1u
M10146 o6 ibias vss vss sky130_fd_pr__nfet_01v8 L=0.5u W=1u
M10147 o6 ibias vss vss sky130_fd_pr__nfet_01v8 L=0.5u W=1u
M10148 o6 ibias vss vss sky130_fd_pr__nfet_01v8 L=0.5u W=1u
M10149 o6 ibias vss vss sky130_fd_pr__nfet_01v8 L=0.5u W=1u
M10150 o6 ibias vss vss sky130_fd_pr__nfet_01v8 L=0.5u W=1u
M10151 o6 ibias vss vss sky130_fd_pr__nfet_01v8 L=0.5u W=1u
M10152 o6 ibias vss vss sky130_fd_pr__nfet_01v8 L=0.5u W=1u
M10153 o6 ibias vss vss sky130_fd_pr__nfet_01v8 L=0.5u W=1u
M10154 o6 ibias vss vss sky130_fd_pr__nfet_01v8 L=0.5u W=1u
M10155 o6 ibias vss vss sky130_fd_pr__nfet_01v8 L=0.5u W=1u
M10156 o6 ibias vss vss sky130_fd_pr__nfet_01v8 L=0.5u W=1u
M10157 o6 ibias vss vss sky130_fd_pr__nfet_01v8 L=0.5u W=1u
M10158 o6 ibias vss vss sky130_fd_pr__nfet_01v8 L=0.5u W=1u
M10159 o6 ibias vss vss sky130_fd_pr__nfet_01v8 L=0.5u W=1u
M10160 o6 ibias vss vss sky130_fd_pr__nfet_01v8 L=0.5u W=1u
M10161 o6 ibias vss vss sky130_fd_pr__nfet_01v8 L=0.5u W=1u
M10162 o6 ibias vss vss sky130_fd_pr__nfet_01v8 L=0.5u W=1u
M10163 o6 ibias vss vss sky130_fd_pr__nfet_01v8 L=0.5u W=1u
M10164 o6 ibias vss vss sky130_fd_pr__nfet_01v8 L=0.5u W=1u
M10165 o6 ibias vss vss sky130_fd_pr__nfet_01v8 L=0.5u W=1u
M10166 o6 ibias vss vss sky130_fd_pr__nfet_01v8 L=0.5u W=1u
M10167 o6 ibias vss vss sky130_fd_pr__nfet_01v8 L=0.5u W=1u
M10168 o6 ibias vss vss sky130_fd_pr__nfet_01v8 L=0.5u W=1u
M10169 o6 ibias vss vss sky130_fd_pr__nfet_01v8 L=0.5u W=1u
M10170 o6 ibias vss vss sky130_fd_pr__nfet_01v8 L=0.5u W=1u
M10171 o6 ibias vss vss sky130_fd_pr__nfet_01v8 L=0.5u W=1u
M10172 o6 ibias vss vss sky130_fd_pr__nfet_01v8 L=0.5u W=1u
M10173 o6 ibias vss vss sky130_fd_pr__nfet_01v8 L=0.5u W=1u
M10174 o6 ibias vss vss sky130_fd_pr__nfet_01v8 L=0.5u W=1u
M10175 o6 ibias vss vss sky130_fd_pr__nfet_01v8 L=0.5u W=1u
M10176 o6 ibias vss vss sky130_fd_pr__nfet_01v8 L=0.5u W=1u
M10177 o6 ibias vss vss sky130_fd_pr__nfet_01v8 L=0.5u W=1u
M10178 o6 ibias vss vss sky130_fd_pr__nfet_01v8 L=0.5u W=1u
M10179 o6 ibias vss vss sky130_fd_pr__nfet_01v8 L=0.5u W=1u
M10180 o6 ibias vss vss sky130_fd_pr__nfet_01v8 L=0.5u W=1u
M10181 o6 ibias vss vss sky130_fd_pr__nfet_01v8 L=0.5u W=1u
M10182 o6 ibias vss vss sky130_fd_pr__nfet_01v8 L=0.5u W=1u
M10183 o6 ibias vss vss sky130_fd_pr__nfet_01v8 L=0.5u W=1u
M10184 o6 ibias vss vss sky130_fd_pr__nfet_01v8 L=0.5u W=1u
M10185 o6 ibias vss vss sky130_fd_pr__nfet_01v8 L=0.5u W=1u
M10186 o6 ibias vss vss sky130_fd_pr__nfet_01v8 L=0.5u W=1u
M10187 o6 ibias vss vss sky130_fd_pr__nfet_01v8 L=0.5u W=1u
M10188 o6 ibias vss vss sky130_fd_pr__nfet_01v8 L=0.5u W=1u
M10189 o6 ibias vss vss sky130_fd_pr__nfet_01v8 L=0.5u W=1u
M10190 o6 ibias vss vss sky130_fd_pr__nfet_01v8 L=0.5u W=1u
M10191 o6 ibias vss vss sky130_fd_pr__nfet_01v8 L=0.5u W=1u
M10192 o6 ibias vss vss sky130_fd_pr__nfet_01v8 L=0.5u W=1u
M10193 o6 ibias vss vss sky130_fd_pr__nfet_01v8 L=0.5u W=1u
M10194 o6 ibias vss vss sky130_fd_pr__nfet_01v8 L=0.5u W=1u
M10195 o6 ibias vss vss sky130_fd_pr__nfet_01v8 L=0.5u W=1u
M10196 o6 ibias vss vss sky130_fd_pr__nfet_01v8 L=0.5u W=1u
M10197 o6 ibias vss vss sky130_fd_pr__nfet_01v8 L=0.5u W=1u
M10198 o6 ibias vss vss sky130_fd_pr__nfet_01v8 L=0.5u W=1u
M10199 o6 ibias vss vss sky130_fd_pr__nfet_01v8 L=0.5u W=1u
M10200 o6 ibias vss vss sky130_fd_pr__nfet_01v8 L=0.5u W=1u
M10201 o6 ibias vss vss sky130_fd_pr__nfet_01v8 L=0.5u W=1u
M10202 o6 ibias vss vss sky130_fd_pr__nfet_01v8 L=0.5u W=1u
M10203 o6 ibias vss vss sky130_fd_pr__nfet_01v8 L=0.5u W=1u
M10204 o6 ibias vss vss sky130_fd_pr__nfet_01v8 L=0.5u W=1u
M10205 o6 ibias vss vss sky130_fd_pr__nfet_01v8 L=0.5u W=1u
M10206 o6 ibias vss vss sky130_fd_pr__nfet_01v8 L=0.5u W=1u
M10207 o6 ibias vss vss sky130_fd_pr__nfet_01v8 L=0.5u W=1u
M10208 o6 ibias vss vss sky130_fd_pr__nfet_01v8 L=0.5u W=1u
M10209 o6 ibias vss vss sky130_fd_pr__nfet_01v8 L=0.5u W=1u
M10210 o6 ibias vss vss sky130_fd_pr__nfet_01v8 L=0.5u W=1u
M10211 o6 ibias vss vss sky130_fd_pr__nfet_01v8 L=0.5u W=1u
M10212 o6 ibias vss vss sky130_fd_pr__nfet_01v8 L=0.5u W=1u
M10213 o6 ibias vss vss sky130_fd_pr__nfet_01v8 L=0.5u W=1u
M10214 o6 ibias vss vss sky130_fd_pr__nfet_01v8 L=0.5u W=1u
M10215 o6 ibias vss vss sky130_fd_pr__nfet_01v8 L=0.5u W=1u
M10216 o6 ibias vss vss sky130_fd_pr__nfet_01v8 L=0.5u W=1u
M10217 o6 ibias vss vss sky130_fd_pr__nfet_01v8 L=0.5u W=1u
M10218 o6 ibias vss vss sky130_fd_pr__nfet_01v8 L=0.5u W=1u
M10219 o6 ibias vss vss sky130_fd_pr__nfet_01v8 L=0.5u W=1u
M10220 o6 ibias vss vss sky130_fd_pr__nfet_01v8 L=0.5u W=1u
M10221 o6 ibias vss vss sky130_fd_pr__nfet_01v8 L=0.5u W=1u
M10222 o6 ibias vss vss sky130_fd_pr__nfet_01v8 L=0.5u W=1u
M10223 o6 ibias vss vss sky130_fd_pr__nfet_01v8 L=0.5u W=1u
M10224 o6 ibias vss vss sky130_fd_pr__nfet_01v8 L=0.5u W=1u
M10225 o6 ibias vss vss sky130_fd_pr__nfet_01v8 L=0.5u W=1u
M10226 o6 ibias vss vss sky130_fd_pr__nfet_01v8 L=0.5u W=1u
M10227 o6 ibias vss vss sky130_fd_pr__nfet_01v8 L=0.5u W=1u
M10228 o6 ibias vss vss sky130_fd_pr__nfet_01v8 L=0.5u W=1u
M10229 o6 ibias vss vss sky130_fd_pr__nfet_01v8 L=0.5u W=1u
M10230 o6 ibias vss vss sky130_fd_pr__nfet_01v8 L=0.5u W=1u
M10231 o6 ibias vss vss sky130_fd_pr__nfet_01v8 L=0.5u W=1u
M10232 o6 ibias vss vss sky130_fd_pr__nfet_01v8 L=0.5u W=1u
M10233 o6 ibias vss vss sky130_fd_pr__nfet_01v8 L=0.5u W=1u
M10234 o6 ibias vss vss sky130_fd_pr__nfet_01v8 L=0.5u W=1u
M10235 o6 ibias vss vss sky130_fd_pr__nfet_01v8 L=0.5u W=1u
M10236 o6 ibias vss vss sky130_fd_pr__nfet_01v8 L=0.5u W=1u
M10237 o6 ibias vss vss sky130_fd_pr__nfet_01v8 L=0.5u W=1u
M10238 o6 ibias vss vss sky130_fd_pr__nfet_01v8 L=0.5u W=1u
M10239 o6 ibias vss vss sky130_fd_pr__nfet_01v8 L=0.5u W=1u
M10240 o6 ibias vss vss sky130_fd_pr__nfet_01v8 L=0.5u W=1u
M10241 o6 ibias vss vss sky130_fd_pr__nfet_01v8 L=0.5u W=1u
M10242 o6 ibias vss vss sky130_fd_pr__nfet_01v8 L=0.5u W=1u
M10243 o6 ibias vss vss sky130_fd_pr__nfet_01v8 L=0.5u W=1u
M10244 o6 ibias vss vss sky130_fd_pr__nfet_01v8 L=0.5u W=1u
M10245 o6 ibias vss vss sky130_fd_pr__nfet_01v8 L=0.5u W=1u
M10246 o6 ibias vss vss sky130_fd_pr__nfet_01v8 L=0.5u W=1u
M10247 o6 ibias vss vss sky130_fd_pr__nfet_01v8 L=0.5u W=1u
M10248 o6 ibias vss vss sky130_fd_pr__nfet_01v8 L=0.5u W=1u
M10249 o6 ibias vss vss sky130_fd_pr__nfet_01v8 L=0.5u W=1u
M10250 o6 ibias vss vss sky130_fd_pr__nfet_01v8 L=0.5u W=1u
M10251 o6 ibias vss vss sky130_fd_pr__nfet_01v8 L=0.5u W=1u
M10252 o6 ibias vss vss sky130_fd_pr__nfet_01v8 L=0.5u W=1u
M10253 o6 ibias vss vss sky130_fd_pr__nfet_01v8 L=0.5u W=1u
M10254 o6 ibias vss vss sky130_fd_pr__nfet_01v8 L=0.5u W=1u
M10255 o6 ibias vss vss sky130_fd_pr__nfet_01v8 L=0.5u W=1u
M10256 o6 ibias vss vss sky130_fd_pr__nfet_01v8 L=0.5u W=1u
M10257 o6 ibias vss vss sky130_fd_pr__nfet_01v8 L=0.5u W=1u
M10258 o6 ibias vss vss sky130_fd_pr__nfet_01v8 L=0.5u W=1u
M10259 o6 ibias vss vss sky130_fd_pr__nfet_01v8 L=0.5u W=1u
M10260 o6 ibias vss vss sky130_fd_pr__nfet_01v8 L=0.5u W=1u
M10261 o6 ibias vss vss sky130_fd_pr__nfet_01v8 L=0.5u W=1u
M10262 o6 ibias vss vss sky130_fd_pr__nfet_01v8 L=0.5u W=1u
M10263 o6 ibias vss vss sky130_fd_pr__nfet_01v8 L=0.5u W=1u
M10264 o6 ibias vss vss sky130_fd_pr__nfet_01v8 L=0.5u W=1u
M10265 o6 ibias vss vss sky130_fd_pr__nfet_01v8 L=0.5u W=1u
M10266 o6 ibias vss vss sky130_fd_pr__nfet_01v8 L=0.5u W=1u
M10267 o6 ibias vss vss sky130_fd_pr__nfet_01v8 L=0.5u W=1u
M10268 o6 ibias vss vss sky130_fd_pr__nfet_01v8 L=0.5u W=1u
M10269 o6 ibias vss vss sky130_fd_pr__nfet_01v8 L=0.5u W=1u
M10270 o6 ibias vss vss sky130_fd_pr__nfet_01v8 L=0.5u W=1u
M10271 o6 ibias vss vss sky130_fd_pr__nfet_01v8 L=0.5u W=1u
M10272 o6 ibias vss vss sky130_fd_pr__nfet_01v8 L=0.5u W=1u
M10273 o6 ibias vss vss sky130_fd_pr__nfet_01v8 L=0.5u W=1u
M10274 o6 ibias vss vss sky130_fd_pr__nfet_01v8 L=0.5u W=1u
M10275 o6 ibias vss vss sky130_fd_pr__nfet_01v8 L=0.5u W=1u
M10276 o6 ibias vss vss sky130_fd_pr__nfet_01v8 L=0.5u W=1u
M10277 o6 ibias vss vss sky130_fd_pr__nfet_01v8 L=0.5u W=1u
M10278 o6 ibias vss vss sky130_fd_pr__nfet_01v8 L=0.5u W=1u
M10279 o6 ibias vss vss sky130_fd_pr__nfet_01v8 L=0.5u W=1u
M10280 o6 ibias vss vss sky130_fd_pr__nfet_01v8 L=0.5u W=1u
M10281 o6 ibias vss vss sky130_fd_pr__nfet_01v8 L=0.5u W=1u
M10282 o6 ibias vss vss sky130_fd_pr__nfet_01v8 L=0.5u W=1u
M10283 o6 ibias vss vss sky130_fd_pr__nfet_01v8 L=0.5u W=1u
M10284 o6 ibias vss vss sky130_fd_pr__nfet_01v8 L=0.5u W=1u
M10285 o6 ibias vss vss sky130_fd_pr__nfet_01v8 L=0.5u W=1u
M10286 o6 ibias vss vss sky130_fd_pr__nfet_01v8 L=0.5u W=1u
M10287 o6 ibias vss vss sky130_fd_pr__nfet_01v8 L=0.5u W=1u
M10288 o7 ibias vss vss sky130_fd_pr__nfet_01v8 L=0.5u W=1u
M10289 o7 ibias vss vss sky130_fd_pr__nfet_01v8 L=0.5u W=1u
M10290 o7 ibias vss vss sky130_fd_pr__nfet_01v8 L=0.5u W=1u
M10291 o7 ibias vss vss sky130_fd_pr__nfet_01v8 L=0.5u W=1u
M10292 o7 ibias vss vss sky130_fd_pr__nfet_01v8 L=0.5u W=1u
M10293 o7 ibias vss vss sky130_fd_pr__nfet_01v8 L=0.5u W=1u
M10294 o7 ibias vss vss sky130_fd_pr__nfet_01v8 L=0.5u W=1u
M10295 o7 ibias vss vss sky130_fd_pr__nfet_01v8 L=0.5u W=1u
M10296 o7 ibias vss vss sky130_fd_pr__nfet_01v8 L=0.5u W=1u
M10297 o7 ibias vss vss sky130_fd_pr__nfet_01v8 L=0.5u W=1u
M10298 o7 ibias vss vss sky130_fd_pr__nfet_01v8 L=0.5u W=1u
M10299 o7 ibias vss vss sky130_fd_pr__nfet_01v8 L=0.5u W=1u
M10300 o7 ibias vss vss sky130_fd_pr__nfet_01v8 L=0.5u W=1u
M10301 o7 ibias vss vss sky130_fd_pr__nfet_01v8 L=0.5u W=1u
M10302 o7 ibias vss vss sky130_fd_pr__nfet_01v8 L=0.5u W=1u
M10303 o7 ibias vss vss sky130_fd_pr__nfet_01v8 L=0.5u W=1u
M10304 o7 ibias vss vss sky130_fd_pr__nfet_01v8 L=0.5u W=1u
M10305 o7 ibias vss vss sky130_fd_pr__nfet_01v8 L=0.5u W=1u
M10306 o7 ibias vss vss sky130_fd_pr__nfet_01v8 L=0.5u W=1u
M10307 o7 ibias vss vss sky130_fd_pr__nfet_01v8 L=0.5u W=1u
M10308 o7 ibias vss vss sky130_fd_pr__nfet_01v8 L=0.5u W=1u
M10309 o7 ibias vss vss sky130_fd_pr__nfet_01v8 L=0.5u W=1u
M10310 o7 ibias vss vss sky130_fd_pr__nfet_01v8 L=0.5u W=1u
M10311 o7 ibias vss vss sky130_fd_pr__nfet_01v8 L=0.5u W=1u
M10312 o7 ibias vss vss sky130_fd_pr__nfet_01v8 L=0.5u W=1u
M10313 o7 ibias vss vss sky130_fd_pr__nfet_01v8 L=0.5u W=1u
M10314 o7 ibias vss vss sky130_fd_pr__nfet_01v8 L=0.5u W=1u
M10315 o7 ibias vss vss sky130_fd_pr__nfet_01v8 L=0.5u W=1u
M10316 o7 ibias vss vss sky130_fd_pr__nfet_01v8 L=0.5u W=1u
M10317 o7 ibias vss vss sky130_fd_pr__nfet_01v8 L=0.5u W=1u
M10318 o7 ibias vss vss sky130_fd_pr__nfet_01v8 L=0.5u W=1u
M10319 o7 ibias vss vss sky130_fd_pr__nfet_01v8 L=0.5u W=1u
M10320 o7 ibias vss vss sky130_fd_pr__nfet_01v8 L=0.5u W=1u
M10321 o7 ibias vss vss sky130_fd_pr__nfet_01v8 L=0.5u W=1u
M10322 o7 ibias vss vss sky130_fd_pr__nfet_01v8 L=0.5u W=1u
M10323 o7 ibias vss vss sky130_fd_pr__nfet_01v8 L=0.5u W=1u
M10324 o7 ibias vss vss sky130_fd_pr__nfet_01v8 L=0.5u W=1u
M10325 o7 ibias vss vss sky130_fd_pr__nfet_01v8 L=0.5u W=1u
M10326 o7 ibias vss vss sky130_fd_pr__nfet_01v8 L=0.5u W=1u
M10327 o7 ibias vss vss sky130_fd_pr__nfet_01v8 L=0.5u W=1u
M10328 o7 ibias vss vss sky130_fd_pr__nfet_01v8 L=0.5u W=1u
M10329 o7 ibias vss vss sky130_fd_pr__nfet_01v8 L=0.5u W=1u
M10330 o7 ibias vss vss sky130_fd_pr__nfet_01v8 L=0.5u W=1u
M10331 o7 ibias vss vss sky130_fd_pr__nfet_01v8 L=0.5u W=1u
M10332 o7 ibias vss vss sky130_fd_pr__nfet_01v8 L=0.5u W=1u
M10333 o7 ibias vss vss sky130_fd_pr__nfet_01v8 L=0.5u W=1u
M10334 o7 ibias vss vss sky130_fd_pr__nfet_01v8 L=0.5u W=1u
M10335 o7 ibias vss vss sky130_fd_pr__nfet_01v8 L=0.5u W=1u
M10336 o7 ibias vss vss sky130_fd_pr__nfet_01v8 L=0.5u W=1u
M10337 o7 ibias vss vss sky130_fd_pr__nfet_01v8 L=0.5u W=1u
M10338 o7 ibias vss vss sky130_fd_pr__nfet_01v8 L=0.5u W=1u
M10339 o7 ibias vss vss sky130_fd_pr__nfet_01v8 L=0.5u W=1u
M10340 o7 ibias vss vss sky130_fd_pr__nfet_01v8 L=0.5u W=1u
M10341 o7 ibias vss vss sky130_fd_pr__nfet_01v8 L=0.5u W=1u
M10342 o7 ibias vss vss sky130_fd_pr__nfet_01v8 L=0.5u W=1u
M10343 o7 ibias vss vss sky130_fd_pr__nfet_01v8 L=0.5u W=1u
M10344 o7 ibias vss vss sky130_fd_pr__nfet_01v8 L=0.5u W=1u
M10345 o7 ibias vss vss sky130_fd_pr__nfet_01v8 L=0.5u W=1u
M10346 o7 ibias vss vss sky130_fd_pr__nfet_01v8 L=0.5u W=1u
M10347 o7 ibias vss vss sky130_fd_pr__nfet_01v8 L=0.5u W=1u
M10348 o7 ibias vss vss sky130_fd_pr__nfet_01v8 L=0.5u W=1u
M10349 o7 ibias vss vss sky130_fd_pr__nfet_01v8 L=0.5u W=1u
M10350 o7 ibias vss vss sky130_fd_pr__nfet_01v8 L=0.5u W=1u
M10351 o7 ibias vss vss sky130_fd_pr__nfet_01v8 L=0.5u W=1u
M10352 o7 ibias vss vss sky130_fd_pr__nfet_01v8 L=0.5u W=1u
M10353 o7 ibias vss vss sky130_fd_pr__nfet_01v8 L=0.5u W=1u
M10354 o7 ibias vss vss sky130_fd_pr__nfet_01v8 L=0.5u W=1u
M10355 o7 ibias vss vss sky130_fd_pr__nfet_01v8 L=0.5u W=1u
M10356 o7 ibias vss vss sky130_fd_pr__nfet_01v8 L=0.5u W=1u
M10357 o7 ibias vss vss sky130_fd_pr__nfet_01v8 L=0.5u W=1u
M10358 o7 ibias vss vss sky130_fd_pr__nfet_01v8 L=0.5u W=1u
M10359 o7 ibias vss vss sky130_fd_pr__nfet_01v8 L=0.5u W=1u
M10360 o7 ibias vss vss sky130_fd_pr__nfet_01v8 L=0.5u W=1u
M10361 o7 ibias vss vss sky130_fd_pr__nfet_01v8 L=0.5u W=1u
M10362 o7 ibias vss vss sky130_fd_pr__nfet_01v8 L=0.5u W=1u
M10363 o7 ibias vss vss sky130_fd_pr__nfet_01v8 L=0.5u W=1u
M10364 o7 ibias vss vss sky130_fd_pr__nfet_01v8 L=0.5u W=1u
M10365 o7 ibias vss vss sky130_fd_pr__nfet_01v8 L=0.5u W=1u
M10366 o7 ibias vss vss sky130_fd_pr__nfet_01v8 L=0.5u W=1u
M10367 o7 ibias vss vss sky130_fd_pr__nfet_01v8 L=0.5u W=1u
M10368 o7 ibias vss vss sky130_fd_pr__nfet_01v8 L=0.5u W=1u
M10369 o7 ibias vss vss sky130_fd_pr__nfet_01v8 L=0.5u W=1u
M10370 o7 ibias vss vss sky130_fd_pr__nfet_01v8 L=0.5u W=1u
M10371 o7 ibias vss vss sky130_fd_pr__nfet_01v8 L=0.5u W=1u
M10372 o7 ibias vss vss sky130_fd_pr__nfet_01v8 L=0.5u W=1u
M10373 o7 ibias vss vss sky130_fd_pr__nfet_01v8 L=0.5u W=1u
M10374 o7 ibias vss vss sky130_fd_pr__nfet_01v8 L=0.5u W=1u
M10375 o7 ibias vss vss sky130_fd_pr__nfet_01v8 L=0.5u W=1u
M10376 o7 ibias vss vss sky130_fd_pr__nfet_01v8 L=0.5u W=1u
M10377 o7 ibias vss vss sky130_fd_pr__nfet_01v8 L=0.5u W=1u
M10378 o7 ibias vss vss sky130_fd_pr__nfet_01v8 L=0.5u W=1u
M10379 o7 ibias vss vss sky130_fd_pr__nfet_01v8 L=0.5u W=1u
M10380 o7 ibias vss vss sky130_fd_pr__nfet_01v8 L=0.5u W=1u
M10381 o7 ibias vss vss sky130_fd_pr__nfet_01v8 L=0.5u W=1u
M10382 o7 ibias vss vss sky130_fd_pr__nfet_01v8 L=0.5u W=1u
M10383 o7 ibias vss vss sky130_fd_pr__nfet_01v8 L=0.5u W=1u
M10384 o7 ibias vss vss sky130_fd_pr__nfet_01v8 L=0.5u W=1u
M10385 o7 ibias vss vss sky130_fd_pr__nfet_01v8 L=0.5u W=1u
M10386 o7 ibias vss vss sky130_fd_pr__nfet_01v8 L=0.5u W=1u
M10387 o7 ibias vss vss sky130_fd_pr__nfet_01v8 L=0.5u W=1u
M10388 o7 ibias vss vss sky130_fd_pr__nfet_01v8 L=0.5u W=1u
M10389 o7 ibias vss vss sky130_fd_pr__nfet_01v8 L=0.5u W=1u
M10390 o7 ibias vss vss sky130_fd_pr__nfet_01v8 L=0.5u W=1u
M10391 o7 ibias vss vss sky130_fd_pr__nfet_01v8 L=0.5u W=1u
M10392 o7 ibias vss vss sky130_fd_pr__nfet_01v8 L=0.5u W=1u
M10393 o7 ibias vss vss sky130_fd_pr__nfet_01v8 L=0.5u W=1u
M10394 o7 ibias vss vss sky130_fd_pr__nfet_01v8 L=0.5u W=1u
M10395 o7 ibias vss vss sky130_fd_pr__nfet_01v8 L=0.5u W=1u
M10396 o7 ibias vss vss sky130_fd_pr__nfet_01v8 L=0.5u W=1u
M10397 o7 ibias vss vss sky130_fd_pr__nfet_01v8 L=0.5u W=1u
M10398 o7 ibias vss vss sky130_fd_pr__nfet_01v8 L=0.5u W=1u
M10399 o7 ibias vss vss sky130_fd_pr__nfet_01v8 L=0.5u W=1u
M10400 o7 ibias vss vss sky130_fd_pr__nfet_01v8 L=0.5u W=1u
M10401 o7 ibias vss vss sky130_fd_pr__nfet_01v8 L=0.5u W=1u
M10402 o7 ibias vss vss sky130_fd_pr__nfet_01v8 L=0.5u W=1u
M10403 o7 ibias vss vss sky130_fd_pr__nfet_01v8 L=0.5u W=1u
M10404 o7 ibias vss vss sky130_fd_pr__nfet_01v8 L=0.5u W=1u
M10405 o7 ibias vss vss sky130_fd_pr__nfet_01v8 L=0.5u W=1u
M10406 o7 ibias vss vss sky130_fd_pr__nfet_01v8 L=0.5u W=1u
M10407 o7 ibias vss vss sky130_fd_pr__nfet_01v8 L=0.5u W=1u
M10408 o7 ibias vss vss sky130_fd_pr__nfet_01v8 L=0.5u W=1u
M10409 o7 ibias vss vss sky130_fd_pr__nfet_01v8 L=0.5u W=1u
M10410 o7 ibias vss vss sky130_fd_pr__nfet_01v8 L=0.5u W=1u
M10411 o7 ibias vss vss sky130_fd_pr__nfet_01v8 L=0.5u W=1u
M10412 o7 ibias vss vss sky130_fd_pr__nfet_01v8 L=0.5u W=1u
M10413 o7 ibias vss vss sky130_fd_pr__nfet_01v8 L=0.5u W=1u
M10414 o7 ibias vss vss sky130_fd_pr__nfet_01v8 L=0.5u W=1u
M10415 o7 ibias vss vss sky130_fd_pr__nfet_01v8 L=0.5u W=1u
M10416 o7 ibias vss vss sky130_fd_pr__nfet_01v8 L=0.5u W=1u
M10417 o7 ibias vss vss sky130_fd_pr__nfet_01v8 L=0.5u W=1u
M10418 o7 ibias vss vss sky130_fd_pr__nfet_01v8 L=0.5u W=1u
M10419 o7 ibias vss vss sky130_fd_pr__nfet_01v8 L=0.5u W=1u
M10420 o7 ibias vss vss sky130_fd_pr__nfet_01v8 L=0.5u W=1u
M10421 o7 ibias vss vss sky130_fd_pr__nfet_01v8 L=0.5u W=1u
M10422 o7 ibias vss vss sky130_fd_pr__nfet_01v8 L=0.5u W=1u
M10423 o7 ibias vss vss sky130_fd_pr__nfet_01v8 L=0.5u W=1u
M10424 o7 ibias vss vss sky130_fd_pr__nfet_01v8 L=0.5u W=1u
M10425 o7 ibias vss vss sky130_fd_pr__nfet_01v8 L=0.5u W=1u
M10426 o7 ibias vss vss sky130_fd_pr__nfet_01v8 L=0.5u W=1u
M10427 o7 ibias vss vss sky130_fd_pr__nfet_01v8 L=0.5u W=1u
M10428 o7 ibias vss vss sky130_fd_pr__nfet_01v8 L=0.5u W=1u
M10429 o7 ibias vss vss sky130_fd_pr__nfet_01v8 L=0.5u W=1u
M10430 o7 ibias vss vss sky130_fd_pr__nfet_01v8 L=0.5u W=1u
M10431 o7 ibias vss vss sky130_fd_pr__nfet_01v8 L=0.5u W=1u
M10432 o7 ibias vss vss sky130_fd_pr__nfet_01v8 L=0.5u W=1u
M10433 o7 ibias vss vss sky130_fd_pr__nfet_01v8 L=0.5u W=1u
M10434 o7 ibias vss vss sky130_fd_pr__nfet_01v8 L=0.5u W=1u
M10435 o7 ibias vss vss sky130_fd_pr__nfet_01v8 L=0.5u W=1u
M10436 o7 ibias vss vss sky130_fd_pr__nfet_01v8 L=0.5u W=1u
M10437 o7 ibias vss vss sky130_fd_pr__nfet_01v8 L=0.5u W=1u
M10438 o7 ibias vss vss sky130_fd_pr__nfet_01v8 L=0.5u W=1u
M10439 o7 ibias vss vss sky130_fd_pr__nfet_01v8 L=0.5u W=1u
M10440 o7 ibias vss vss sky130_fd_pr__nfet_01v8 L=0.5u W=1u
M10441 o7 ibias vss vss sky130_fd_pr__nfet_01v8 L=0.5u W=1u
M10442 o7 ibias vss vss sky130_fd_pr__nfet_01v8 L=0.5u W=1u
M10443 o7 ibias vss vss sky130_fd_pr__nfet_01v8 L=0.5u W=1u
M10444 o7 ibias vss vss sky130_fd_pr__nfet_01v8 L=0.5u W=1u
M10445 o7 ibias vss vss sky130_fd_pr__nfet_01v8 L=0.5u W=1u
M10446 o7 ibias vss vss sky130_fd_pr__nfet_01v8 L=0.5u W=1u
M10447 o7 ibias vss vss sky130_fd_pr__nfet_01v8 L=0.5u W=1u
M10448 o7 ibias vss vss sky130_fd_pr__nfet_01v8 L=0.5u W=1u
M10449 o7 ibias vss vss sky130_fd_pr__nfet_01v8 L=0.5u W=1u
M10450 o7 ibias vss vss sky130_fd_pr__nfet_01v8 L=0.5u W=1u
M10451 o7 ibias vss vss sky130_fd_pr__nfet_01v8 L=0.5u W=1u
M10452 o7 ibias vss vss sky130_fd_pr__nfet_01v8 L=0.5u W=1u
M10453 o7 ibias vss vss sky130_fd_pr__nfet_01v8 L=0.5u W=1u
M10454 o7 ibias vss vss sky130_fd_pr__nfet_01v8 L=0.5u W=1u
M10455 o7 ibias vss vss sky130_fd_pr__nfet_01v8 L=0.5u W=1u
M10456 o7 ibias vss vss sky130_fd_pr__nfet_01v8 L=0.5u W=1u
M10457 o7 ibias vss vss sky130_fd_pr__nfet_01v8 L=0.5u W=1u
M10458 o7 ibias vss vss sky130_fd_pr__nfet_01v8 L=0.5u W=1u
M10459 o7 ibias vss vss sky130_fd_pr__nfet_01v8 L=0.5u W=1u
M10460 o7 ibias vss vss sky130_fd_pr__nfet_01v8 L=0.5u W=1u
M10461 o7 ibias vss vss sky130_fd_pr__nfet_01v8 L=0.5u W=1u
M10462 o7 ibias vss vss sky130_fd_pr__nfet_01v8 L=0.5u W=1u
M10463 o7 ibias vss vss sky130_fd_pr__nfet_01v8 L=0.5u W=1u
M10464 o7 ibias vss vss sky130_fd_pr__nfet_01v8 L=0.5u W=1u
M10465 o7 ibias vss vss sky130_fd_pr__nfet_01v8 L=0.5u W=1u
M10466 o7 ibias vss vss sky130_fd_pr__nfet_01v8 L=0.5u W=1u
M10467 o7 ibias vss vss sky130_fd_pr__nfet_01v8 L=0.5u W=1u
M10468 o7 ibias vss vss sky130_fd_pr__nfet_01v8 L=0.5u W=1u
M10469 o7 ibias vss vss sky130_fd_pr__nfet_01v8 L=0.5u W=1u
M10470 o7 ibias vss vss sky130_fd_pr__nfet_01v8 L=0.5u W=1u
M10471 o7 ibias vss vss sky130_fd_pr__nfet_01v8 L=0.5u W=1u
M10472 o7 ibias vss vss sky130_fd_pr__nfet_01v8 L=0.5u W=1u
M10473 o7 ibias vss vss sky130_fd_pr__nfet_01v8 L=0.5u W=1u
M10474 o7 ibias vss vss sky130_fd_pr__nfet_01v8 L=0.5u W=1u
M10475 o7 ibias vss vss sky130_fd_pr__nfet_01v8 L=0.5u W=1u
M10476 o7 ibias vss vss sky130_fd_pr__nfet_01v8 L=0.5u W=1u
M10477 o7 ibias vss vss sky130_fd_pr__nfet_01v8 L=0.5u W=1u
M10478 o7 ibias vss vss sky130_fd_pr__nfet_01v8 L=0.5u W=1u
M10479 o7 ibias vss vss sky130_fd_pr__nfet_01v8 L=0.5u W=1u
M10480 o7 ibias vss vss sky130_fd_pr__nfet_01v8 L=0.5u W=1u
M10481 o7 ibias vss vss sky130_fd_pr__nfet_01v8 L=0.5u W=1u
M10482 o7 ibias vss vss sky130_fd_pr__nfet_01v8 L=0.5u W=1u
M10483 o7 ibias vss vss sky130_fd_pr__nfet_01v8 L=0.5u W=1u
M10484 o7 ibias vss vss sky130_fd_pr__nfet_01v8 L=0.5u W=1u
M10485 o7 ibias vss vss sky130_fd_pr__nfet_01v8 L=0.5u W=1u
M10486 o7 ibias vss vss sky130_fd_pr__nfet_01v8 L=0.5u W=1u
M10487 o7 ibias vss vss sky130_fd_pr__nfet_01v8 L=0.5u W=1u
M10488 o7 ibias vss vss sky130_fd_pr__nfet_01v8 L=0.5u W=1u
M10489 o7 ibias vss vss sky130_fd_pr__nfet_01v8 L=0.5u W=1u
M10490 o7 ibias vss vss sky130_fd_pr__nfet_01v8 L=0.5u W=1u
M10491 o7 ibias vss vss sky130_fd_pr__nfet_01v8 L=0.5u W=1u
M10492 o7 ibias vss vss sky130_fd_pr__nfet_01v8 L=0.5u W=1u
M10493 o7 ibias vss vss sky130_fd_pr__nfet_01v8 L=0.5u W=1u
M10494 o7 ibias vss vss sky130_fd_pr__nfet_01v8 L=0.5u W=1u
M10495 o7 ibias vss vss sky130_fd_pr__nfet_01v8 L=0.5u W=1u
M10496 o7 ibias vss vss sky130_fd_pr__nfet_01v8 L=0.5u W=1u
M10497 o7 ibias vss vss sky130_fd_pr__nfet_01v8 L=0.5u W=1u
M10498 o7 ibias vss vss sky130_fd_pr__nfet_01v8 L=0.5u W=1u
M10499 o7 ibias vss vss sky130_fd_pr__nfet_01v8 L=0.5u W=1u
M10500 o7 ibias vss vss sky130_fd_pr__nfet_01v8 L=0.5u W=1u
M10501 o7 ibias vss vss sky130_fd_pr__nfet_01v8 L=0.5u W=1u
M10502 o7 ibias vss vss sky130_fd_pr__nfet_01v8 L=0.5u W=1u
M10503 o7 ibias vss vss sky130_fd_pr__nfet_01v8 L=0.5u W=1u
M10504 o7 ibias vss vss sky130_fd_pr__nfet_01v8 L=0.5u W=1u
M10505 o7 ibias vss vss sky130_fd_pr__nfet_01v8 L=0.5u W=1u
M10506 o7 ibias vss vss sky130_fd_pr__nfet_01v8 L=0.5u W=1u
M10507 o7 ibias vss vss sky130_fd_pr__nfet_01v8 L=0.5u W=1u
M10508 o7 ibias vss vss sky130_fd_pr__nfet_01v8 L=0.5u W=1u
M10509 o7 ibias vss vss sky130_fd_pr__nfet_01v8 L=0.5u W=1u
M10510 o7 ibias vss vss sky130_fd_pr__nfet_01v8 L=0.5u W=1u
M10511 o7 ibias vss vss sky130_fd_pr__nfet_01v8 L=0.5u W=1u
M10512 o7 ibias vss vss sky130_fd_pr__nfet_01v8 L=0.5u W=1u
M10513 o7 ibias vss vss sky130_fd_pr__nfet_01v8 L=0.5u W=1u
M10514 o7 ibias vss vss sky130_fd_pr__nfet_01v8 L=0.5u W=1u
M10515 o7 ibias vss vss sky130_fd_pr__nfet_01v8 L=0.5u W=1u
M10516 o7 ibias vss vss sky130_fd_pr__nfet_01v8 L=0.5u W=1u
M10517 o7 ibias vss vss sky130_fd_pr__nfet_01v8 L=0.5u W=1u
M10518 o7 ibias vss vss sky130_fd_pr__nfet_01v8 L=0.5u W=1u
M10519 o7 ibias vss vss sky130_fd_pr__nfet_01v8 L=0.5u W=1u
M10520 o7 ibias vss vss sky130_fd_pr__nfet_01v8 L=0.5u W=1u
M10521 o7 ibias vss vss sky130_fd_pr__nfet_01v8 L=0.5u W=1u
M10522 o7 ibias vss vss sky130_fd_pr__nfet_01v8 L=0.5u W=1u
M10523 o7 ibias vss vss sky130_fd_pr__nfet_01v8 L=0.5u W=1u
M10524 o7 ibias vss vss sky130_fd_pr__nfet_01v8 L=0.5u W=1u
M10525 o7 ibias vss vss sky130_fd_pr__nfet_01v8 L=0.5u W=1u
M10526 o7 ibias vss vss sky130_fd_pr__nfet_01v8 L=0.5u W=1u
M10527 o7 ibias vss vss sky130_fd_pr__nfet_01v8 L=0.5u W=1u
M10528 o7 ibias vss vss sky130_fd_pr__nfet_01v8 L=0.5u W=1u
M10529 o7 ibias vss vss sky130_fd_pr__nfet_01v8 L=0.5u W=1u
M10530 o7 ibias vss vss sky130_fd_pr__nfet_01v8 L=0.5u W=1u
M10531 o7 ibias vss vss sky130_fd_pr__nfet_01v8 L=0.5u W=1u
M10532 o7 ibias vss vss sky130_fd_pr__nfet_01v8 L=0.5u W=1u
M10533 o7 ibias vss vss sky130_fd_pr__nfet_01v8 L=0.5u W=1u
M10534 o7 ibias vss vss sky130_fd_pr__nfet_01v8 L=0.5u W=1u
M10535 o7 ibias vss vss sky130_fd_pr__nfet_01v8 L=0.5u W=1u
M10536 o7 ibias vss vss sky130_fd_pr__nfet_01v8 L=0.5u W=1u
M10537 o7 ibias vss vss sky130_fd_pr__nfet_01v8 L=0.5u W=1u
M10538 o7 ibias vss vss sky130_fd_pr__nfet_01v8 L=0.5u W=1u
M10539 o7 ibias vss vss sky130_fd_pr__nfet_01v8 L=0.5u W=1u
M10540 o7 ibias vss vss sky130_fd_pr__nfet_01v8 L=0.5u W=1u
M10541 o7 ibias vss vss sky130_fd_pr__nfet_01v8 L=0.5u W=1u
M10542 o7 ibias vss vss sky130_fd_pr__nfet_01v8 L=0.5u W=1u
M10543 o7 ibias vss vss sky130_fd_pr__nfet_01v8 L=0.5u W=1u
M10544 o7 ibias vss vss sky130_fd_pr__nfet_01v8 L=0.5u W=1u
M10545 o7 ibias vss vss sky130_fd_pr__nfet_01v8 L=0.5u W=1u
M10546 o7 ibias vss vss sky130_fd_pr__nfet_01v8 L=0.5u W=1u
M10547 o7 ibias vss vss sky130_fd_pr__nfet_01v8 L=0.5u W=1u
M10548 o7 ibias vss vss sky130_fd_pr__nfet_01v8 L=0.5u W=1u
M10549 o7 ibias vss vss sky130_fd_pr__nfet_01v8 L=0.5u W=1u
M10550 o7 ibias vss vss sky130_fd_pr__nfet_01v8 L=0.5u W=1u
M10551 o7 ibias vss vss sky130_fd_pr__nfet_01v8 L=0.5u W=1u
M10552 o7 ibias vss vss sky130_fd_pr__nfet_01v8 L=0.5u W=1u
M10553 o7 ibias vss vss sky130_fd_pr__nfet_01v8 L=0.5u W=1u
M10554 o7 ibias vss vss sky130_fd_pr__nfet_01v8 L=0.5u W=1u
M10555 o7 ibias vss vss sky130_fd_pr__nfet_01v8 L=0.5u W=1u
M10556 o7 ibias vss vss sky130_fd_pr__nfet_01v8 L=0.5u W=1u
M10557 o7 ibias vss vss sky130_fd_pr__nfet_01v8 L=0.5u W=1u
M10558 o7 ibias vss vss sky130_fd_pr__nfet_01v8 L=0.5u W=1u
M10559 o7 ibias vss vss sky130_fd_pr__nfet_01v8 L=0.5u W=1u
M10560 o7 ibias vss vss sky130_fd_pr__nfet_01v8 L=0.5u W=1u
M10561 o7 ibias vss vss sky130_fd_pr__nfet_01v8 L=0.5u W=1u
M10562 o7 ibias vss vss sky130_fd_pr__nfet_01v8 L=0.5u W=1u
M10563 o7 ibias vss vss sky130_fd_pr__nfet_01v8 L=0.5u W=1u
M10564 o7 ibias vss vss sky130_fd_pr__nfet_01v8 L=0.5u W=1u
M10565 o7 ibias vss vss sky130_fd_pr__nfet_01v8 L=0.5u W=1u
M10566 o7 ibias vss vss sky130_fd_pr__nfet_01v8 L=0.5u W=1u
M10567 o7 ibias vss vss sky130_fd_pr__nfet_01v8 L=0.5u W=1u
M10568 o7 ibias vss vss sky130_fd_pr__nfet_01v8 L=0.5u W=1u
M10569 o7 ibias vss vss sky130_fd_pr__nfet_01v8 L=0.5u W=1u
M10570 o7 ibias vss vss sky130_fd_pr__nfet_01v8 L=0.5u W=1u
M10571 o7 ibias vss vss sky130_fd_pr__nfet_01v8 L=0.5u W=1u
M10572 o7 ibias vss vss sky130_fd_pr__nfet_01v8 L=0.5u W=1u
M10573 o7 ibias vss vss sky130_fd_pr__nfet_01v8 L=0.5u W=1u
M10574 o7 ibias vss vss sky130_fd_pr__nfet_01v8 L=0.5u W=1u
M10575 o7 ibias vss vss sky130_fd_pr__nfet_01v8 L=0.5u W=1u
M10576 o7 ibias vss vss sky130_fd_pr__nfet_01v8 L=0.5u W=1u
M10577 o7 ibias vss vss sky130_fd_pr__nfet_01v8 L=0.5u W=1u
M10578 o7 ibias vss vss sky130_fd_pr__nfet_01v8 L=0.5u W=1u
M10579 o7 ibias vss vss sky130_fd_pr__nfet_01v8 L=0.5u W=1u
M10580 o7 ibias vss vss sky130_fd_pr__nfet_01v8 L=0.5u W=1u
M10581 o7 ibias vss vss sky130_fd_pr__nfet_01v8 L=0.5u W=1u
M10582 o7 ibias vss vss sky130_fd_pr__nfet_01v8 L=0.5u W=1u
M10583 o7 ibias vss vss sky130_fd_pr__nfet_01v8 L=0.5u W=1u
M10584 o7 ibias vss vss sky130_fd_pr__nfet_01v8 L=0.5u W=1u
M10585 o7 ibias vss vss sky130_fd_pr__nfet_01v8 L=0.5u W=1u
M10586 o7 ibias vss vss sky130_fd_pr__nfet_01v8 L=0.5u W=1u
M10587 o7 ibias vss vss sky130_fd_pr__nfet_01v8 L=0.5u W=1u
M10588 o7 ibias vss vss sky130_fd_pr__nfet_01v8 L=0.5u W=1u
M10589 o7 ibias vss vss sky130_fd_pr__nfet_01v8 L=0.5u W=1u
M10590 o7 ibias vss vss sky130_fd_pr__nfet_01v8 L=0.5u W=1u
M10591 o7 ibias vss vss sky130_fd_pr__nfet_01v8 L=0.5u W=1u
M10592 o7 ibias vss vss sky130_fd_pr__nfet_01v8 L=0.5u W=1u
M10593 o7 ibias vss vss sky130_fd_pr__nfet_01v8 L=0.5u W=1u
M10594 o7 ibias vss vss sky130_fd_pr__nfet_01v8 L=0.5u W=1u
M10595 o7 ibias vss vss sky130_fd_pr__nfet_01v8 L=0.5u W=1u
M10596 o7 ibias vss vss sky130_fd_pr__nfet_01v8 L=0.5u W=1u
M10597 o7 ibias vss vss sky130_fd_pr__nfet_01v8 L=0.5u W=1u
M10598 o7 ibias vss vss sky130_fd_pr__nfet_01v8 L=0.5u W=1u
M10599 o7 ibias vss vss sky130_fd_pr__nfet_01v8 L=0.5u W=1u
M10600 o7 ibias vss vss sky130_fd_pr__nfet_01v8 L=0.5u W=1u
M10601 o7 ibias vss vss sky130_fd_pr__nfet_01v8 L=0.5u W=1u
M10602 o7 ibias vss vss sky130_fd_pr__nfet_01v8 L=0.5u W=1u
M10603 o7 ibias vss vss sky130_fd_pr__nfet_01v8 L=0.5u W=1u
M10604 o7 ibias vss vss sky130_fd_pr__nfet_01v8 L=0.5u W=1u
M10605 o7 ibias vss vss sky130_fd_pr__nfet_01v8 L=0.5u W=1u
M10606 o7 ibias vss vss sky130_fd_pr__nfet_01v8 L=0.5u W=1u
M10607 o7 ibias vss vss sky130_fd_pr__nfet_01v8 L=0.5u W=1u
M10608 o7 ibias vss vss sky130_fd_pr__nfet_01v8 L=0.5u W=1u
M10609 o7 ibias vss vss sky130_fd_pr__nfet_01v8 L=0.5u W=1u
M10610 o7 ibias vss vss sky130_fd_pr__nfet_01v8 L=0.5u W=1u
M10611 o7 ibias vss vss sky130_fd_pr__nfet_01v8 L=0.5u W=1u
M10612 o7 ibias vss vss sky130_fd_pr__nfet_01v8 L=0.5u W=1u
M10613 o7 ibias vss vss sky130_fd_pr__nfet_01v8 L=0.5u W=1u
M10614 o7 ibias vss vss sky130_fd_pr__nfet_01v8 L=0.5u W=1u
M10615 o7 ibias vss vss sky130_fd_pr__nfet_01v8 L=0.5u W=1u
M10616 o7 ibias vss vss sky130_fd_pr__nfet_01v8 L=0.5u W=1u
M10617 o7 ibias vss vss sky130_fd_pr__nfet_01v8 L=0.5u W=1u
M10618 o7 ibias vss vss sky130_fd_pr__nfet_01v8 L=0.5u W=1u
M10619 o7 ibias vss vss sky130_fd_pr__nfet_01v8 L=0.5u W=1u
M10620 o7 ibias vss vss sky130_fd_pr__nfet_01v8 L=0.5u W=1u
M10621 o7 ibias vss vss sky130_fd_pr__nfet_01v8 L=0.5u W=1u
M10622 o7 ibias vss vss sky130_fd_pr__nfet_01v8 L=0.5u W=1u
M10623 o7 ibias vss vss sky130_fd_pr__nfet_01v8 L=0.5u W=1u
M10624 o7 ibias vss vss sky130_fd_pr__nfet_01v8 L=0.5u W=1u
M10625 o7 ibias vss vss sky130_fd_pr__nfet_01v8 L=0.5u W=1u
M10626 o7 ibias vss vss sky130_fd_pr__nfet_01v8 L=0.5u W=1u
M10627 o7 ibias vss vss sky130_fd_pr__nfet_01v8 L=0.5u W=1u
M10628 o7 ibias vss vss sky130_fd_pr__nfet_01v8 L=0.5u W=1u
M10629 o7 ibias vss vss sky130_fd_pr__nfet_01v8 L=0.5u W=1u
M10630 o7 ibias vss vss sky130_fd_pr__nfet_01v8 L=0.5u W=1u
M10631 o7 ibias vss vss sky130_fd_pr__nfet_01v8 L=0.5u W=1u
M10632 o7 ibias vss vss sky130_fd_pr__nfet_01v8 L=0.5u W=1u
M10633 o7 ibias vss vss sky130_fd_pr__nfet_01v8 L=0.5u W=1u
M10634 o7 ibias vss vss sky130_fd_pr__nfet_01v8 L=0.5u W=1u
M10635 o7 ibias vss vss sky130_fd_pr__nfet_01v8 L=0.5u W=1u
M10636 o7 ibias vss vss sky130_fd_pr__nfet_01v8 L=0.5u W=1u
M10637 o7 ibias vss vss sky130_fd_pr__nfet_01v8 L=0.5u W=1u
M10638 o7 ibias vss vss sky130_fd_pr__nfet_01v8 L=0.5u W=1u
M10639 o7 ibias vss vss sky130_fd_pr__nfet_01v8 L=0.5u W=1u
M10640 o7 ibias vss vss sky130_fd_pr__nfet_01v8 L=0.5u W=1u
M10641 o7 ibias vss vss sky130_fd_pr__nfet_01v8 L=0.5u W=1u
M10642 o7 ibias vss vss sky130_fd_pr__nfet_01v8 L=0.5u W=1u
M10643 o7 ibias vss vss sky130_fd_pr__nfet_01v8 L=0.5u W=1u
M10644 o7 ibias vss vss sky130_fd_pr__nfet_01v8 L=0.5u W=1u
M10645 o7 ibias vss vss sky130_fd_pr__nfet_01v8 L=0.5u W=1u
M10646 o7 ibias vss vss sky130_fd_pr__nfet_01v8 L=0.5u W=1u
M10647 o7 ibias vss vss sky130_fd_pr__nfet_01v8 L=0.5u W=1u
M10648 o7 ibias vss vss sky130_fd_pr__nfet_01v8 L=0.5u W=1u
M10649 o7 ibias vss vss sky130_fd_pr__nfet_01v8 L=0.5u W=1u
M10650 o7 ibias vss vss sky130_fd_pr__nfet_01v8 L=0.5u W=1u
M10651 o7 ibias vss vss sky130_fd_pr__nfet_01v8 L=0.5u W=1u
M10652 o7 ibias vss vss sky130_fd_pr__nfet_01v8 L=0.5u W=1u
M10653 o7 ibias vss vss sky130_fd_pr__nfet_01v8 L=0.5u W=1u
M10654 o7 ibias vss vss sky130_fd_pr__nfet_01v8 L=0.5u W=1u
M10655 o7 ibias vss vss sky130_fd_pr__nfet_01v8 L=0.5u W=1u
M10656 o7 ibias vss vss sky130_fd_pr__nfet_01v8 L=0.5u W=1u
M10657 o7 ibias vss vss sky130_fd_pr__nfet_01v8 L=0.5u W=1u
M10658 o7 ibias vss vss sky130_fd_pr__nfet_01v8 L=0.5u W=1u
M10659 o7 ibias vss vss sky130_fd_pr__nfet_01v8 L=0.5u W=1u
M10660 o7 ibias vss vss sky130_fd_pr__nfet_01v8 L=0.5u W=1u
M10661 o7 ibias vss vss sky130_fd_pr__nfet_01v8 L=0.5u W=1u
M10662 o7 ibias vss vss sky130_fd_pr__nfet_01v8 L=0.5u W=1u
M10663 o7 ibias vss vss sky130_fd_pr__nfet_01v8 L=0.5u W=1u
M10664 o7 ibias vss vss sky130_fd_pr__nfet_01v8 L=0.5u W=1u
M10665 o7 ibias vss vss sky130_fd_pr__nfet_01v8 L=0.5u W=1u
M10666 o7 ibias vss vss sky130_fd_pr__nfet_01v8 L=0.5u W=1u
M10667 o7 ibias vss vss sky130_fd_pr__nfet_01v8 L=0.5u W=1u
M10668 o7 ibias vss vss sky130_fd_pr__nfet_01v8 L=0.5u W=1u
M10669 o7 ibias vss vss sky130_fd_pr__nfet_01v8 L=0.5u W=1u
M10670 o7 ibias vss vss sky130_fd_pr__nfet_01v8 L=0.5u W=1u
M10671 o7 ibias vss vss sky130_fd_pr__nfet_01v8 L=0.5u W=1u
M10672 o7 ibias vss vss sky130_fd_pr__nfet_01v8 L=0.5u W=1u
M10673 o7 ibias vss vss sky130_fd_pr__nfet_01v8 L=0.5u W=1u
M10674 o7 ibias vss vss sky130_fd_pr__nfet_01v8 L=0.5u W=1u
M10675 o7 ibias vss vss sky130_fd_pr__nfet_01v8 L=0.5u W=1u
M10676 o7 ibias vss vss sky130_fd_pr__nfet_01v8 L=0.5u W=1u
M10677 o7 ibias vss vss sky130_fd_pr__nfet_01v8 L=0.5u W=1u
M10678 o7 ibias vss vss sky130_fd_pr__nfet_01v8 L=0.5u W=1u
M10679 o7 ibias vss vss sky130_fd_pr__nfet_01v8 L=0.5u W=1u
M10680 o7 ibias vss vss sky130_fd_pr__nfet_01v8 L=0.5u W=1u
M10681 o7 ibias vss vss sky130_fd_pr__nfet_01v8 L=0.5u W=1u
M10682 o7 ibias vss vss sky130_fd_pr__nfet_01v8 L=0.5u W=1u
M10683 o7 ibias vss vss sky130_fd_pr__nfet_01v8 L=0.5u W=1u
M10684 o7 ibias vss vss sky130_fd_pr__nfet_01v8 L=0.5u W=1u
M10685 o7 ibias vss vss sky130_fd_pr__nfet_01v8 L=0.5u W=1u
M10686 o7 ibias vss vss sky130_fd_pr__nfet_01v8 L=0.5u W=1u
M10687 o7 ibias vss vss sky130_fd_pr__nfet_01v8 L=0.5u W=1u
M10688 o7 ibias vss vss sky130_fd_pr__nfet_01v8 L=0.5u W=1u
M10689 o7 ibias vss vss sky130_fd_pr__nfet_01v8 L=0.5u W=1u
M10690 o7 ibias vss vss sky130_fd_pr__nfet_01v8 L=0.5u W=1u
M10691 o7 ibias vss vss sky130_fd_pr__nfet_01v8 L=0.5u W=1u
M10692 o7 ibias vss vss sky130_fd_pr__nfet_01v8 L=0.5u W=1u
M10693 o7 ibias vss vss sky130_fd_pr__nfet_01v8 L=0.5u W=1u
M10694 o7 ibias vss vss sky130_fd_pr__nfet_01v8 L=0.5u W=1u
M10695 o7 ibias vss vss sky130_fd_pr__nfet_01v8 L=0.5u W=1u
M10696 o7 ibias vss vss sky130_fd_pr__nfet_01v8 L=0.5u W=1u
M10697 o7 ibias vss vss sky130_fd_pr__nfet_01v8 L=0.5u W=1u
M10698 o7 ibias vss vss sky130_fd_pr__nfet_01v8 L=0.5u W=1u
M10699 o7 ibias vss vss sky130_fd_pr__nfet_01v8 L=0.5u W=1u
M10700 o7 ibias vss vss sky130_fd_pr__nfet_01v8 L=0.5u W=1u
M10701 o7 ibias vss vss sky130_fd_pr__nfet_01v8 L=0.5u W=1u
M10702 o7 ibias vss vss sky130_fd_pr__nfet_01v8 L=0.5u W=1u
M10703 o7 ibias vss vss sky130_fd_pr__nfet_01v8 L=0.5u W=1u
M10704 o7 ibias vss vss sky130_fd_pr__nfet_01v8 L=0.5u W=1u
M10705 o7 ibias vss vss sky130_fd_pr__nfet_01v8 L=0.5u W=1u
M10706 o7 ibias vss vss sky130_fd_pr__nfet_01v8 L=0.5u W=1u
M10707 o7 ibias vss vss sky130_fd_pr__nfet_01v8 L=0.5u W=1u
M10708 o7 ibias vss vss sky130_fd_pr__nfet_01v8 L=0.5u W=1u
M10709 o7 ibias vss vss sky130_fd_pr__nfet_01v8 L=0.5u W=1u
M10710 o7 ibias vss vss sky130_fd_pr__nfet_01v8 L=0.5u W=1u
M10711 o7 ibias vss vss sky130_fd_pr__nfet_01v8 L=0.5u W=1u
M10712 o7 ibias vss vss sky130_fd_pr__nfet_01v8 L=0.5u W=1u
M10713 o7 ibias vss vss sky130_fd_pr__nfet_01v8 L=0.5u W=1u
M10714 o7 ibias vss vss sky130_fd_pr__nfet_01v8 L=0.5u W=1u
M10715 o7 ibias vss vss sky130_fd_pr__nfet_01v8 L=0.5u W=1u
M10716 o7 ibias vss vss sky130_fd_pr__nfet_01v8 L=0.5u W=1u
M10717 o7 ibias vss vss sky130_fd_pr__nfet_01v8 L=0.5u W=1u
M10718 o7 ibias vss vss sky130_fd_pr__nfet_01v8 L=0.5u W=1u
M10719 o7 ibias vss vss sky130_fd_pr__nfet_01v8 L=0.5u W=1u
M10720 o7 ibias vss vss sky130_fd_pr__nfet_01v8 L=0.5u W=1u
M10721 o7 ibias vss vss sky130_fd_pr__nfet_01v8 L=0.5u W=1u
M10722 o7 ibias vss vss sky130_fd_pr__nfet_01v8 L=0.5u W=1u
M10723 o7 ibias vss vss sky130_fd_pr__nfet_01v8 L=0.5u W=1u
M10724 o7 ibias vss vss sky130_fd_pr__nfet_01v8 L=0.5u W=1u
M10725 o7 ibias vss vss sky130_fd_pr__nfet_01v8 L=0.5u W=1u
M10726 o7 ibias vss vss sky130_fd_pr__nfet_01v8 L=0.5u W=1u
M10727 o7 ibias vss vss sky130_fd_pr__nfet_01v8 L=0.5u W=1u
M10728 o7 ibias vss vss sky130_fd_pr__nfet_01v8 L=0.5u W=1u
M10729 o7 ibias vss vss sky130_fd_pr__nfet_01v8 L=0.5u W=1u
M10730 o7 ibias vss vss sky130_fd_pr__nfet_01v8 L=0.5u W=1u
M10731 o7 ibias vss vss sky130_fd_pr__nfet_01v8 L=0.5u W=1u
M10732 o7 ibias vss vss sky130_fd_pr__nfet_01v8 L=0.5u W=1u
M10733 o7 ibias vss vss sky130_fd_pr__nfet_01v8 L=0.5u W=1u
M10734 o7 ibias vss vss sky130_fd_pr__nfet_01v8 L=0.5u W=1u
M10735 o7 ibias vss vss sky130_fd_pr__nfet_01v8 L=0.5u W=1u
M10736 o7 ibias vss vss sky130_fd_pr__nfet_01v8 L=0.5u W=1u
M10737 o7 ibias vss vss sky130_fd_pr__nfet_01v8 L=0.5u W=1u
M10738 o7 ibias vss vss sky130_fd_pr__nfet_01v8 L=0.5u W=1u
M10739 o7 ibias vss vss sky130_fd_pr__nfet_01v8 L=0.5u W=1u
M10740 o7 ibias vss vss sky130_fd_pr__nfet_01v8 L=0.5u W=1u
M10741 o7 ibias vss vss sky130_fd_pr__nfet_01v8 L=0.5u W=1u
M10742 o7 ibias vss vss sky130_fd_pr__nfet_01v8 L=0.5u W=1u
M10743 o7 ibias vss vss sky130_fd_pr__nfet_01v8 L=0.5u W=1u
M10744 o7 ibias vss vss sky130_fd_pr__nfet_01v8 L=0.5u W=1u
M10745 o7 ibias vss vss sky130_fd_pr__nfet_01v8 L=0.5u W=1u
M10746 o7 ibias vss vss sky130_fd_pr__nfet_01v8 L=0.5u W=1u
M10747 o7 ibias vss vss sky130_fd_pr__nfet_01v8 L=0.5u W=1u
M10748 o7 ibias vss vss sky130_fd_pr__nfet_01v8 L=0.5u W=1u
M10749 o7 ibias vss vss sky130_fd_pr__nfet_01v8 L=0.5u W=1u
M10750 o7 ibias vss vss sky130_fd_pr__nfet_01v8 L=0.5u W=1u
M10751 o7 ibias vss vss sky130_fd_pr__nfet_01v8 L=0.5u W=1u
M10752 o7 ibias vss vss sky130_fd_pr__nfet_01v8 L=0.5u W=1u
M10753 o7 ibias vss vss sky130_fd_pr__nfet_01v8 L=0.5u W=1u
M10754 o7 ibias vss vss sky130_fd_pr__nfet_01v8 L=0.5u W=1u
M10755 o7 ibias vss vss sky130_fd_pr__nfet_01v8 L=0.5u W=1u
M10756 o7 ibias vss vss sky130_fd_pr__nfet_01v8 L=0.5u W=1u
M10757 o7 ibias vss vss sky130_fd_pr__nfet_01v8 L=0.5u W=1u
M10758 o7 ibias vss vss sky130_fd_pr__nfet_01v8 L=0.5u W=1u
M10759 o7 ibias vss vss sky130_fd_pr__nfet_01v8 L=0.5u W=1u
M10760 o7 ibias vss vss sky130_fd_pr__nfet_01v8 L=0.5u W=1u
M10761 o7 ibias vss vss sky130_fd_pr__nfet_01v8 L=0.5u W=1u
M10762 o7 ibias vss vss sky130_fd_pr__nfet_01v8 L=0.5u W=1u
M10763 o7 ibias vss vss sky130_fd_pr__nfet_01v8 L=0.5u W=1u
M10764 o7 ibias vss vss sky130_fd_pr__nfet_01v8 L=0.5u W=1u
M10765 o7 ibias vss vss sky130_fd_pr__nfet_01v8 L=0.5u W=1u
M10766 o7 ibias vss vss sky130_fd_pr__nfet_01v8 L=0.5u W=1u
M10767 o7 ibias vss vss sky130_fd_pr__nfet_01v8 L=0.5u W=1u
M10768 o7 ibias vss vss sky130_fd_pr__nfet_01v8 L=0.5u W=1u
M10769 o7 ibias vss vss sky130_fd_pr__nfet_01v8 L=0.5u W=1u
M10770 o7 ibias vss vss sky130_fd_pr__nfet_01v8 L=0.5u W=1u
M10771 o7 ibias vss vss sky130_fd_pr__nfet_01v8 L=0.5u W=1u
M10772 o7 ibias vss vss sky130_fd_pr__nfet_01v8 L=0.5u W=1u
M10773 o7 ibias vss vss sky130_fd_pr__nfet_01v8 L=0.5u W=1u
M10774 o7 ibias vss vss sky130_fd_pr__nfet_01v8 L=0.5u W=1u
M10775 o7 ibias vss vss sky130_fd_pr__nfet_01v8 L=0.5u W=1u
M10776 o7 ibias vss vss sky130_fd_pr__nfet_01v8 L=0.5u W=1u
M10777 o7 ibias vss vss sky130_fd_pr__nfet_01v8 L=0.5u W=1u
M10778 o7 ibias vss vss sky130_fd_pr__nfet_01v8 L=0.5u W=1u
M10779 o7 ibias vss vss sky130_fd_pr__nfet_01v8 L=0.5u W=1u
M10780 o7 ibias vss vss sky130_fd_pr__nfet_01v8 L=0.5u W=1u
M10781 o7 ibias vss vss sky130_fd_pr__nfet_01v8 L=0.5u W=1u
M10782 o7 ibias vss vss sky130_fd_pr__nfet_01v8 L=0.5u W=1u
M10783 o7 ibias vss vss sky130_fd_pr__nfet_01v8 L=0.5u W=1u
M10784 o7 ibias vss vss sky130_fd_pr__nfet_01v8 L=0.5u W=1u
M10785 o7 ibias vss vss sky130_fd_pr__nfet_01v8 L=0.5u W=1u
M10786 o7 ibias vss vss sky130_fd_pr__nfet_01v8 L=0.5u W=1u
M10787 o7 ibias vss vss sky130_fd_pr__nfet_01v8 L=0.5u W=1u
M10788 o7 ibias vss vss sky130_fd_pr__nfet_01v8 L=0.5u W=1u
M10789 o7 ibias vss vss sky130_fd_pr__nfet_01v8 L=0.5u W=1u
M10790 o7 ibias vss vss sky130_fd_pr__nfet_01v8 L=0.5u W=1u
M10791 o7 ibias vss vss sky130_fd_pr__nfet_01v8 L=0.5u W=1u
M10792 o7 ibias vss vss sky130_fd_pr__nfet_01v8 L=0.5u W=1u
M10793 o7 ibias vss vss sky130_fd_pr__nfet_01v8 L=0.5u W=1u
M10794 o7 ibias vss vss sky130_fd_pr__nfet_01v8 L=0.5u W=1u
M10795 o7 ibias vss vss sky130_fd_pr__nfet_01v8 L=0.5u W=1u
M10796 o7 ibias vss vss sky130_fd_pr__nfet_01v8 L=0.5u W=1u
M10797 o7 ibias vss vss sky130_fd_pr__nfet_01v8 L=0.5u W=1u
M10798 o7 ibias vss vss sky130_fd_pr__nfet_01v8 L=0.5u W=1u
M10799 o7 ibias vss vss sky130_fd_pr__nfet_01v8 L=0.5u W=1u
M10800 o7 ibias vss vss sky130_fd_pr__nfet_01v8 L=0.5u W=1u
M10801 o7 ibias vss vss sky130_fd_pr__nfet_01v8 L=0.5u W=1u
M10802 o7 ibias vss vss sky130_fd_pr__nfet_01v8 L=0.5u W=1u
M10803 o7 ibias vss vss sky130_fd_pr__nfet_01v8 L=0.5u W=1u
M10804 o7 ibias vss vss sky130_fd_pr__nfet_01v8 L=0.5u W=1u
M10805 o7 ibias vss vss sky130_fd_pr__nfet_01v8 L=0.5u W=1u
M10806 o7 ibias vss vss sky130_fd_pr__nfet_01v8 L=0.5u W=1u
M10807 o7 ibias vss vss sky130_fd_pr__nfet_01v8 L=0.5u W=1u
M10808 o7 ibias vss vss sky130_fd_pr__nfet_01v8 L=0.5u W=1u
M10809 o7 ibias vss vss sky130_fd_pr__nfet_01v8 L=0.5u W=1u
M10810 o7 ibias vss vss sky130_fd_pr__nfet_01v8 L=0.5u W=1u
M10811 o7 ibias vss vss sky130_fd_pr__nfet_01v8 L=0.5u W=1u
M10812 o7 ibias vss vss sky130_fd_pr__nfet_01v8 L=0.5u W=1u
M10813 o7 ibias vss vss sky130_fd_pr__nfet_01v8 L=0.5u W=1u
M10814 o7 ibias vss vss sky130_fd_pr__nfet_01v8 L=0.5u W=1u
M10815 o7 ibias vss vss sky130_fd_pr__nfet_01v8 L=0.5u W=1u
M10816 o7 ibias vss vss sky130_fd_pr__nfet_01v8 L=0.5u W=1u
M10817 o7 ibias vss vss sky130_fd_pr__nfet_01v8 L=0.5u W=1u
M10818 o7 ibias vss vss sky130_fd_pr__nfet_01v8 L=0.5u W=1u
M10819 o7 ibias vss vss sky130_fd_pr__nfet_01v8 L=0.5u W=1u
M10820 o7 ibias vss vss sky130_fd_pr__nfet_01v8 L=0.5u W=1u
M10821 o7 ibias vss vss sky130_fd_pr__nfet_01v8 L=0.5u W=1u
M10822 o7 ibias vss vss sky130_fd_pr__nfet_01v8 L=0.5u W=1u
M10823 o7 ibias vss vss sky130_fd_pr__nfet_01v8 L=0.5u W=1u
M10824 o7 ibias vss vss sky130_fd_pr__nfet_01v8 L=0.5u W=1u
M10825 o7 ibias vss vss sky130_fd_pr__nfet_01v8 L=0.5u W=1u
M10826 o7 ibias vss vss sky130_fd_pr__nfet_01v8 L=0.5u W=1u
M10827 o7 ibias vss vss sky130_fd_pr__nfet_01v8 L=0.5u W=1u
M10828 o7 ibias vss vss sky130_fd_pr__nfet_01v8 L=0.5u W=1u
M10829 o7 ibias vss vss sky130_fd_pr__nfet_01v8 L=0.5u W=1u
M10830 o7 ibias vss vss sky130_fd_pr__nfet_01v8 L=0.5u W=1u
M10831 o7 ibias vss vss sky130_fd_pr__nfet_01v8 L=0.5u W=1u
M10832 o7 ibias vss vss sky130_fd_pr__nfet_01v8 L=0.5u W=1u
M10833 o7 ibias vss vss sky130_fd_pr__nfet_01v8 L=0.5u W=1u
M10834 o7 ibias vss vss sky130_fd_pr__nfet_01v8 L=0.5u W=1u
M10835 o7 ibias vss vss sky130_fd_pr__nfet_01v8 L=0.5u W=1u
M10836 o7 ibias vss vss sky130_fd_pr__nfet_01v8 L=0.5u W=1u
M10837 o7 ibias vss vss sky130_fd_pr__nfet_01v8 L=0.5u W=1u
M10838 o7 ibias vss vss sky130_fd_pr__nfet_01v8 L=0.5u W=1u
M10839 o7 ibias vss vss sky130_fd_pr__nfet_01v8 L=0.5u W=1u
M10840 o7 ibias vss vss sky130_fd_pr__nfet_01v8 L=0.5u W=1u
M10841 o7 ibias vss vss sky130_fd_pr__nfet_01v8 L=0.5u W=1u
M10842 o7 ibias vss vss sky130_fd_pr__nfet_01v8 L=0.5u W=1u
M10843 o7 ibias vss vss sky130_fd_pr__nfet_01v8 L=0.5u W=1u
M10844 o7 ibias vss vss sky130_fd_pr__nfet_01v8 L=0.5u W=1u
M10845 o7 ibias vss vss sky130_fd_pr__nfet_01v8 L=0.5u W=1u
M10846 o7 ibias vss vss sky130_fd_pr__nfet_01v8 L=0.5u W=1u
M10847 o7 ibias vss vss sky130_fd_pr__nfet_01v8 L=0.5u W=1u
M10848 o7 ibias vss vss sky130_fd_pr__nfet_01v8 L=0.5u W=1u
M10849 o7 ibias vss vss sky130_fd_pr__nfet_01v8 L=0.5u W=1u
M10850 o7 ibias vss vss sky130_fd_pr__nfet_01v8 L=0.5u W=1u
M10851 o7 ibias vss vss sky130_fd_pr__nfet_01v8 L=0.5u W=1u
M10852 o7 ibias vss vss sky130_fd_pr__nfet_01v8 L=0.5u W=1u
M10853 o7 ibias vss vss sky130_fd_pr__nfet_01v8 L=0.5u W=1u
M10854 o7 ibias vss vss sky130_fd_pr__nfet_01v8 L=0.5u W=1u
M10855 o7 ibias vss vss sky130_fd_pr__nfet_01v8 L=0.5u W=1u
M10856 o7 ibias vss vss sky130_fd_pr__nfet_01v8 L=0.5u W=1u
M10857 o7 ibias vss vss sky130_fd_pr__nfet_01v8 L=0.5u W=1u
M10858 o7 ibias vss vss sky130_fd_pr__nfet_01v8 L=0.5u W=1u
M10859 o7 ibias vss vss sky130_fd_pr__nfet_01v8 L=0.5u W=1u
M10860 o7 ibias vss vss sky130_fd_pr__nfet_01v8 L=0.5u W=1u
M10861 o7 ibias vss vss sky130_fd_pr__nfet_01v8 L=0.5u W=1u
M10862 o7 ibias vss vss sky130_fd_pr__nfet_01v8 L=0.5u W=1u
M10863 o7 ibias vss vss sky130_fd_pr__nfet_01v8 L=0.5u W=1u
M10864 o7 ibias vss vss sky130_fd_pr__nfet_01v8 L=0.5u W=1u
M10865 o7 ibias vss vss sky130_fd_pr__nfet_01v8 L=0.5u W=1u
M10866 o7 ibias vss vss sky130_fd_pr__nfet_01v8 L=0.5u W=1u
M10867 o7 ibias vss vss sky130_fd_pr__nfet_01v8 L=0.5u W=1u
M10868 o7 ibias vss vss sky130_fd_pr__nfet_01v8 L=0.5u W=1u
M10869 o7 ibias vss vss sky130_fd_pr__nfet_01v8 L=0.5u W=1u
M10870 o7 ibias vss vss sky130_fd_pr__nfet_01v8 L=0.5u W=1u
M10871 o7 ibias vss vss sky130_fd_pr__nfet_01v8 L=0.5u W=1u
M10872 o7 ibias vss vss sky130_fd_pr__nfet_01v8 L=0.5u W=1u
M10873 o7 ibias vss vss sky130_fd_pr__nfet_01v8 L=0.5u W=1u
M10874 o7 ibias vss vss sky130_fd_pr__nfet_01v8 L=0.5u W=1u
M10875 o7 ibias vss vss sky130_fd_pr__nfet_01v8 L=0.5u W=1u
M10876 o7 ibias vss vss sky130_fd_pr__nfet_01v8 L=0.5u W=1u
M10877 o7 ibias vss vss sky130_fd_pr__nfet_01v8 L=0.5u W=1u
M10878 o7 ibias vss vss sky130_fd_pr__nfet_01v8 L=0.5u W=1u
M10879 o7 ibias vss vss sky130_fd_pr__nfet_01v8 L=0.5u W=1u
M10880 o7 ibias vss vss sky130_fd_pr__nfet_01v8 L=0.5u W=1u
M10881 o7 ibias vss vss sky130_fd_pr__nfet_01v8 L=0.5u W=1u
M10882 o7 ibias vss vss sky130_fd_pr__nfet_01v8 L=0.5u W=1u
M10883 o7 ibias vss vss sky130_fd_pr__nfet_01v8 L=0.5u W=1u
M10884 o7 ibias vss vss sky130_fd_pr__nfet_01v8 L=0.5u W=1u
M10885 o7 ibias vss vss sky130_fd_pr__nfet_01v8 L=0.5u W=1u
M10886 o7 ibias vss vss sky130_fd_pr__nfet_01v8 L=0.5u W=1u
M10887 o7 ibias vss vss sky130_fd_pr__nfet_01v8 L=0.5u W=1u
M10888 o7 ibias vss vss sky130_fd_pr__nfet_01v8 L=0.5u W=1u
M10889 o7 ibias vss vss sky130_fd_pr__nfet_01v8 L=0.5u W=1u
M10890 o7 ibias vss vss sky130_fd_pr__nfet_01v8 L=0.5u W=1u
M10891 o7 ibias vss vss sky130_fd_pr__nfet_01v8 L=0.5u W=1u
M10892 o7 ibias vss vss sky130_fd_pr__nfet_01v8 L=0.5u W=1u
M10893 o7 ibias vss vss sky130_fd_pr__nfet_01v8 L=0.5u W=1u
M10894 o7 ibias vss vss sky130_fd_pr__nfet_01v8 L=0.5u W=1u
M10895 o7 ibias vss vss sky130_fd_pr__nfet_01v8 L=0.5u W=1u
M10896 o7 ibias vss vss sky130_fd_pr__nfet_01v8 L=0.5u W=1u
M10897 o7 ibias vss vss sky130_fd_pr__nfet_01v8 L=0.5u W=1u
M10898 o7 ibias vss vss sky130_fd_pr__nfet_01v8 L=0.5u W=1u
M10899 o7 ibias vss vss sky130_fd_pr__nfet_01v8 L=0.5u W=1u
M10900 o7 ibias vss vss sky130_fd_pr__nfet_01v8 L=0.5u W=1u
M10901 o7 ibias vss vss sky130_fd_pr__nfet_01v8 L=0.5u W=1u
M10902 o7 ibias vss vss sky130_fd_pr__nfet_01v8 L=0.5u W=1u
M10903 o7 ibias vss vss sky130_fd_pr__nfet_01v8 L=0.5u W=1u
M10904 o7 ibias vss vss sky130_fd_pr__nfet_01v8 L=0.5u W=1u
M10905 o7 ibias vss vss sky130_fd_pr__nfet_01v8 L=0.5u W=1u
M10906 o7 ibias vss vss sky130_fd_pr__nfet_01v8 L=0.5u W=1u
M10907 o7 ibias vss vss sky130_fd_pr__nfet_01v8 L=0.5u W=1u
M10908 o7 ibias vss vss sky130_fd_pr__nfet_01v8 L=0.5u W=1u
M10909 o7 ibias vss vss sky130_fd_pr__nfet_01v8 L=0.5u W=1u
M10910 o7 ibias vss vss sky130_fd_pr__nfet_01v8 L=0.5u W=1u
M10911 o7 ibias vss vss sky130_fd_pr__nfet_01v8 L=0.5u W=1u
M10912 o7 ibias vss vss sky130_fd_pr__nfet_01v8 L=0.5u W=1u
M10913 o7 ibias vss vss sky130_fd_pr__nfet_01v8 L=0.5u W=1u
M10914 o7 ibias vss vss sky130_fd_pr__nfet_01v8 L=0.5u W=1u
M10915 o7 ibias vss vss sky130_fd_pr__nfet_01v8 L=0.5u W=1u
M10916 o7 ibias vss vss sky130_fd_pr__nfet_01v8 L=0.5u W=1u
M10917 o7 ibias vss vss sky130_fd_pr__nfet_01v8 L=0.5u W=1u
M10918 o7 ibias vss vss sky130_fd_pr__nfet_01v8 L=0.5u W=1u
M10919 o7 ibias vss vss sky130_fd_pr__nfet_01v8 L=0.5u W=1u
M10920 o7 ibias vss vss sky130_fd_pr__nfet_01v8 L=0.5u W=1u
M10921 o7 ibias vss vss sky130_fd_pr__nfet_01v8 L=0.5u W=1u
M10922 o7 ibias vss vss sky130_fd_pr__nfet_01v8 L=0.5u W=1u
M10923 o7 ibias vss vss sky130_fd_pr__nfet_01v8 L=0.5u W=1u
M10924 o7 ibias vss vss sky130_fd_pr__nfet_01v8 L=0.5u W=1u
M10925 o7 ibias vss vss sky130_fd_pr__nfet_01v8 L=0.5u W=1u
M10926 o7 ibias vss vss sky130_fd_pr__nfet_01v8 L=0.5u W=1u
M10927 o7 ibias vss vss sky130_fd_pr__nfet_01v8 L=0.5u W=1u
M10928 o7 ibias vss vss sky130_fd_pr__nfet_01v8 L=0.5u W=1u
M10929 o7 ibias vss vss sky130_fd_pr__nfet_01v8 L=0.5u W=1u
M10930 o7 ibias vss vss sky130_fd_pr__nfet_01v8 L=0.5u W=1u
M10931 o7 ibias vss vss sky130_fd_pr__nfet_01v8 L=0.5u W=1u
M10932 o7 ibias vss vss sky130_fd_pr__nfet_01v8 L=0.5u W=1u
M10933 o7 ibias vss vss sky130_fd_pr__nfet_01v8 L=0.5u W=1u
M10934 o7 ibias vss vss sky130_fd_pr__nfet_01v8 L=0.5u W=1u
M10935 o7 ibias vss vss sky130_fd_pr__nfet_01v8 L=0.5u W=1u
M10936 o7 ibias vss vss sky130_fd_pr__nfet_01v8 L=0.5u W=1u
M10937 o7 ibias vss vss sky130_fd_pr__nfet_01v8 L=0.5u W=1u
M10938 o7 ibias vss vss sky130_fd_pr__nfet_01v8 L=0.5u W=1u
M10939 o7 ibias vss vss sky130_fd_pr__nfet_01v8 L=0.5u W=1u
M10940 o7 ibias vss vss sky130_fd_pr__nfet_01v8 L=0.5u W=1u
M10941 o7 ibias vss vss sky130_fd_pr__nfet_01v8 L=0.5u W=1u
M10942 o7 ibias vss vss sky130_fd_pr__nfet_01v8 L=0.5u W=1u
M10943 o7 ibias vss vss sky130_fd_pr__nfet_01v8 L=0.5u W=1u
M10944 o7 ibias vss vss sky130_fd_pr__nfet_01v8 L=0.5u W=1u
M10945 o7 ibias vss vss sky130_fd_pr__nfet_01v8 L=0.5u W=1u
M10946 o7 ibias vss vss sky130_fd_pr__nfet_01v8 L=0.5u W=1u
M10947 o7 ibias vss vss sky130_fd_pr__nfet_01v8 L=0.5u W=1u
M10948 o7 ibias vss vss sky130_fd_pr__nfet_01v8 L=0.5u W=1u
M10949 o7 ibias vss vss sky130_fd_pr__nfet_01v8 L=0.5u W=1u
M10950 o7 ibias vss vss sky130_fd_pr__nfet_01v8 L=0.5u W=1u
M10951 o7 ibias vss vss sky130_fd_pr__nfet_01v8 L=0.5u W=1u
M10952 o7 ibias vss vss sky130_fd_pr__nfet_01v8 L=0.5u W=1u
M10953 o7 ibias vss vss sky130_fd_pr__nfet_01v8 L=0.5u W=1u
M10954 o7 ibias vss vss sky130_fd_pr__nfet_01v8 L=0.5u W=1u
M10955 o7 ibias vss vss sky130_fd_pr__nfet_01v8 L=0.5u W=1u
M10956 o7 ibias vss vss sky130_fd_pr__nfet_01v8 L=0.5u W=1u
M10957 o7 ibias vss vss sky130_fd_pr__nfet_01v8 L=0.5u W=1u
M10958 o7 ibias vss vss sky130_fd_pr__nfet_01v8 L=0.5u W=1u
M10959 o7 ibias vss vss sky130_fd_pr__nfet_01v8 L=0.5u W=1u
M10960 o7 ibias vss vss sky130_fd_pr__nfet_01v8 L=0.5u W=1u
M10961 o7 ibias vss vss sky130_fd_pr__nfet_01v8 L=0.5u W=1u
M10962 o7 ibias vss vss sky130_fd_pr__nfet_01v8 L=0.5u W=1u
M10963 o7 ibias vss vss sky130_fd_pr__nfet_01v8 L=0.5u W=1u
M10964 o7 ibias vss vss sky130_fd_pr__nfet_01v8 L=0.5u W=1u
M10965 o7 ibias vss vss sky130_fd_pr__nfet_01v8 L=0.5u W=1u
M10966 o7 ibias vss vss sky130_fd_pr__nfet_01v8 L=0.5u W=1u
M10967 o7 ibias vss vss sky130_fd_pr__nfet_01v8 L=0.5u W=1u
M10968 o7 ibias vss vss sky130_fd_pr__nfet_01v8 L=0.5u W=1u
M10969 o7 ibias vss vss sky130_fd_pr__nfet_01v8 L=0.5u W=1u
M10970 o7 ibias vss vss sky130_fd_pr__nfet_01v8 L=0.5u W=1u
M10971 o7 ibias vss vss sky130_fd_pr__nfet_01v8 L=0.5u W=1u
M10972 o7 ibias vss vss sky130_fd_pr__nfet_01v8 L=0.5u W=1u
M10973 o7 ibias vss vss sky130_fd_pr__nfet_01v8 L=0.5u W=1u
M10974 o7 ibias vss vss sky130_fd_pr__nfet_01v8 L=0.5u W=1u
M10975 o7 ibias vss vss sky130_fd_pr__nfet_01v8 L=0.5u W=1u
M10976 o7 ibias vss vss sky130_fd_pr__nfet_01v8 L=0.5u W=1u
M10977 o7 ibias vss vss sky130_fd_pr__nfet_01v8 L=0.5u W=1u
M10978 o7 ibias vss vss sky130_fd_pr__nfet_01v8 L=0.5u W=1u
M10979 o7 ibias vss vss sky130_fd_pr__nfet_01v8 L=0.5u W=1u
M10980 o7 ibias vss vss sky130_fd_pr__nfet_01v8 L=0.5u W=1u
M10981 o7 ibias vss vss sky130_fd_pr__nfet_01v8 L=0.5u W=1u
M10982 o7 ibias vss vss sky130_fd_pr__nfet_01v8 L=0.5u W=1u
M10983 o7 ibias vss vss sky130_fd_pr__nfet_01v8 L=0.5u W=1u
M10984 o7 ibias vss vss sky130_fd_pr__nfet_01v8 L=0.5u W=1u
M10985 o7 ibias vss vss sky130_fd_pr__nfet_01v8 L=0.5u W=1u
M10986 o7 ibias vss vss sky130_fd_pr__nfet_01v8 L=0.5u W=1u
M10987 o7 ibias vss vss sky130_fd_pr__nfet_01v8 L=0.5u W=1u
M10988 o7 ibias vss vss sky130_fd_pr__nfet_01v8 L=0.5u W=1u
M10989 o7 ibias vss vss sky130_fd_pr__nfet_01v8 L=0.5u W=1u
M10990 o7 ibias vss vss sky130_fd_pr__nfet_01v8 L=0.5u W=1u
M10991 o7 ibias vss vss sky130_fd_pr__nfet_01v8 L=0.5u W=1u
M10992 o7 ibias vss vss sky130_fd_pr__nfet_01v8 L=0.5u W=1u
M10993 o7 ibias vss vss sky130_fd_pr__nfet_01v8 L=0.5u W=1u
M10994 o7 ibias vss vss sky130_fd_pr__nfet_01v8 L=0.5u W=1u
M10995 o7 ibias vss vss sky130_fd_pr__nfet_01v8 L=0.5u W=1u
M10996 o7 ibias vss vss sky130_fd_pr__nfet_01v8 L=0.5u W=1u
M10997 o7 ibias vss vss sky130_fd_pr__nfet_01v8 L=0.5u W=1u
M10998 o7 ibias vss vss sky130_fd_pr__nfet_01v8 L=0.5u W=1u
M10999 o7 ibias vss vss sky130_fd_pr__nfet_01v8 L=0.5u W=1u
M11000 o7 ibias vss vss sky130_fd_pr__nfet_01v8 L=0.5u W=1u
M11001 o7 ibias vss vss sky130_fd_pr__nfet_01v8 L=0.5u W=1u
M11002 o7 ibias vss vss sky130_fd_pr__nfet_01v8 L=0.5u W=1u
M11003 o7 ibias vss vss sky130_fd_pr__nfet_01v8 L=0.5u W=1u
M11004 o7 ibias vss vss sky130_fd_pr__nfet_01v8 L=0.5u W=1u
M11005 o7 ibias vss vss sky130_fd_pr__nfet_01v8 L=0.5u W=1u
M11006 o7 ibias vss vss sky130_fd_pr__nfet_01v8 L=0.5u W=1u
M11007 o7 ibias vss vss sky130_fd_pr__nfet_01v8 L=0.5u W=1u
M11008 o7 ibias vss vss sky130_fd_pr__nfet_01v8 L=0.5u W=1u
M11009 o7 ibias vss vss sky130_fd_pr__nfet_01v8 L=0.5u W=1u
M11010 o7 ibias vss vss sky130_fd_pr__nfet_01v8 L=0.5u W=1u
M11011 o7 ibias vss vss sky130_fd_pr__nfet_01v8 L=0.5u W=1u
M11012 o7 ibias vss vss sky130_fd_pr__nfet_01v8 L=0.5u W=1u
M11013 o7 ibias vss vss sky130_fd_pr__nfet_01v8 L=0.5u W=1u
M11014 o7 ibias vss vss sky130_fd_pr__nfet_01v8 L=0.5u W=1u
M11015 o7 ibias vss vss sky130_fd_pr__nfet_01v8 L=0.5u W=1u
M11016 o7 ibias vss vss sky130_fd_pr__nfet_01v8 L=0.5u W=1u
M11017 o7 ibias vss vss sky130_fd_pr__nfet_01v8 L=0.5u W=1u
M11018 o7 ibias vss vss sky130_fd_pr__nfet_01v8 L=0.5u W=1u
M11019 o7 ibias vss vss sky130_fd_pr__nfet_01v8 L=0.5u W=1u
M11020 o7 ibias vss vss sky130_fd_pr__nfet_01v8 L=0.5u W=1u
M11021 o7 ibias vss vss sky130_fd_pr__nfet_01v8 L=0.5u W=1u
M11022 o7 ibias vss vss sky130_fd_pr__nfet_01v8 L=0.5u W=1u
M11023 o7 ibias vss vss sky130_fd_pr__nfet_01v8 L=0.5u W=1u
M11024 o7 ibias vss vss sky130_fd_pr__nfet_01v8 L=0.5u W=1u
M11025 o7 ibias vss vss sky130_fd_pr__nfet_01v8 L=0.5u W=1u
M11026 o7 ibias vss vss sky130_fd_pr__nfet_01v8 L=0.5u W=1u
M11027 o7 ibias vss vss sky130_fd_pr__nfet_01v8 L=0.5u W=1u
M11028 o7 ibias vss vss sky130_fd_pr__nfet_01v8 L=0.5u W=1u
M11029 o7 ibias vss vss sky130_fd_pr__nfet_01v8 L=0.5u W=1u
M11030 o7 ibias vss vss sky130_fd_pr__nfet_01v8 L=0.5u W=1u
M11031 o7 ibias vss vss sky130_fd_pr__nfet_01v8 L=0.5u W=1u
M11032 o7 ibias vss vss sky130_fd_pr__nfet_01v8 L=0.5u W=1u
M11033 o7 ibias vss vss sky130_fd_pr__nfet_01v8 L=0.5u W=1u
M11034 o7 ibias vss vss sky130_fd_pr__nfet_01v8 L=0.5u W=1u
M11035 o7 ibias vss vss sky130_fd_pr__nfet_01v8 L=0.5u W=1u
M11036 o7 ibias vss vss sky130_fd_pr__nfet_01v8 L=0.5u W=1u
M11037 o7 ibias vss vss sky130_fd_pr__nfet_01v8 L=0.5u W=1u
M11038 o7 ibias vss vss sky130_fd_pr__nfet_01v8 L=0.5u W=1u
M11039 o7 ibias vss vss sky130_fd_pr__nfet_01v8 L=0.5u W=1u
M11040 o7 ibias vss vss sky130_fd_pr__nfet_01v8 L=0.5u W=1u
M11041 o7 ibias vss vss sky130_fd_pr__nfet_01v8 L=0.5u W=1u
M11042 o7 ibias vss vss sky130_fd_pr__nfet_01v8 L=0.5u W=1u
M11043 o7 ibias vss vss sky130_fd_pr__nfet_01v8 L=0.5u W=1u
M11044 o7 ibias vss vss sky130_fd_pr__nfet_01v8 L=0.5u W=1u
M11045 o7 ibias vss vss sky130_fd_pr__nfet_01v8 L=0.5u W=1u
M11046 o7 ibias vss vss sky130_fd_pr__nfet_01v8 L=0.5u W=1u
M11047 o7 ibias vss vss sky130_fd_pr__nfet_01v8 L=0.5u W=1u
M11048 o7 ibias vss vss sky130_fd_pr__nfet_01v8 L=0.5u W=1u
M11049 o7 ibias vss vss sky130_fd_pr__nfet_01v8 L=0.5u W=1u
M11050 o7 ibias vss vss sky130_fd_pr__nfet_01v8 L=0.5u W=1u
M11051 o7 ibias vss vss sky130_fd_pr__nfet_01v8 L=0.5u W=1u
M11052 o7 ibias vss vss sky130_fd_pr__nfet_01v8 L=0.5u W=1u
M11053 o7 ibias vss vss sky130_fd_pr__nfet_01v8 L=0.5u W=1u
M11054 o7 ibias vss vss sky130_fd_pr__nfet_01v8 L=0.5u W=1u
M11055 o7 ibias vss vss sky130_fd_pr__nfet_01v8 L=0.5u W=1u
M11056 o7 ibias vss vss sky130_fd_pr__nfet_01v8 L=0.5u W=1u
M11057 o7 ibias vss vss sky130_fd_pr__nfet_01v8 L=0.5u W=1u
M11058 o7 ibias vss vss sky130_fd_pr__nfet_01v8 L=0.5u W=1u
M11059 o7 ibias vss vss sky130_fd_pr__nfet_01v8 L=0.5u W=1u
M11060 o7 ibias vss vss sky130_fd_pr__nfet_01v8 L=0.5u W=1u
M11061 o7 ibias vss vss sky130_fd_pr__nfet_01v8 L=0.5u W=1u
M11062 o7 ibias vss vss sky130_fd_pr__nfet_01v8 L=0.5u W=1u
M11063 o7 ibias vss vss sky130_fd_pr__nfet_01v8 L=0.5u W=1u
M11064 o7 ibias vss vss sky130_fd_pr__nfet_01v8 L=0.5u W=1u
M11065 o7 ibias vss vss sky130_fd_pr__nfet_01v8 L=0.5u W=1u
M11066 o7 ibias vss vss sky130_fd_pr__nfet_01v8 L=0.5u W=1u
M11067 o7 ibias vss vss sky130_fd_pr__nfet_01v8 L=0.5u W=1u
M11068 o7 ibias vss vss sky130_fd_pr__nfet_01v8 L=0.5u W=1u
M11069 o7 ibias vss vss sky130_fd_pr__nfet_01v8 L=0.5u W=1u
M11070 o7 ibias vss vss sky130_fd_pr__nfet_01v8 L=0.5u W=1u
M11071 o7 ibias vss vss sky130_fd_pr__nfet_01v8 L=0.5u W=1u
M11072 o7 ibias vss vss sky130_fd_pr__nfet_01v8 L=0.5u W=1u
M11073 o7 ibias vss vss sky130_fd_pr__nfet_01v8 L=0.5u W=1u
M11074 o7 ibias vss vss sky130_fd_pr__nfet_01v8 L=0.5u W=1u
M11075 o7 ibias vss vss sky130_fd_pr__nfet_01v8 L=0.5u W=1u
M11076 o7 ibias vss vss sky130_fd_pr__nfet_01v8 L=0.5u W=1u
M11077 o7 ibias vss vss sky130_fd_pr__nfet_01v8 L=0.5u W=1u
M11078 o7 ibias vss vss sky130_fd_pr__nfet_01v8 L=0.5u W=1u
M11079 o7 ibias vss vss sky130_fd_pr__nfet_01v8 L=0.5u W=1u
M11080 o7 ibias vss vss sky130_fd_pr__nfet_01v8 L=0.5u W=1u
M11081 o7 ibias vss vss sky130_fd_pr__nfet_01v8 L=0.5u W=1u
M11082 o7 ibias vss vss sky130_fd_pr__nfet_01v8 L=0.5u W=1u
M11083 o7 ibias vss vss sky130_fd_pr__nfet_01v8 L=0.5u W=1u
M11084 o7 ibias vss vss sky130_fd_pr__nfet_01v8 L=0.5u W=1u
M11085 o7 ibias vss vss sky130_fd_pr__nfet_01v8 L=0.5u W=1u
M11086 o7 ibias vss vss sky130_fd_pr__nfet_01v8 L=0.5u W=1u
M11087 o7 ibias vss vss sky130_fd_pr__nfet_01v8 L=0.5u W=1u
M11088 o7 ibias vss vss sky130_fd_pr__nfet_01v8 L=0.5u W=1u
M11089 o7 ibias vss vss sky130_fd_pr__nfet_01v8 L=0.5u W=1u
M11090 o7 ibias vss vss sky130_fd_pr__nfet_01v8 L=0.5u W=1u
M11091 o7 ibias vss vss sky130_fd_pr__nfet_01v8 L=0.5u W=1u
M11092 o7 ibias vss vss sky130_fd_pr__nfet_01v8 L=0.5u W=1u
M11093 o7 ibias vss vss sky130_fd_pr__nfet_01v8 L=0.5u W=1u
M11094 o7 ibias vss vss sky130_fd_pr__nfet_01v8 L=0.5u W=1u
M11095 o7 ibias vss vss sky130_fd_pr__nfet_01v8 L=0.5u W=1u
M11096 o7 ibias vss vss sky130_fd_pr__nfet_01v8 L=0.5u W=1u
M11097 o7 ibias vss vss sky130_fd_pr__nfet_01v8 L=0.5u W=1u
M11098 o7 ibias vss vss sky130_fd_pr__nfet_01v8 L=0.5u W=1u
M11099 o7 ibias vss vss sky130_fd_pr__nfet_01v8 L=0.5u W=1u
M11100 o7 ibias vss vss sky130_fd_pr__nfet_01v8 L=0.5u W=1u
M11101 o7 ibias vss vss sky130_fd_pr__nfet_01v8 L=0.5u W=1u
M11102 o7 ibias vss vss sky130_fd_pr__nfet_01v8 L=0.5u W=1u
M11103 o7 ibias vss vss sky130_fd_pr__nfet_01v8 L=0.5u W=1u
M11104 o7 ibias vss vss sky130_fd_pr__nfet_01v8 L=0.5u W=1u
M11105 o7 ibias vss vss sky130_fd_pr__nfet_01v8 L=0.5u W=1u
M11106 o7 ibias vss vss sky130_fd_pr__nfet_01v8 L=0.5u W=1u
M11107 o7 ibias vss vss sky130_fd_pr__nfet_01v8 L=0.5u W=1u
M11108 o7 ibias vss vss sky130_fd_pr__nfet_01v8 L=0.5u W=1u
M11109 o7 ibias vss vss sky130_fd_pr__nfet_01v8 L=0.5u W=1u
M11110 o7 ibias vss vss sky130_fd_pr__nfet_01v8 L=0.5u W=1u
M11111 o7 ibias vss vss sky130_fd_pr__nfet_01v8 L=0.5u W=1u
M11112 o7 ibias vss vss sky130_fd_pr__nfet_01v8 L=0.5u W=1u
M11113 o7 ibias vss vss sky130_fd_pr__nfet_01v8 L=0.5u W=1u
M11114 o7 ibias vss vss sky130_fd_pr__nfet_01v8 L=0.5u W=1u
M11115 o7 ibias vss vss sky130_fd_pr__nfet_01v8 L=0.5u W=1u
M11116 o7 ibias vss vss sky130_fd_pr__nfet_01v8 L=0.5u W=1u
M11117 o7 ibias vss vss sky130_fd_pr__nfet_01v8 L=0.5u W=1u
M11118 o7 ibias vss vss sky130_fd_pr__nfet_01v8 L=0.5u W=1u
M11119 o7 ibias vss vss sky130_fd_pr__nfet_01v8 L=0.5u W=1u
M11120 o7 ibias vss vss sky130_fd_pr__nfet_01v8 L=0.5u W=1u
M11121 o7 ibias vss vss sky130_fd_pr__nfet_01v8 L=0.5u W=1u
M11122 o7 ibias vss vss sky130_fd_pr__nfet_01v8 L=0.5u W=1u
M11123 o7 ibias vss vss sky130_fd_pr__nfet_01v8 L=0.5u W=1u
M11124 o7 ibias vss vss sky130_fd_pr__nfet_01v8 L=0.5u W=1u
M11125 o7 ibias vss vss sky130_fd_pr__nfet_01v8 L=0.5u W=1u
M11126 o7 ibias vss vss sky130_fd_pr__nfet_01v8 L=0.5u W=1u
M11127 o7 ibias vss vss sky130_fd_pr__nfet_01v8 L=0.5u W=1u
M11128 o7 ibias vss vss sky130_fd_pr__nfet_01v8 L=0.5u W=1u
M11129 o7 ibias vss vss sky130_fd_pr__nfet_01v8 L=0.5u W=1u
M11130 o7 ibias vss vss sky130_fd_pr__nfet_01v8 L=0.5u W=1u
M11131 o7 ibias vss vss sky130_fd_pr__nfet_01v8 L=0.5u W=1u
M11132 o7 ibias vss vss sky130_fd_pr__nfet_01v8 L=0.5u W=1u
M11133 o7 ibias vss vss sky130_fd_pr__nfet_01v8 L=0.5u W=1u
M11134 o7 ibias vss vss sky130_fd_pr__nfet_01v8 L=0.5u W=1u
M11135 o7 ibias vss vss sky130_fd_pr__nfet_01v8 L=0.5u W=1u
M11136 o7 ibias vss vss sky130_fd_pr__nfet_01v8 L=0.5u W=1u
M11137 o7 ibias vss vss sky130_fd_pr__nfet_01v8 L=0.5u W=1u
M11138 o7 ibias vss vss sky130_fd_pr__nfet_01v8 L=0.5u W=1u
M11139 o7 ibias vss vss sky130_fd_pr__nfet_01v8 L=0.5u W=1u
M11140 o7 ibias vss vss sky130_fd_pr__nfet_01v8 L=0.5u W=1u
M11141 o7 ibias vss vss sky130_fd_pr__nfet_01v8 L=0.5u W=1u
M11142 o7 ibias vss vss sky130_fd_pr__nfet_01v8 L=0.5u W=1u
M11143 o7 ibias vss vss sky130_fd_pr__nfet_01v8 L=0.5u W=1u
M11144 o7 ibias vss vss sky130_fd_pr__nfet_01v8 L=0.5u W=1u
M11145 o7 ibias vss vss sky130_fd_pr__nfet_01v8 L=0.5u W=1u
M11146 o7 ibias vss vss sky130_fd_pr__nfet_01v8 L=0.5u W=1u
M11147 o7 ibias vss vss sky130_fd_pr__nfet_01v8 L=0.5u W=1u
M11148 o7 ibias vss vss sky130_fd_pr__nfet_01v8 L=0.5u W=1u
M11149 o7 ibias vss vss sky130_fd_pr__nfet_01v8 L=0.5u W=1u
M11150 o7 ibias vss vss sky130_fd_pr__nfet_01v8 L=0.5u W=1u
M11151 o7 ibias vss vss sky130_fd_pr__nfet_01v8 L=0.5u W=1u
M11152 o7 ibias vss vss sky130_fd_pr__nfet_01v8 L=0.5u W=1u
M11153 o7 ibias vss vss sky130_fd_pr__nfet_01v8 L=0.5u W=1u
M11154 o7 ibias vss vss sky130_fd_pr__nfet_01v8 L=0.5u W=1u
M11155 o7 ibias vss vss sky130_fd_pr__nfet_01v8 L=0.5u W=1u
M11156 o7 ibias vss vss sky130_fd_pr__nfet_01v8 L=0.5u W=1u
M11157 o7 ibias vss vss sky130_fd_pr__nfet_01v8 L=0.5u W=1u
M11158 o7 ibias vss vss sky130_fd_pr__nfet_01v8 L=0.5u W=1u
M11159 o7 ibias vss vss sky130_fd_pr__nfet_01v8 L=0.5u W=1u
M11160 o7 ibias vss vss sky130_fd_pr__nfet_01v8 L=0.5u W=1u
M11161 o7 ibias vss vss sky130_fd_pr__nfet_01v8 L=0.5u W=1u
M11162 o7 ibias vss vss sky130_fd_pr__nfet_01v8 L=0.5u W=1u
M11163 o7 ibias vss vss sky130_fd_pr__nfet_01v8 L=0.5u W=1u
M11164 o7 ibias vss vss sky130_fd_pr__nfet_01v8 L=0.5u W=1u
M11165 o7 ibias vss vss sky130_fd_pr__nfet_01v8 L=0.5u W=1u
M11166 o7 ibias vss vss sky130_fd_pr__nfet_01v8 L=0.5u W=1u
M11167 o7 ibias vss vss sky130_fd_pr__nfet_01v8 L=0.5u W=1u
M11168 o7 ibias vss vss sky130_fd_pr__nfet_01v8 L=0.5u W=1u
M11169 o7 ibias vss vss sky130_fd_pr__nfet_01v8 L=0.5u W=1u
M11170 o7 ibias vss vss sky130_fd_pr__nfet_01v8 L=0.5u W=1u
M11171 o7 ibias vss vss sky130_fd_pr__nfet_01v8 L=0.5u W=1u
M11172 o7 ibias vss vss sky130_fd_pr__nfet_01v8 L=0.5u W=1u
M11173 o7 ibias vss vss sky130_fd_pr__nfet_01v8 L=0.5u W=1u
M11174 o7 ibias vss vss sky130_fd_pr__nfet_01v8 L=0.5u W=1u
M11175 o7 ibias vss vss sky130_fd_pr__nfet_01v8 L=0.5u W=1u
M11176 o7 ibias vss vss sky130_fd_pr__nfet_01v8 L=0.5u W=1u
M11177 o7 ibias vss vss sky130_fd_pr__nfet_01v8 L=0.5u W=1u
M11178 o7 ibias vss vss sky130_fd_pr__nfet_01v8 L=0.5u W=1u
M11179 o7 ibias vss vss sky130_fd_pr__nfet_01v8 L=0.5u W=1u
M11180 o7 ibias vss vss sky130_fd_pr__nfet_01v8 L=0.5u W=1u
M11181 o7 ibias vss vss sky130_fd_pr__nfet_01v8 L=0.5u W=1u
M11182 o7 ibias vss vss sky130_fd_pr__nfet_01v8 L=0.5u W=1u
M11183 o7 ibias vss vss sky130_fd_pr__nfet_01v8 L=0.5u W=1u
M11184 o7 ibias vss vss sky130_fd_pr__nfet_01v8 L=0.5u W=1u
M11185 o7 ibias vss vss sky130_fd_pr__nfet_01v8 L=0.5u W=1u
M11186 o7 ibias vss vss sky130_fd_pr__nfet_01v8 L=0.5u W=1u
M11187 o7 ibias vss vss sky130_fd_pr__nfet_01v8 L=0.5u W=1u
M11188 o7 ibias vss vss sky130_fd_pr__nfet_01v8 L=0.5u W=1u
M11189 o7 ibias vss vss sky130_fd_pr__nfet_01v8 L=0.5u W=1u
M11190 o7 ibias vss vss sky130_fd_pr__nfet_01v8 L=0.5u W=1u
M11191 o7 ibias vss vss sky130_fd_pr__nfet_01v8 L=0.5u W=1u
M11192 o7 ibias vss vss sky130_fd_pr__nfet_01v8 L=0.5u W=1u
M11193 o7 ibias vss vss sky130_fd_pr__nfet_01v8 L=0.5u W=1u
M11194 o7 ibias vss vss sky130_fd_pr__nfet_01v8 L=0.5u W=1u
M11195 o7 ibias vss vss sky130_fd_pr__nfet_01v8 L=0.5u W=1u
M11196 o7 ibias vss vss sky130_fd_pr__nfet_01v8 L=0.5u W=1u
M11197 o7 ibias vss vss sky130_fd_pr__nfet_01v8 L=0.5u W=1u
M11198 o7 ibias vss vss sky130_fd_pr__nfet_01v8 L=0.5u W=1u
M11199 o7 ibias vss vss sky130_fd_pr__nfet_01v8 L=0.5u W=1u
M11200 o7 ibias vss vss sky130_fd_pr__nfet_01v8 L=0.5u W=1u
M11201 o7 ibias vss vss sky130_fd_pr__nfet_01v8 L=0.5u W=1u
M11202 o7 ibias vss vss sky130_fd_pr__nfet_01v8 L=0.5u W=1u
M11203 o7 ibias vss vss sky130_fd_pr__nfet_01v8 L=0.5u W=1u
M11204 o7 ibias vss vss sky130_fd_pr__nfet_01v8 L=0.5u W=1u
M11205 o7 ibias vss vss sky130_fd_pr__nfet_01v8 L=0.5u W=1u
M11206 o7 ibias vss vss sky130_fd_pr__nfet_01v8 L=0.5u W=1u
M11207 o7 ibias vss vss sky130_fd_pr__nfet_01v8 L=0.5u W=1u
M11208 o7 ibias vss vss sky130_fd_pr__nfet_01v8 L=0.5u W=1u
M11209 o7 ibias vss vss sky130_fd_pr__nfet_01v8 L=0.5u W=1u
M11210 o7 ibias vss vss sky130_fd_pr__nfet_01v8 L=0.5u W=1u
M11211 o7 ibias vss vss sky130_fd_pr__nfet_01v8 L=0.5u W=1u
M11212 o7 ibias vss vss sky130_fd_pr__nfet_01v8 L=0.5u W=1u
M11213 o7 ibias vss vss sky130_fd_pr__nfet_01v8 L=0.5u W=1u
M11214 o7 ibias vss vss sky130_fd_pr__nfet_01v8 L=0.5u W=1u
M11215 o7 ibias vss vss sky130_fd_pr__nfet_01v8 L=0.5u W=1u
M11216 o7 ibias vss vss sky130_fd_pr__nfet_01v8 L=0.5u W=1u
M11217 o7 ibias vss vss sky130_fd_pr__nfet_01v8 L=0.5u W=1u
M11218 o7 ibias vss vss sky130_fd_pr__nfet_01v8 L=0.5u W=1u
M11219 o7 ibias vss vss sky130_fd_pr__nfet_01v8 L=0.5u W=1u
M11220 o7 ibias vss vss sky130_fd_pr__nfet_01v8 L=0.5u W=1u
M11221 o7 ibias vss vss sky130_fd_pr__nfet_01v8 L=0.5u W=1u
M11222 o7 ibias vss vss sky130_fd_pr__nfet_01v8 L=0.5u W=1u
M11223 o7 ibias vss vss sky130_fd_pr__nfet_01v8 L=0.5u W=1u
M11224 o7 ibias vss vss sky130_fd_pr__nfet_01v8 L=0.5u W=1u
M11225 o7 ibias vss vss sky130_fd_pr__nfet_01v8 L=0.5u W=1u
M11226 o7 ibias vss vss sky130_fd_pr__nfet_01v8 L=0.5u W=1u
M11227 o7 ibias vss vss sky130_fd_pr__nfet_01v8 L=0.5u W=1u
M11228 o7 ibias vss vss sky130_fd_pr__nfet_01v8 L=0.5u W=1u
M11229 o7 ibias vss vss sky130_fd_pr__nfet_01v8 L=0.5u W=1u
M11230 o7 ibias vss vss sky130_fd_pr__nfet_01v8 L=0.5u W=1u
M11231 o7 ibias vss vss sky130_fd_pr__nfet_01v8 L=0.5u W=1u
M11232 o7 ibias vss vss sky130_fd_pr__nfet_01v8 L=0.5u W=1u
M11233 o7 ibias vss vss sky130_fd_pr__nfet_01v8 L=0.5u W=1u
M11234 o7 ibias vss vss sky130_fd_pr__nfet_01v8 L=0.5u W=1u
M11235 o7 ibias vss vss sky130_fd_pr__nfet_01v8 L=0.5u W=1u
M11236 o7 ibias vss vss sky130_fd_pr__nfet_01v8 L=0.5u W=1u
M11237 o7 ibias vss vss sky130_fd_pr__nfet_01v8 L=0.5u W=1u
M11238 o7 ibias vss vss sky130_fd_pr__nfet_01v8 L=0.5u W=1u
M11239 o7 ibias vss vss sky130_fd_pr__nfet_01v8 L=0.5u W=1u
M11240 o7 ibias vss vss sky130_fd_pr__nfet_01v8 L=0.5u W=1u
M11241 o7 ibias vss vss sky130_fd_pr__nfet_01v8 L=0.5u W=1u
M11242 o7 ibias vss vss sky130_fd_pr__nfet_01v8 L=0.5u W=1u
M11243 o7 ibias vss vss sky130_fd_pr__nfet_01v8 L=0.5u W=1u
M11244 o7 ibias vss vss sky130_fd_pr__nfet_01v8 L=0.5u W=1u
M11245 o7 ibias vss vss sky130_fd_pr__nfet_01v8 L=0.5u W=1u
M11246 o7 ibias vss vss sky130_fd_pr__nfet_01v8 L=0.5u W=1u
M11247 o7 ibias vss vss sky130_fd_pr__nfet_01v8 L=0.5u W=1u
M11248 o7 ibias vss vss sky130_fd_pr__nfet_01v8 L=0.5u W=1u
M11249 o7 ibias vss vss sky130_fd_pr__nfet_01v8 L=0.5u W=1u
M11250 o7 ibias vss vss sky130_fd_pr__nfet_01v8 L=0.5u W=1u
M11251 o7 ibias vss vss sky130_fd_pr__nfet_01v8 L=0.5u W=1u
M11252 o7 ibias vss vss sky130_fd_pr__nfet_01v8 L=0.5u W=1u
M11253 o7 ibias vss vss sky130_fd_pr__nfet_01v8 L=0.5u W=1u
M11254 o7 ibias vss vss sky130_fd_pr__nfet_01v8 L=0.5u W=1u
M11255 o7 ibias vss vss sky130_fd_pr__nfet_01v8 L=0.5u W=1u
M11256 o7 ibias vss vss sky130_fd_pr__nfet_01v8 L=0.5u W=1u
M11257 o7 ibias vss vss sky130_fd_pr__nfet_01v8 L=0.5u W=1u
M11258 o7 ibias vss vss sky130_fd_pr__nfet_01v8 L=0.5u W=1u
M11259 o7 ibias vss vss sky130_fd_pr__nfet_01v8 L=0.5u W=1u
M11260 o7 ibias vss vss sky130_fd_pr__nfet_01v8 L=0.5u W=1u
M11261 o7 ibias vss vss sky130_fd_pr__nfet_01v8 L=0.5u W=1u
M11262 o7 ibias vss vss sky130_fd_pr__nfet_01v8 L=0.5u W=1u
M11263 o7 ibias vss vss sky130_fd_pr__nfet_01v8 L=0.5u W=1u
M11264 o7 ibias vss vss sky130_fd_pr__nfet_01v8 L=0.5u W=1u
M11265 o7 ibias vss vss sky130_fd_pr__nfet_01v8 L=0.5u W=1u
M11266 o7 ibias vss vss sky130_fd_pr__nfet_01v8 L=0.5u W=1u
M11267 o7 ibias vss vss sky130_fd_pr__nfet_01v8 L=0.5u W=1u
M11268 o7 ibias vss vss sky130_fd_pr__nfet_01v8 L=0.5u W=1u
M11269 o7 ibias vss vss sky130_fd_pr__nfet_01v8 L=0.5u W=1u
M11270 o7 ibias vss vss sky130_fd_pr__nfet_01v8 L=0.5u W=1u
M11271 o7 ibias vss vss sky130_fd_pr__nfet_01v8 L=0.5u W=1u
M11272 o7 ibias vss vss sky130_fd_pr__nfet_01v8 L=0.5u W=1u
M11273 o7 ibias vss vss sky130_fd_pr__nfet_01v8 L=0.5u W=1u
M11274 o7 ibias vss vss sky130_fd_pr__nfet_01v8 L=0.5u W=1u
M11275 o7 ibias vss vss sky130_fd_pr__nfet_01v8 L=0.5u W=1u
M11276 o7 ibias vss vss sky130_fd_pr__nfet_01v8 L=0.5u W=1u
M11277 o7 ibias vss vss sky130_fd_pr__nfet_01v8 L=0.5u W=1u
M11278 o7 ibias vss vss sky130_fd_pr__nfet_01v8 L=0.5u W=1u
M11279 o7 ibias vss vss sky130_fd_pr__nfet_01v8 L=0.5u W=1u
M11280 o7 ibias vss vss sky130_fd_pr__nfet_01v8 L=0.5u W=1u
M11281 o7 ibias vss vss sky130_fd_pr__nfet_01v8 L=0.5u W=1u
M11282 o7 ibias vss vss sky130_fd_pr__nfet_01v8 L=0.5u W=1u
M11283 o7 ibias vss vss sky130_fd_pr__nfet_01v8 L=0.5u W=1u
M11284 o7 ibias vss vss sky130_fd_pr__nfet_01v8 L=0.5u W=1u
M11285 o7 ibias vss vss sky130_fd_pr__nfet_01v8 L=0.5u W=1u
M11286 o7 ibias vss vss sky130_fd_pr__nfet_01v8 L=0.5u W=1u
M11287 o7 ibias vss vss sky130_fd_pr__nfet_01v8 L=0.5u W=1u
M11288 o7 ibias vss vss sky130_fd_pr__nfet_01v8 L=0.5u W=1u
M11289 o7 ibias vss vss sky130_fd_pr__nfet_01v8 L=0.5u W=1u
M11290 o7 ibias vss vss sky130_fd_pr__nfet_01v8 L=0.5u W=1u
M11291 o7 ibias vss vss sky130_fd_pr__nfet_01v8 L=0.5u W=1u
M11292 o7 ibias vss vss sky130_fd_pr__nfet_01v8 L=0.5u W=1u
M11293 o7 ibias vss vss sky130_fd_pr__nfet_01v8 L=0.5u W=1u
M11294 o7 ibias vss vss sky130_fd_pr__nfet_01v8 L=0.5u W=1u
M11295 o7 ibias vss vss sky130_fd_pr__nfet_01v8 L=0.5u W=1u
M11296 o7 ibias vss vss sky130_fd_pr__nfet_01v8 L=0.5u W=1u
M11297 o7 ibias vss vss sky130_fd_pr__nfet_01v8 L=0.5u W=1u
M11298 o7 ibias vss vss sky130_fd_pr__nfet_01v8 L=0.5u W=1u
M11299 o7 ibias vss vss sky130_fd_pr__nfet_01v8 L=0.5u W=1u
M11300 o7 ibias vss vss sky130_fd_pr__nfet_01v8 L=0.5u W=1u
M11301 o7 ibias vss vss sky130_fd_pr__nfet_01v8 L=0.5u W=1u
M11302 o7 ibias vss vss sky130_fd_pr__nfet_01v8 L=0.5u W=1u
M11303 o7 ibias vss vss sky130_fd_pr__nfet_01v8 L=0.5u W=1u
M11304 o7 ibias vss vss sky130_fd_pr__nfet_01v8 L=0.5u W=1u
M11305 o7 ibias vss vss sky130_fd_pr__nfet_01v8 L=0.5u W=1u
M11306 o7 ibias vss vss sky130_fd_pr__nfet_01v8 L=0.5u W=1u
M11307 o7 ibias vss vss sky130_fd_pr__nfet_01v8 L=0.5u W=1u
M11308 o7 ibias vss vss sky130_fd_pr__nfet_01v8 L=0.5u W=1u
M11309 o7 ibias vss vss sky130_fd_pr__nfet_01v8 L=0.5u W=1u
M11310 o7 ibias vss vss sky130_fd_pr__nfet_01v8 L=0.5u W=1u
M11311 o7 ibias vss vss sky130_fd_pr__nfet_01v8 L=0.5u W=1u
M11312 o7 ibias vss vss sky130_fd_pr__nfet_01v8 L=0.5u W=1u
M11313 o7 ibias vss vss sky130_fd_pr__nfet_01v8 L=0.5u W=1u
M11314 o7 ibias vss vss sky130_fd_pr__nfet_01v8 L=0.5u W=1u
M11315 o7 ibias vss vss sky130_fd_pr__nfet_01v8 L=0.5u W=1u
M11316 o7 ibias vss vss sky130_fd_pr__nfet_01v8 L=0.5u W=1u
M11317 o7 ibias vss vss sky130_fd_pr__nfet_01v8 L=0.5u W=1u
M11318 o7 ibias vss vss sky130_fd_pr__nfet_01v8 L=0.5u W=1u
M11319 o7 ibias vss vss sky130_fd_pr__nfet_01v8 L=0.5u W=1u
M11320 o7 ibias vss vss sky130_fd_pr__nfet_01v8 L=0.5u W=1u
M11321 o7 ibias vss vss sky130_fd_pr__nfet_01v8 L=0.5u W=1u
M11322 o7 ibias vss vss sky130_fd_pr__nfet_01v8 L=0.5u W=1u
M11323 o7 ibias vss vss sky130_fd_pr__nfet_01v8 L=0.5u W=1u
M11324 o7 ibias vss vss sky130_fd_pr__nfet_01v8 L=0.5u W=1u
M11325 o7 ibias vss vss sky130_fd_pr__nfet_01v8 L=0.5u W=1u
M11326 o7 ibias vss vss sky130_fd_pr__nfet_01v8 L=0.5u W=1u
M11327 o7 ibias vss vss sky130_fd_pr__nfet_01v8 L=0.5u W=1u
M11328 o7 ibias vss vss sky130_fd_pr__nfet_01v8 L=0.5u W=1u
M11329 o7 ibias vss vss sky130_fd_pr__nfet_01v8 L=0.5u W=1u
M11330 o7 ibias vss vss sky130_fd_pr__nfet_01v8 L=0.5u W=1u
M11331 o7 ibias vss vss sky130_fd_pr__nfet_01v8 L=0.5u W=1u
M11332 o7 ibias vss vss sky130_fd_pr__nfet_01v8 L=0.5u W=1u
M11333 o7 ibias vss vss sky130_fd_pr__nfet_01v8 L=0.5u W=1u
M11334 o7 ibias vss vss sky130_fd_pr__nfet_01v8 L=0.5u W=1u
M11335 o7 ibias vss vss sky130_fd_pr__nfet_01v8 L=0.5u W=1u
M11336 o7 ibias vss vss sky130_fd_pr__nfet_01v8 L=0.5u W=1u
M11337 o7 ibias vss vss sky130_fd_pr__nfet_01v8 L=0.5u W=1u
M11338 o7 ibias vss vss sky130_fd_pr__nfet_01v8 L=0.5u W=1u
M11339 o7 ibias vss vss sky130_fd_pr__nfet_01v8 L=0.5u W=1u
M11340 o7 ibias vss vss sky130_fd_pr__nfet_01v8 L=0.5u W=1u
M11341 o7 ibias vss vss sky130_fd_pr__nfet_01v8 L=0.5u W=1u
M11342 o7 ibias vss vss sky130_fd_pr__nfet_01v8 L=0.5u W=1u
M11343 o7 ibias vss vss sky130_fd_pr__nfet_01v8 L=0.5u W=1u
M11344 o7 ibias vss vss sky130_fd_pr__nfet_01v8 L=0.5u W=1u
M11345 o7 ibias vss vss sky130_fd_pr__nfet_01v8 L=0.5u W=1u
M11346 o7 ibias vss vss sky130_fd_pr__nfet_01v8 L=0.5u W=1u
M11347 o7 ibias vss vss sky130_fd_pr__nfet_01v8 L=0.5u W=1u
M11348 o7 ibias vss vss sky130_fd_pr__nfet_01v8 L=0.5u W=1u
M11349 o7 ibias vss vss sky130_fd_pr__nfet_01v8 L=0.5u W=1u
M11350 o7 ibias vss vss sky130_fd_pr__nfet_01v8 L=0.5u W=1u
M11351 o7 ibias vss vss sky130_fd_pr__nfet_01v8 L=0.5u W=1u
M11352 o7 ibias vss vss sky130_fd_pr__nfet_01v8 L=0.5u W=1u
M11353 o7 ibias vss vss sky130_fd_pr__nfet_01v8 L=0.5u W=1u
M11354 o7 ibias vss vss sky130_fd_pr__nfet_01v8 L=0.5u W=1u
M11355 o7 ibias vss vss sky130_fd_pr__nfet_01v8 L=0.5u W=1u
M11356 o7 ibias vss vss sky130_fd_pr__nfet_01v8 L=0.5u W=1u
M11357 o7 ibias vss vss sky130_fd_pr__nfet_01v8 L=0.5u W=1u
M11358 o7 ibias vss vss sky130_fd_pr__nfet_01v8 L=0.5u W=1u
M11359 o7 ibias vss vss sky130_fd_pr__nfet_01v8 L=0.5u W=1u
M11360 o7 ibias vss vss sky130_fd_pr__nfet_01v8 L=0.5u W=1u
M11361 o7 ibias vss vss sky130_fd_pr__nfet_01v8 L=0.5u W=1u
M11362 o7 ibias vss vss sky130_fd_pr__nfet_01v8 L=0.5u W=1u
M11363 o7 ibias vss vss sky130_fd_pr__nfet_01v8 L=0.5u W=1u
M11364 o7 ibias vss vss sky130_fd_pr__nfet_01v8 L=0.5u W=1u
M11365 o7 ibias vss vss sky130_fd_pr__nfet_01v8 L=0.5u W=1u
M11366 o7 ibias vss vss sky130_fd_pr__nfet_01v8 L=0.5u W=1u
M11367 o7 ibias vss vss sky130_fd_pr__nfet_01v8 L=0.5u W=1u
M11368 o7 ibias vss vss sky130_fd_pr__nfet_01v8 L=0.5u W=1u
M11369 o7 ibias vss vss sky130_fd_pr__nfet_01v8 L=0.5u W=1u
M11370 o7 ibias vss vss sky130_fd_pr__nfet_01v8 L=0.5u W=1u
M11371 o7 ibias vss vss sky130_fd_pr__nfet_01v8 L=0.5u W=1u
M11372 o7 ibias vss vss sky130_fd_pr__nfet_01v8 L=0.5u W=1u
M11373 o7 ibias vss vss sky130_fd_pr__nfet_01v8 L=0.5u W=1u
M11374 o7 ibias vss vss sky130_fd_pr__nfet_01v8 L=0.5u W=1u
M11375 o7 ibias vss vss sky130_fd_pr__nfet_01v8 L=0.5u W=1u
M11376 o7 ibias vss vss sky130_fd_pr__nfet_01v8 L=0.5u W=1u
M11377 o7 ibias vss vss sky130_fd_pr__nfet_01v8 L=0.5u W=1u
M11378 o7 ibias vss vss sky130_fd_pr__nfet_01v8 L=0.5u W=1u
M11379 o7 ibias vss vss sky130_fd_pr__nfet_01v8 L=0.5u W=1u
M11380 o7 ibias vss vss sky130_fd_pr__nfet_01v8 L=0.5u W=1u
M11381 o7 ibias vss vss sky130_fd_pr__nfet_01v8 L=0.5u W=1u
M11382 o7 ibias vss vss sky130_fd_pr__nfet_01v8 L=0.5u W=1u
M11383 o7 ibias vss vss sky130_fd_pr__nfet_01v8 L=0.5u W=1u
M11384 o7 ibias vss vss sky130_fd_pr__nfet_01v8 L=0.5u W=1u
M11385 o7 ibias vss vss sky130_fd_pr__nfet_01v8 L=0.5u W=1u
M11386 o7 ibias vss vss sky130_fd_pr__nfet_01v8 L=0.5u W=1u
M11387 o7 ibias vss vss sky130_fd_pr__nfet_01v8 L=0.5u W=1u
M11388 o7 ibias vss vss sky130_fd_pr__nfet_01v8 L=0.5u W=1u
M11389 o7 ibias vss vss sky130_fd_pr__nfet_01v8 L=0.5u W=1u
M11390 o7 ibias vss vss sky130_fd_pr__nfet_01v8 L=0.5u W=1u
M11391 o7 ibias vss vss sky130_fd_pr__nfet_01v8 L=0.5u W=1u
M11392 o7 ibias vss vss sky130_fd_pr__nfet_01v8 L=0.5u W=1u
M11393 o7 ibias vss vss sky130_fd_pr__nfet_01v8 L=0.5u W=1u
M11394 o7 ibias vss vss sky130_fd_pr__nfet_01v8 L=0.5u W=1u
M11395 o7 ibias vss vss sky130_fd_pr__nfet_01v8 L=0.5u W=1u
M11396 o7 ibias vss vss sky130_fd_pr__nfet_01v8 L=0.5u W=1u
M11397 o7 ibias vss vss sky130_fd_pr__nfet_01v8 L=0.5u W=1u
M11398 o7 ibias vss vss sky130_fd_pr__nfet_01v8 L=0.5u W=1u
M11399 o7 ibias vss vss sky130_fd_pr__nfet_01v8 L=0.5u W=1u
M11400 o7 ibias vss vss sky130_fd_pr__nfet_01v8 L=0.5u W=1u
M11401 o7 ibias vss vss sky130_fd_pr__nfet_01v8 L=0.5u W=1u
M11402 o7 ibias vss vss sky130_fd_pr__nfet_01v8 L=0.5u W=1u
M11403 o7 ibias vss vss sky130_fd_pr__nfet_01v8 L=0.5u W=1u
M11404 o7 ibias vss vss sky130_fd_pr__nfet_01v8 L=0.5u W=1u
M11405 o7 ibias vss vss sky130_fd_pr__nfet_01v8 L=0.5u W=1u
M11406 o7 ibias vss vss sky130_fd_pr__nfet_01v8 L=0.5u W=1u
M11407 o7 ibias vss vss sky130_fd_pr__nfet_01v8 L=0.5u W=1u
M11408 o7 ibias vss vss sky130_fd_pr__nfet_01v8 L=0.5u W=1u
M11409 o7 ibias vss vss sky130_fd_pr__nfet_01v8 L=0.5u W=1u
M11410 o7 ibias vss vss sky130_fd_pr__nfet_01v8 L=0.5u W=1u
M11411 o7 ibias vss vss sky130_fd_pr__nfet_01v8 L=0.5u W=1u
M11412 o7 ibias vss vss sky130_fd_pr__nfet_01v8 L=0.5u W=1u
M11413 o7 ibias vss vss sky130_fd_pr__nfet_01v8 L=0.5u W=1u
M11414 o7 ibias vss vss sky130_fd_pr__nfet_01v8 L=0.5u W=1u
M11415 o7 ibias vss vss sky130_fd_pr__nfet_01v8 L=0.5u W=1u
M11416 o7 ibias vss vss sky130_fd_pr__nfet_01v8 L=0.5u W=1u
M11417 o7 ibias vss vss sky130_fd_pr__nfet_01v8 L=0.5u W=1u
M11418 o7 ibias vss vss sky130_fd_pr__nfet_01v8 L=0.5u W=1u
M11419 o7 ibias vss vss sky130_fd_pr__nfet_01v8 L=0.5u W=1u
M11420 o7 ibias vss vss sky130_fd_pr__nfet_01v8 L=0.5u W=1u
M11421 o7 ibias vss vss sky130_fd_pr__nfet_01v8 L=0.5u W=1u
M11422 o7 ibias vss vss sky130_fd_pr__nfet_01v8 L=0.5u W=1u
M11423 o7 ibias vss vss sky130_fd_pr__nfet_01v8 L=0.5u W=1u
M11424 o7 ibias vss vss sky130_fd_pr__nfet_01v8 L=0.5u W=1u
M11425 o7 ibias vss vss sky130_fd_pr__nfet_01v8 L=0.5u W=1u
M11426 o7 ibias vss vss sky130_fd_pr__nfet_01v8 L=0.5u W=1u
M11427 o7 ibias vss vss sky130_fd_pr__nfet_01v8 L=0.5u W=1u
M11428 o7 ibias vss vss sky130_fd_pr__nfet_01v8 L=0.5u W=1u
M11429 o7 ibias vss vss sky130_fd_pr__nfet_01v8 L=0.5u W=1u
M11430 o7 ibias vss vss sky130_fd_pr__nfet_01v8 L=0.5u W=1u
M11431 o7 ibias vss vss sky130_fd_pr__nfet_01v8 L=0.5u W=1u
M11432 o7 ibias vss vss sky130_fd_pr__nfet_01v8 L=0.5u W=1u
M11433 o7 ibias vss vss sky130_fd_pr__nfet_01v8 L=0.5u W=1u
M11434 o7 ibias vss vss sky130_fd_pr__nfet_01v8 L=0.5u W=1u
M11435 o7 ibias vss vss sky130_fd_pr__nfet_01v8 L=0.5u W=1u
M11436 o7 ibias vss vss sky130_fd_pr__nfet_01v8 L=0.5u W=1u
M11437 o7 ibias vss vss sky130_fd_pr__nfet_01v8 L=0.5u W=1u
M11438 o7 ibias vss vss sky130_fd_pr__nfet_01v8 L=0.5u W=1u
M11439 o7 ibias vss vss sky130_fd_pr__nfet_01v8 L=0.5u W=1u
M11440 o7 ibias vss vss sky130_fd_pr__nfet_01v8 L=0.5u W=1u
M11441 o7 ibias vss vss sky130_fd_pr__nfet_01v8 L=0.5u W=1u
M11442 o7 ibias vss vss sky130_fd_pr__nfet_01v8 L=0.5u W=1u
M11443 o7 ibias vss vss sky130_fd_pr__nfet_01v8 L=0.5u W=1u
M11444 o7 ibias vss vss sky130_fd_pr__nfet_01v8 L=0.5u W=1u
M11445 o7 ibias vss vss sky130_fd_pr__nfet_01v8 L=0.5u W=1u
M11446 o7 ibias vss vss sky130_fd_pr__nfet_01v8 L=0.5u W=1u
M11447 o7 ibias vss vss sky130_fd_pr__nfet_01v8 L=0.5u W=1u
M11448 o7 ibias vss vss sky130_fd_pr__nfet_01v8 L=0.5u W=1u
M11449 o7 ibias vss vss sky130_fd_pr__nfet_01v8 L=0.5u W=1u
M11450 o7 ibias vss vss sky130_fd_pr__nfet_01v8 L=0.5u W=1u
M11451 o7 ibias vss vss sky130_fd_pr__nfet_01v8 L=0.5u W=1u
M11452 o7 ibias vss vss sky130_fd_pr__nfet_01v8 L=0.5u W=1u
M11453 o7 ibias vss vss sky130_fd_pr__nfet_01v8 L=0.5u W=1u
M11454 o7 ibias vss vss sky130_fd_pr__nfet_01v8 L=0.5u W=1u
M11455 o7 ibias vss vss sky130_fd_pr__nfet_01v8 L=0.5u W=1u
M11456 o7 ibias vss vss sky130_fd_pr__nfet_01v8 L=0.5u W=1u
M11457 o7 ibias vss vss sky130_fd_pr__nfet_01v8 L=0.5u W=1u
M11458 o7 ibias vss vss sky130_fd_pr__nfet_01v8 L=0.5u W=1u
M11459 o7 ibias vss vss sky130_fd_pr__nfet_01v8 L=0.5u W=1u
M11460 o7 ibias vss vss sky130_fd_pr__nfet_01v8 L=0.5u W=1u
M11461 o7 ibias vss vss sky130_fd_pr__nfet_01v8 L=0.5u W=1u
M11462 o7 ibias vss vss sky130_fd_pr__nfet_01v8 L=0.5u W=1u
M11463 o7 ibias vss vss sky130_fd_pr__nfet_01v8 L=0.5u W=1u
M11464 o7 ibias vss vss sky130_fd_pr__nfet_01v8 L=0.5u W=1u
M11465 o7 ibias vss vss sky130_fd_pr__nfet_01v8 L=0.5u W=1u
M11466 o7 ibias vss vss sky130_fd_pr__nfet_01v8 L=0.5u W=1u
M11467 o7 ibias vss vss sky130_fd_pr__nfet_01v8 L=0.5u W=1u
M11468 o7 ibias vss vss sky130_fd_pr__nfet_01v8 L=0.5u W=1u
M11469 o7 ibias vss vss sky130_fd_pr__nfet_01v8 L=0.5u W=1u
M11470 o7 ibias vss vss sky130_fd_pr__nfet_01v8 L=0.5u W=1u
M11471 o7 ibias vss vss sky130_fd_pr__nfet_01v8 L=0.5u W=1u
M11472 o7 ibias vss vss sky130_fd_pr__nfet_01v8 L=0.5u W=1u
M11473 o7 ibias vss vss sky130_fd_pr__nfet_01v8 L=0.5u W=1u
M11474 o7 ibias vss vss sky130_fd_pr__nfet_01v8 L=0.5u W=1u
M11475 o7 ibias vss vss sky130_fd_pr__nfet_01v8 L=0.5u W=1u
M11476 o7 ibias vss vss sky130_fd_pr__nfet_01v8 L=0.5u W=1u
M11477 o7 ibias vss vss sky130_fd_pr__nfet_01v8 L=0.5u W=1u
M11478 o7 ibias vss vss sky130_fd_pr__nfet_01v8 L=0.5u W=1u
M11479 o7 ibias vss vss sky130_fd_pr__nfet_01v8 L=0.5u W=1u
M11480 o7 ibias vss vss sky130_fd_pr__nfet_01v8 L=0.5u W=1u
M11481 o7 ibias vss vss sky130_fd_pr__nfet_01v8 L=0.5u W=1u
M11482 o7 ibias vss vss sky130_fd_pr__nfet_01v8 L=0.5u W=1u
M11483 o7 ibias vss vss sky130_fd_pr__nfet_01v8 L=0.5u W=1u
M11484 o7 ibias vss vss sky130_fd_pr__nfet_01v8 L=0.5u W=1u
M11485 o7 ibias vss vss sky130_fd_pr__nfet_01v8 L=0.5u W=1u
M11486 o7 ibias vss vss sky130_fd_pr__nfet_01v8 L=0.5u W=1u
M11487 o7 ibias vss vss sky130_fd_pr__nfet_01v8 L=0.5u W=1u
M11488 o7 ibias vss vss sky130_fd_pr__nfet_01v8 L=0.5u W=1u
M11489 o7 ibias vss vss sky130_fd_pr__nfet_01v8 L=0.5u W=1u
M11490 o7 ibias vss vss sky130_fd_pr__nfet_01v8 L=0.5u W=1u
M11491 o7 ibias vss vss sky130_fd_pr__nfet_01v8 L=0.5u W=1u
M11492 o7 ibias vss vss sky130_fd_pr__nfet_01v8 L=0.5u W=1u
M11493 o7 ibias vss vss sky130_fd_pr__nfet_01v8 L=0.5u W=1u
M11494 o7 ibias vss vss sky130_fd_pr__nfet_01v8 L=0.5u W=1u
M11495 o7 ibias vss vss sky130_fd_pr__nfet_01v8 L=0.5u W=1u
M11496 o7 ibias vss vss sky130_fd_pr__nfet_01v8 L=0.5u W=1u
M11497 o7 ibias vss vss sky130_fd_pr__nfet_01v8 L=0.5u W=1u
M11498 o7 ibias vss vss sky130_fd_pr__nfet_01v8 L=0.5u W=1u
M11499 o7 ibias vss vss sky130_fd_pr__nfet_01v8 L=0.5u W=1u
M11500 o7 ibias vss vss sky130_fd_pr__nfet_01v8 L=0.5u W=1u
M11501 o7 ibias vss vss sky130_fd_pr__nfet_01v8 L=0.5u W=1u
M11502 o7 ibias vss vss sky130_fd_pr__nfet_01v8 L=0.5u W=1u
M11503 o7 ibias vss vss sky130_fd_pr__nfet_01v8 L=0.5u W=1u
M11504 o7 ibias vss vss sky130_fd_pr__nfet_01v8 L=0.5u W=1u
M11505 o7 ibias vss vss sky130_fd_pr__nfet_01v8 L=0.5u W=1u
M11506 o7 ibias vss vss sky130_fd_pr__nfet_01v8 L=0.5u W=1u
M11507 o7 ibias vss vss sky130_fd_pr__nfet_01v8 L=0.5u W=1u
M11508 o7 ibias vss vss sky130_fd_pr__nfet_01v8 L=0.5u W=1u
M11509 o7 ibias vss vss sky130_fd_pr__nfet_01v8 L=0.5u W=1u
M11510 o7 ibias vss vss sky130_fd_pr__nfet_01v8 L=0.5u W=1u
M11511 o7 ibias vss vss sky130_fd_pr__nfet_01v8 L=0.5u W=1u
M11512 o7 ibias vss vss sky130_fd_pr__nfet_01v8 L=0.5u W=1u
M11513 o7 ibias vss vss sky130_fd_pr__nfet_01v8 L=0.5u W=1u
M11514 o7 ibias vss vss sky130_fd_pr__nfet_01v8 L=0.5u W=1u
M11515 o7 ibias vss vss sky130_fd_pr__nfet_01v8 L=0.5u W=1u
M11516 o7 ibias vss vss sky130_fd_pr__nfet_01v8 L=0.5u W=1u
M11517 o7 ibias vss vss sky130_fd_pr__nfet_01v8 L=0.5u W=1u
M11518 o7 ibias vss vss sky130_fd_pr__nfet_01v8 L=0.5u W=1u
M11519 o7 ibias vss vss sky130_fd_pr__nfet_01v8 L=0.5u W=1u
M11520 o7 ibias vss vss sky130_fd_pr__nfet_01v8 L=0.5u W=1u
M11521 o7 ibias vss vss sky130_fd_pr__nfet_01v8 L=0.5u W=1u
M11522 o7 ibias vss vss sky130_fd_pr__nfet_01v8 L=0.5u W=1u
M11523 o7 ibias vss vss sky130_fd_pr__nfet_01v8 L=0.5u W=1u
M11524 o7 ibias vss vss sky130_fd_pr__nfet_01v8 L=0.5u W=1u
M11525 o7 ibias vss vss sky130_fd_pr__nfet_01v8 L=0.5u W=1u
M11526 o7 ibias vss vss sky130_fd_pr__nfet_01v8 L=0.5u W=1u
M11527 o7 ibias vss vss sky130_fd_pr__nfet_01v8 L=0.5u W=1u
M11528 o7 ibias vss vss sky130_fd_pr__nfet_01v8 L=0.5u W=1u
M11529 o7 ibias vss vss sky130_fd_pr__nfet_01v8 L=0.5u W=1u
M11530 o7 ibias vss vss sky130_fd_pr__nfet_01v8 L=0.5u W=1u
M11531 o7 ibias vss vss sky130_fd_pr__nfet_01v8 L=0.5u W=1u
M11532 o7 ibias vss vss sky130_fd_pr__nfet_01v8 L=0.5u W=1u
M11533 o7 ibias vss vss sky130_fd_pr__nfet_01v8 L=0.5u W=1u
M11534 o7 ibias vss vss sky130_fd_pr__nfet_01v8 L=0.5u W=1u
M11535 o7 ibias vss vss sky130_fd_pr__nfet_01v8 L=0.5u W=1u
M11536 o7 ibias vss vss sky130_fd_pr__nfet_01v8 L=0.5u W=1u
M11537 o7 ibias vss vss sky130_fd_pr__nfet_01v8 L=0.5u W=1u
M11538 o7 ibias vss vss sky130_fd_pr__nfet_01v8 L=0.5u W=1u
M11539 o7 ibias vss vss sky130_fd_pr__nfet_01v8 L=0.5u W=1u
M11540 o7 ibias vss vss sky130_fd_pr__nfet_01v8 L=0.5u W=1u
M11541 o7 ibias vss vss sky130_fd_pr__nfet_01v8 L=0.5u W=1u
M11542 o7 ibias vss vss sky130_fd_pr__nfet_01v8 L=0.5u W=1u
M11543 o7 ibias vss vss sky130_fd_pr__nfet_01v8 L=0.5u W=1u
M11544 o7 ibias vss vss sky130_fd_pr__nfet_01v8 L=0.5u W=1u
M11545 o7 ibias vss vss sky130_fd_pr__nfet_01v8 L=0.5u W=1u
M11546 o7 ibias vss vss sky130_fd_pr__nfet_01v8 L=0.5u W=1u
M11547 o7 ibias vss vss sky130_fd_pr__nfet_01v8 L=0.5u W=1u
M11548 o7 ibias vss vss sky130_fd_pr__nfet_01v8 L=0.5u W=1u
M11549 o7 ibias vss vss sky130_fd_pr__nfet_01v8 L=0.5u W=1u
M11550 o7 ibias vss vss sky130_fd_pr__nfet_01v8 L=0.5u W=1u
M11551 o7 ibias vss vss sky130_fd_pr__nfet_01v8 L=0.5u W=1u
M11552 o7 ibias vss vss sky130_fd_pr__nfet_01v8 L=0.5u W=1u
M11553 o7 ibias vss vss sky130_fd_pr__nfet_01v8 L=0.5u W=1u
M11554 o7 ibias vss vss sky130_fd_pr__nfet_01v8 L=0.5u W=1u
M11555 o7 ibias vss vss sky130_fd_pr__nfet_01v8 L=0.5u W=1u
M11556 o7 ibias vss vss sky130_fd_pr__nfet_01v8 L=0.5u W=1u
M11557 o7 ibias vss vss sky130_fd_pr__nfet_01v8 L=0.5u W=1u
M11558 o7 ibias vss vss sky130_fd_pr__nfet_01v8 L=0.5u W=1u
M11559 o7 ibias vss vss sky130_fd_pr__nfet_01v8 L=0.5u W=1u
M11560 o7 ibias vss vss sky130_fd_pr__nfet_01v8 L=0.5u W=1u
M11561 o7 ibias vss vss sky130_fd_pr__nfet_01v8 L=0.5u W=1u
M11562 o7 ibias vss vss sky130_fd_pr__nfet_01v8 L=0.5u W=1u
M11563 o7 ibias vss vss sky130_fd_pr__nfet_01v8 L=0.5u W=1u
M11564 o7 ibias vss vss sky130_fd_pr__nfet_01v8 L=0.5u W=1u
M11565 o7 ibias vss vss sky130_fd_pr__nfet_01v8 L=0.5u W=1u
M11566 o7 ibias vss vss sky130_fd_pr__nfet_01v8 L=0.5u W=1u
M11567 o7 ibias vss vss sky130_fd_pr__nfet_01v8 L=0.5u W=1u
M11568 o7 ibias vss vss sky130_fd_pr__nfet_01v8 L=0.5u W=1u
M11569 o7 ibias vss vss sky130_fd_pr__nfet_01v8 L=0.5u W=1u
M11570 o7 ibias vss vss sky130_fd_pr__nfet_01v8 L=0.5u W=1u
M11571 o7 ibias vss vss sky130_fd_pr__nfet_01v8 L=0.5u W=1u
M11572 o7 ibias vss vss sky130_fd_pr__nfet_01v8 L=0.5u W=1u
M11573 o7 ibias vss vss sky130_fd_pr__nfet_01v8 L=0.5u W=1u
M11574 o7 ibias vss vss sky130_fd_pr__nfet_01v8 L=0.5u W=1u
M11575 o7 ibias vss vss sky130_fd_pr__nfet_01v8 L=0.5u W=1u
M11576 o7 ibias vss vss sky130_fd_pr__nfet_01v8 L=0.5u W=1u
M11577 o7 ibias vss vss sky130_fd_pr__nfet_01v8 L=0.5u W=1u
M11578 o7 ibias vss vss sky130_fd_pr__nfet_01v8 L=0.5u W=1u
M11579 o7 ibias vss vss sky130_fd_pr__nfet_01v8 L=0.5u W=1u
M11580 o7 ibias vss vss sky130_fd_pr__nfet_01v8 L=0.5u W=1u
M11581 o7 ibias vss vss sky130_fd_pr__nfet_01v8 L=0.5u W=1u
M11582 o7 ibias vss vss sky130_fd_pr__nfet_01v8 L=0.5u W=1u
M11583 o7 ibias vss vss sky130_fd_pr__nfet_01v8 L=0.5u W=1u
M11584 o7 ibias vss vss sky130_fd_pr__nfet_01v8 L=0.5u W=1u
M11585 o7 ibias vss vss sky130_fd_pr__nfet_01v8 L=0.5u W=1u
M11586 o7 ibias vss vss sky130_fd_pr__nfet_01v8 L=0.5u W=1u
M11587 o7 ibias vss vss sky130_fd_pr__nfet_01v8 L=0.5u W=1u
M11588 o7 ibias vss vss sky130_fd_pr__nfet_01v8 L=0.5u W=1u
M11589 o7 ibias vss vss sky130_fd_pr__nfet_01v8 L=0.5u W=1u
M11590 o7 ibias vss vss sky130_fd_pr__nfet_01v8 L=0.5u W=1u
M11591 o7 ibias vss vss sky130_fd_pr__nfet_01v8 L=0.5u W=1u
M11592 o7 ibias vss vss sky130_fd_pr__nfet_01v8 L=0.5u W=1u
M11593 o7 ibias vss vss sky130_fd_pr__nfet_01v8 L=0.5u W=1u
M11594 o7 ibias vss vss sky130_fd_pr__nfet_01v8 L=0.5u W=1u
M11595 o7 ibias vss vss sky130_fd_pr__nfet_01v8 L=0.5u W=1u
M11596 o7 ibias vss vss sky130_fd_pr__nfet_01v8 L=0.5u W=1u
M11597 o7 ibias vss vss sky130_fd_pr__nfet_01v8 L=0.5u W=1u
M11598 o7 ibias vss vss sky130_fd_pr__nfet_01v8 L=0.5u W=1u
M11599 o7 ibias vss vss sky130_fd_pr__nfet_01v8 L=0.5u W=1u
M11600 o7 ibias vss vss sky130_fd_pr__nfet_01v8 L=0.5u W=1u
M11601 o7 ibias vss vss sky130_fd_pr__nfet_01v8 L=0.5u W=1u
M11602 o7 ibias vss vss sky130_fd_pr__nfet_01v8 L=0.5u W=1u
M11603 o7 ibias vss vss sky130_fd_pr__nfet_01v8 L=0.5u W=1u
M11604 o7 ibias vss vss sky130_fd_pr__nfet_01v8 L=0.5u W=1u
M11605 o7 ibias vss vss sky130_fd_pr__nfet_01v8 L=0.5u W=1u
M11606 o7 ibias vss vss sky130_fd_pr__nfet_01v8 L=0.5u W=1u
M11607 o7 ibias vss vss sky130_fd_pr__nfet_01v8 L=0.5u W=1u
M11608 o7 ibias vss vss sky130_fd_pr__nfet_01v8 L=0.5u W=1u
M11609 o7 ibias vss vss sky130_fd_pr__nfet_01v8 L=0.5u W=1u
M11610 o7 ibias vss vss sky130_fd_pr__nfet_01v8 L=0.5u W=1u
M11611 o7 ibias vss vss sky130_fd_pr__nfet_01v8 L=0.5u W=1u
M11612 o7 ibias vss vss sky130_fd_pr__nfet_01v8 L=0.5u W=1u
M11613 o7 ibias vss vss sky130_fd_pr__nfet_01v8 L=0.5u W=1u
M11614 o7 ibias vss vss sky130_fd_pr__nfet_01v8 L=0.5u W=1u
M11615 o7 ibias vss vss sky130_fd_pr__nfet_01v8 L=0.5u W=1u
M11616 o7 ibias vss vss sky130_fd_pr__nfet_01v8 L=0.5u W=1u
M11617 o7 ibias vss vss sky130_fd_pr__nfet_01v8 L=0.5u W=1u
M11618 o7 ibias vss vss sky130_fd_pr__nfet_01v8 L=0.5u W=1u
M11619 o7 ibias vss vss sky130_fd_pr__nfet_01v8 L=0.5u W=1u
M11620 o7 ibias vss vss sky130_fd_pr__nfet_01v8 L=0.5u W=1u
M11621 o7 ibias vss vss sky130_fd_pr__nfet_01v8 L=0.5u W=1u
M11622 o7 ibias vss vss sky130_fd_pr__nfet_01v8 L=0.5u W=1u
M11623 o7 ibias vss vss sky130_fd_pr__nfet_01v8 L=0.5u W=1u
M11624 o7 ibias vss vss sky130_fd_pr__nfet_01v8 L=0.5u W=1u
M11625 o7 ibias vss vss sky130_fd_pr__nfet_01v8 L=0.5u W=1u
M11626 o7 ibias vss vss sky130_fd_pr__nfet_01v8 L=0.5u W=1u
M11627 o7 ibias vss vss sky130_fd_pr__nfet_01v8 L=0.5u W=1u
M11628 o7 ibias vss vss sky130_fd_pr__nfet_01v8 L=0.5u W=1u
M11629 o7 ibias vss vss sky130_fd_pr__nfet_01v8 L=0.5u W=1u
M11630 o7 ibias vss vss sky130_fd_pr__nfet_01v8 L=0.5u W=1u
M11631 o7 ibias vss vss sky130_fd_pr__nfet_01v8 L=0.5u W=1u
M11632 o7 ibias vss vss sky130_fd_pr__nfet_01v8 L=0.5u W=1u
M11633 o7 ibias vss vss sky130_fd_pr__nfet_01v8 L=0.5u W=1u
M11634 o7 ibias vss vss sky130_fd_pr__nfet_01v8 L=0.5u W=1u
M11635 o7 ibias vss vss sky130_fd_pr__nfet_01v8 L=0.5u W=1u
M11636 o7 ibias vss vss sky130_fd_pr__nfet_01v8 L=0.5u W=1u
M11637 o7 ibias vss vss sky130_fd_pr__nfet_01v8 L=0.5u W=1u
M11638 o7 ibias vss vss sky130_fd_pr__nfet_01v8 L=0.5u W=1u
M11639 o7 ibias vss vss sky130_fd_pr__nfet_01v8 L=0.5u W=1u
M11640 o7 ibias vss vss sky130_fd_pr__nfet_01v8 L=0.5u W=1u
M11641 o7 ibias vss vss sky130_fd_pr__nfet_01v8 L=0.5u W=1u
M11642 o7 ibias vss vss sky130_fd_pr__nfet_01v8 L=0.5u W=1u
M11643 o7 ibias vss vss sky130_fd_pr__nfet_01v8 L=0.5u W=1u
M11644 o7 ibias vss vss sky130_fd_pr__nfet_01v8 L=0.5u W=1u
M11645 o7 ibias vss vss sky130_fd_pr__nfet_01v8 L=0.5u W=1u
M11646 o7 ibias vss vss sky130_fd_pr__nfet_01v8 L=0.5u W=1u
M11647 o7 ibias vss vss sky130_fd_pr__nfet_01v8 L=0.5u W=1u
M11648 o7 ibias vss vss sky130_fd_pr__nfet_01v8 L=0.5u W=1u
M11649 o7 ibias vss vss sky130_fd_pr__nfet_01v8 L=0.5u W=1u
M11650 o7 ibias vss vss sky130_fd_pr__nfet_01v8 L=0.5u W=1u
M11651 o7 ibias vss vss sky130_fd_pr__nfet_01v8 L=0.5u W=1u
M11652 o7 ibias vss vss sky130_fd_pr__nfet_01v8 L=0.5u W=1u
M11653 o7 ibias vss vss sky130_fd_pr__nfet_01v8 L=0.5u W=1u
M11654 o7 ibias vss vss sky130_fd_pr__nfet_01v8 L=0.5u W=1u
M11655 o7 ibias vss vss sky130_fd_pr__nfet_01v8 L=0.5u W=1u
M11656 o7 ibias vss vss sky130_fd_pr__nfet_01v8 L=0.5u W=1u
M11657 o7 ibias vss vss sky130_fd_pr__nfet_01v8 L=0.5u W=1u
M11658 o7 ibias vss vss sky130_fd_pr__nfet_01v8 L=0.5u W=1u
M11659 o7 ibias vss vss sky130_fd_pr__nfet_01v8 L=0.5u W=1u
M11660 o7 ibias vss vss sky130_fd_pr__nfet_01v8 L=0.5u W=1u
M11661 o7 ibias vss vss sky130_fd_pr__nfet_01v8 L=0.5u W=1u
M11662 o7 ibias vss vss sky130_fd_pr__nfet_01v8 L=0.5u W=1u
M11663 o7 ibias vss vss sky130_fd_pr__nfet_01v8 L=0.5u W=1u
M11664 o7 ibias vss vss sky130_fd_pr__nfet_01v8 L=0.5u W=1u
M11665 o7 ibias vss vss sky130_fd_pr__nfet_01v8 L=0.5u W=1u
M11666 o7 ibias vss vss sky130_fd_pr__nfet_01v8 L=0.5u W=1u
M11667 o7 ibias vss vss sky130_fd_pr__nfet_01v8 L=0.5u W=1u
M11668 o7 ibias vss vss sky130_fd_pr__nfet_01v8 L=0.5u W=1u
M11669 o7 ibias vss vss sky130_fd_pr__nfet_01v8 L=0.5u W=1u
M11670 o7 ibias vss vss sky130_fd_pr__nfet_01v8 L=0.5u W=1u
M11671 o7 ibias vss vss sky130_fd_pr__nfet_01v8 L=0.5u W=1u
M11672 o7 ibias vss vss sky130_fd_pr__nfet_01v8 L=0.5u W=1u
M11673 o7 ibias vss vss sky130_fd_pr__nfet_01v8 L=0.5u W=1u
M11674 o7 ibias vss vss sky130_fd_pr__nfet_01v8 L=0.5u W=1u
M11675 o7 ibias vss vss sky130_fd_pr__nfet_01v8 L=0.5u W=1u
M11676 o7 ibias vss vss sky130_fd_pr__nfet_01v8 L=0.5u W=1u
M11677 o7 ibias vss vss sky130_fd_pr__nfet_01v8 L=0.5u W=1u
M11678 o7 ibias vss vss sky130_fd_pr__nfet_01v8 L=0.5u W=1u
M11679 o7 ibias vss vss sky130_fd_pr__nfet_01v8 L=0.5u W=1u
M11680 o7 ibias vss vss sky130_fd_pr__nfet_01v8 L=0.5u W=1u
M11681 o7 ibias vss vss sky130_fd_pr__nfet_01v8 L=0.5u W=1u
M11682 o7 ibias vss vss sky130_fd_pr__nfet_01v8 L=0.5u W=1u
M11683 o7 ibias vss vss sky130_fd_pr__nfet_01v8 L=0.5u W=1u
M11684 o7 ibias vss vss sky130_fd_pr__nfet_01v8 L=0.5u W=1u
M11685 o7 ibias vss vss sky130_fd_pr__nfet_01v8 L=0.5u W=1u
M11686 o7 ibias vss vss sky130_fd_pr__nfet_01v8 L=0.5u W=1u
M11687 o7 ibias vss vss sky130_fd_pr__nfet_01v8 L=0.5u W=1u
M11688 o7 ibias vss vss sky130_fd_pr__nfet_01v8 L=0.5u W=1u
M11689 o7 ibias vss vss sky130_fd_pr__nfet_01v8 L=0.5u W=1u
M11690 o7 ibias vss vss sky130_fd_pr__nfet_01v8 L=0.5u W=1u
M11691 o7 ibias vss vss sky130_fd_pr__nfet_01v8 L=0.5u W=1u
M11692 o7 ibias vss vss sky130_fd_pr__nfet_01v8 L=0.5u W=1u
M11693 o7 ibias vss vss sky130_fd_pr__nfet_01v8 L=0.5u W=1u
M11694 o7 ibias vss vss sky130_fd_pr__nfet_01v8 L=0.5u W=1u
M11695 o7 ibias vss vss sky130_fd_pr__nfet_01v8 L=0.5u W=1u
M11696 o7 ibias vss vss sky130_fd_pr__nfet_01v8 L=0.5u W=1u
M11697 o7 ibias vss vss sky130_fd_pr__nfet_01v8 L=0.5u W=1u
M11698 o7 ibias vss vss sky130_fd_pr__nfet_01v8 L=0.5u W=1u
M11699 o7 ibias vss vss sky130_fd_pr__nfet_01v8 L=0.5u W=1u
M11700 o7 ibias vss vss sky130_fd_pr__nfet_01v8 L=0.5u W=1u
M11701 o7 ibias vss vss sky130_fd_pr__nfet_01v8 L=0.5u W=1u
M11702 o7 ibias vss vss sky130_fd_pr__nfet_01v8 L=0.5u W=1u
M11703 o7 ibias vss vss sky130_fd_pr__nfet_01v8 L=0.5u W=1u
M11704 o7 ibias vss vss sky130_fd_pr__nfet_01v8 L=0.5u W=1u
M11705 o7 ibias vss vss sky130_fd_pr__nfet_01v8 L=0.5u W=1u
M11706 o7 ibias vss vss sky130_fd_pr__nfet_01v8 L=0.5u W=1u
M11707 o7 ibias vss vss sky130_fd_pr__nfet_01v8 L=0.5u W=1u
M11708 o7 ibias vss vss sky130_fd_pr__nfet_01v8 L=0.5u W=1u
M11709 o7 ibias vss vss sky130_fd_pr__nfet_01v8 L=0.5u W=1u
M11710 o7 ibias vss vss sky130_fd_pr__nfet_01v8 L=0.5u W=1u
M11711 o7 ibias vss vss sky130_fd_pr__nfet_01v8 L=0.5u W=1u
M11712 o7 ibias vss vss sky130_fd_pr__nfet_01v8 L=0.5u W=1u
M11713 o7 ibias vss vss sky130_fd_pr__nfet_01v8 L=0.5u W=1u
M11714 o7 ibias vss vss sky130_fd_pr__nfet_01v8 L=0.5u W=1u
M11715 o7 ibias vss vss sky130_fd_pr__nfet_01v8 L=0.5u W=1u
M11716 o7 ibias vss vss sky130_fd_pr__nfet_01v8 L=0.5u W=1u
M11717 o7 ibias vss vss sky130_fd_pr__nfet_01v8 L=0.5u W=1u
M11718 o7 ibias vss vss sky130_fd_pr__nfet_01v8 L=0.5u W=1u
M11719 o7 ibias vss vss sky130_fd_pr__nfet_01v8 L=0.5u W=1u
M11720 o7 ibias vss vss sky130_fd_pr__nfet_01v8 L=0.5u W=1u
M11721 o7 ibias vss vss sky130_fd_pr__nfet_01v8 L=0.5u W=1u
M11722 o7 ibias vss vss sky130_fd_pr__nfet_01v8 L=0.5u W=1u
M11723 o7 ibias vss vss sky130_fd_pr__nfet_01v8 L=0.5u W=1u
M11724 o7 ibias vss vss sky130_fd_pr__nfet_01v8 L=0.5u W=1u
M11725 o7 ibias vss vss sky130_fd_pr__nfet_01v8 L=0.5u W=1u
M11726 o7 ibias vss vss sky130_fd_pr__nfet_01v8 L=0.5u W=1u
M11727 o7 ibias vss vss sky130_fd_pr__nfet_01v8 L=0.5u W=1u
M11728 o7 ibias vss vss sky130_fd_pr__nfet_01v8 L=0.5u W=1u
M11729 o7 ibias vss vss sky130_fd_pr__nfet_01v8 L=0.5u W=1u
M11730 o7 ibias vss vss sky130_fd_pr__nfet_01v8 L=0.5u W=1u
M11731 o7 ibias vss vss sky130_fd_pr__nfet_01v8 L=0.5u W=1u
M11732 o7 ibias vss vss sky130_fd_pr__nfet_01v8 L=0.5u W=1u
M11733 o7 ibias vss vss sky130_fd_pr__nfet_01v8 L=0.5u W=1u
M11734 o7 ibias vss vss sky130_fd_pr__nfet_01v8 L=0.5u W=1u
M11735 o7 ibias vss vss sky130_fd_pr__nfet_01v8 L=0.5u W=1u
M11736 o7 ibias vss vss sky130_fd_pr__nfet_01v8 L=0.5u W=1u
M11737 o7 ibias vss vss sky130_fd_pr__nfet_01v8 L=0.5u W=1u
M11738 o7 ibias vss vss sky130_fd_pr__nfet_01v8 L=0.5u W=1u
M11739 o7 ibias vss vss sky130_fd_pr__nfet_01v8 L=0.5u W=1u
M11740 o7 ibias vss vss sky130_fd_pr__nfet_01v8 L=0.5u W=1u
M11741 o7 ibias vss vss sky130_fd_pr__nfet_01v8 L=0.5u W=1u
M11742 o7 ibias vss vss sky130_fd_pr__nfet_01v8 L=0.5u W=1u
M11743 o7 ibias vss vss sky130_fd_pr__nfet_01v8 L=0.5u W=1u
M11744 o7 ibias vss vss sky130_fd_pr__nfet_01v8 L=0.5u W=1u
M11745 o7 ibias vss vss sky130_fd_pr__nfet_01v8 L=0.5u W=1u
M11746 o7 ibias vss vss sky130_fd_pr__nfet_01v8 L=0.5u W=1u
M11747 o7 ibias vss vss sky130_fd_pr__nfet_01v8 L=0.5u W=1u
M11748 o7 ibias vss vss sky130_fd_pr__nfet_01v8 L=0.5u W=1u
M11749 o7 ibias vss vss sky130_fd_pr__nfet_01v8 L=0.5u W=1u
M11750 o7 ibias vss vss sky130_fd_pr__nfet_01v8 L=0.5u W=1u
M11751 o7 ibias vss vss sky130_fd_pr__nfet_01v8 L=0.5u W=1u
M11752 o7 ibias vss vss sky130_fd_pr__nfet_01v8 L=0.5u W=1u
M11753 o7 ibias vss vss sky130_fd_pr__nfet_01v8 L=0.5u W=1u
M11754 o7 ibias vss vss sky130_fd_pr__nfet_01v8 L=0.5u W=1u
M11755 o7 ibias vss vss sky130_fd_pr__nfet_01v8 L=0.5u W=1u
M11756 o7 ibias vss vss sky130_fd_pr__nfet_01v8 L=0.5u W=1u
M11757 o7 ibias vss vss sky130_fd_pr__nfet_01v8 L=0.5u W=1u
M11758 o7 ibias vss vss sky130_fd_pr__nfet_01v8 L=0.5u W=1u
M11759 o7 ibias vss vss sky130_fd_pr__nfet_01v8 L=0.5u W=1u
M11760 o7 ibias vss vss sky130_fd_pr__nfet_01v8 L=0.5u W=1u
M11761 o7 ibias vss vss sky130_fd_pr__nfet_01v8 L=0.5u W=1u
M11762 o7 ibias vss vss sky130_fd_pr__nfet_01v8 L=0.5u W=1u
M11763 o7 ibias vss vss sky130_fd_pr__nfet_01v8 L=0.5u W=1u
M11764 o7 ibias vss vss sky130_fd_pr__nfet_01v8 L=0.5u W=1u
M11765 o7 ibias vss vss sky130_fd_pr__nfet_01v8 L=0.5u W=1u
M11766 o7 ibias vss vss sky130_fd_pr__nfet_01v8 L=0.5u W=1u
M11767 o7 ibias vss vss sky130_fd_pr__nfet_01v8 L=0.5u W=1u
M11768 o7 ibias vss vss sky130_fd_pr__nfet_01v8 L=0.5u W=1u
M11769 o7 ibias vss vss sky130_fd_pr__nfet_01v8 L=0.5u W=1u
M11770 o7 ibias vss vss sky130_fd_pr__nfet_01v8 L=0.5u W=1u
M11771 o7 ibias vss vss sky130_fd_pr__nfet_01v8 L=0.5u W=1u
M11772 o7 ibias vss vss sky130_fd_pr__nfet_01v8 L=0.5u W=1u
M11773 o7 ibias vss vss sky130_fd_pr__nfet_01v8 L=0.5u W=1u
M11774 o7 ibias vss vss sky130_fd_pr__nfet_01v8 L=0.5u W=1u
M11775 o7 ibias vss vss sky130_fd_pr__nfet_01v8 L=0.5u W=1u
M11776 o7 ibias vss vss sky130_fd_pr__nfet_01v8 L=0.5u W=1u
M11777 o7 ibias vss vss sky130_fd_pr__nfet_01v8 L=0.5u W=1u
M11778 o7 ibias vss vss sky130_fd_pr__nfet_01v8 L=0.5u W=1u
M11779 o7 ibias vss vss sky130_fd_pr__nfet_01v8 L=0.5u W=1u
M11780 o7 ibias vss vss sky130_fd_pr__nfet_01v8 L=0.5u W=1u
M11781 o7 ibias vss vss sky130_fd_pr__nfet_01v8 L=0.5u W=1u
M11782 o7 ibias vss vss sky130_fd_pr__nfet_01v8 L=0.5u W=1u
M11783 o7 ibias vss vss sky130_fd_pr__nfet_01v8 L=0.5u W=1u
M11784 o7 ibias vss vss sky130_fd_pr__nfet_01v8 L=0.5u W=1u
M11785 o7 ibias vss vss sky130_fd_pr__nfet_01v8 L=0.5u W=1u
M11786 o7 ibias vss vss sky130_fd_pr__nfet_01v8 L=0.5u W=1u
M11787 o7 ibias vss vss sky130_fd_pr__nfet_01v8 L=0.5u W=1u
M11788 o7 ibias vss vss sky130_fd_pr__nfet_01v8 L=0.5u W=1u
M11789 o7 ibias vss vss sky130_fd_pr__nfet_01v8 L=0.5u W=1u
M11790 o7 ibias vss vss sky130_fd_pr__nfet_01v8 L=0.5u W=1u
M11791 o7 ibias vss vss sky130_fd_pr__nfet_01v8 L=0.5u W=1u
M11792 o7 ibias vss vss sky130_fd_pr__nfet_01v8 L=0.5u W=1u
M11793 o7 ibias vss vss sky130_fd_pr__nfet_01v8 L=0.5u W=1u
M11794 o7 ibias vss vss sky130_fd_pr__nfet_01v8 L=0.5u W=1u
M11795 o7 ibias vss vss sky130_fd_pr__nfet_01v8 L=0.5u W=1u
M11796 o7 ibias vss vss sky130_fd_pr__nfet_01v8 L=0.5u W=1u
M11797 o7 ibias vss vss sky130_fd_pr__nfet_01v8 L=0.5u W=1u
M11798 o7 ibias vss vss sky130_fd_pr__nfet_01v8 L=0.5u W=1u
M11799 o7 ibias vss vss sky130_fd_pr__nfet_01v8 L=0.5u W=1u
M11800 o7 ibias vss vss sky130_fd_pr__nfet_01v8 L=0.5u W=1u
M11801 o7 ibias vss vss sky130_fd_pr__nfet_01v8 L=0.5u W=1u
M11802 o7 ibias vss vss sky130_fd_pr__nfet_01v8 L=0.5u W=1u
M11803 o7 ibias vss vss sky130_fd_pr__nfet_01v8 L=0.5u W=1u
M11804 o7 ibias vss vss sky130_fd_pr__nfet_01v8 L=0.5u W=1u
M11805 o7 ibias vss vss sky130_fd_pr__nfet_01v8 L=0.5u W=1u
M11806 o7 ibias vss vss sky130_fd_pr__nfet_01v8 L=0.5u W=1u
M11807 o7 ibias vss vss sky130_fd_pr__nfet_01v8 L=0.5u W=1u
M11808 o7 ibias vss vss sky130_fd_pr__nfet_01v8 L=0.5u W=1u
M11809 o7 ibias vss vss sky130_fd_pr__nfet_01v8 L=0.5u W=1u
M11810 o7 ibias vss vss sky130_fd_pr__nfet_01v8 L=0.5u W=1u
M11811 o7 ibias vss vss sky130_fd_pr__nfet_01v8 L=0.5u W=1u
M11812 o7 ibias vss vss sky130_fd_pr__nfet_01v8 L=0.5u W=1u
M11813 o7 ibias vss vss sky130_fd_pr__nfet_01v8 L=0.5u W=1u
M11814 o7 ibias vss vss sky130_fd_pr__nfet_01v8 L=0.5u W=1u
M11815 o7 ibias vss vss sky130_fd_pr__nfet_01v8 L=0.5u W=1u
M11816 o7 ibias vss vss sky130_fd_pr__nfet_01v8 L=0.5u W=1u
M11817 o7 ibias vss vss sky130_fd_pr__nfet_01v8 L=0.5u W=1u
M11818 o7 ibias vss vss sky130_fd_pr__nfet_01v8 L=0.5u W=1u
M11819 o7 ibias vss vss sky130_fd_pr__nfet_01v8 L=0.5u W=1u
M11820 o7 ibias vss vss sky130_fd_pr__nfet_01v8 L=0.5u W=1u
M11821 o7 ibias vss vss sky130_fd_pr__nfet_01v8 L=0.5u W=1u
M11822 o7 ibias vss vss sky130_fd_pr__nfet_01v8 L=0.5u W=1u
M11823 o7 ibias vss vss sky130_fd_pr__nfet_01v8 L=0.5u W=1u
M11824 o7 ibias vss vss sky130_fd_pr__nfet_01v8 L=0.5u W=1u
M11825 o7 ibias vss vss sky130_fd_pr__nfet_01v8 L=0.5u W=1u
M11826 o7 ibias vss vss sky130_fd_pr__nfet_01v8 L=0.5u W=1u
M11827 o7 ibias vss vss sky130_fd_pr__nfet_01v8 L=0.5u W=1u
M11828 o7 ibias vss vss sky130_fd_pr__nfet_01v8 L=0.5u W=1u
M11829 o7 ibias vss vss sky130_fd_pr__nfet_01v8 L=0.5u W=1u
M11830 o7 ibias vss vss sky130_fd_pr__nfet_01v8 L=0.5u W=1u
M11831 o7 ibias vss vss sky130_fd_pr__nfet_01v8 L=0.5u W=1u
M11832 o7 ibias vss vss sky130_fd_pr__nfet_01v8 L=0.5u W=1u
M11833 o7 ibias vss vss sky130_fd_pr__nfet_01v8 L=0.5u W=1u
M11834 o7 ibias vss vss sky130_fd_pr__nfet_01v8 L=0.5u W=1u
M11835 o7 ibias vss vss sky130_fd_pr__nfet_01v8 L=0.5u W=1u
M11836 o7 ibias vss vss sky130_fd_pr__nfet_01v8 L=0.5u W=1u
M11837 o7 ibias vss vss sky130_fd_pr__nfet_01v8 L=0.5u W=1u
M11838 o7 ibias vss vss sky130_fd_pr__nfet_01v8 L=0.5u W=1u
M11839 o7 ibias vss vss sky130_fd_pr__nfet_01v8 L=0.5u W=1u
M11840 o7 ibias vss vss sky130_fd_pr__nfet_01v8 L=0.5u W=1u
M11841 o7 ibias vss vss sky130_fd_pr__nfet_01v8 L=0.5u W=1u
M11842 o7 ibias vss vss sky130_fd_pr__nfet_01v8 L=0.5u W=1u
M11843 o7 ibias vss vss sky130_fd_pr__nfet_01v8 L=0.5u W=1u
M11844 o7 ibias vss vss sky130_fd_pr__nfet_01v8 L=0.5u W=1u
M11845 o7 ibias vss vss sky130_fd_pr__nfet_01v8 L=0.5u W=1u
M11846 o7 ibias vss vss sky130_fd_pr__nfet_01v8 L=0.5u W=1u
M11847 o7 ibias vss vss sky130_fd_pr__nfet_01v8 L=0.5u W=1u
M11848 o7 ibias vss vss sky130_fd_pr__nfet_01v8 L=0.5u W=1u
M11849 o7 ibias vss vss sky130_fd_pr__nfet_01v8 L=0.5u W=1u
M11850 o7 ibias vss vss sky130_fd_pr__nfet_01v8 L=0.5u W=1u
M11851 o7 ibias vss vss sky130_fd_pr__nfet_01v8 L=0.5u W=1u
M11852 o7 ibias vss vss sky130_fd_pr__nfet_01v8 L=0.5u W=1u
M11853 o7 ibias vss vss sky130_fd_pr__nfet_01v8 L=0.5u W=1u
M11854 o7 ibias vss vss sky130_fd_pr__nfet_01v8 L=0.5u W=1u
M11855 o7 ibias vss vss sky130_fd_pr__nfet_01v8 L=0.5u W=1u
M11856 o7 ibias vss vss sky130_fd_pr__nfet_01v8 L=0.5u W=1u
M11857 o7 ibias vss vss sky130_fd_pr__nfet_01v8 L=0.5u W=1u
M11858 o7 ibias vss vss sky130_fd_pr__nfet_01v8 L=0.5u W=1u
M11859 o7 ibias vss vss sky130_fd_pr__nfet_01v8 L=0.5u W=1u
M11860 o7 ibias vss vss sky130_fd_pr__nfet_01v8 L=0.5u W=1u
M11861 o7 ibias vss vss sky130_fd_pr__nfet_01v8 L=0.5u W=1u
M11862 o7 ibias vss vss sky130_fd_pr__nfet_01v8 L=0.5u W=1u
M11863 o7 ibias vss vss sky130_fd_pr__nfet_01v8 L=0.5u W=1u
M11864 o7 ibias vss vss sky130_fd_pr__nfet_01v8 L=0.5u W=1u
M11865 o7 ibias vss vss sky130_fd_pr__nfet_01v8 L=0.5u W=1u
M11866 o7 ibias vss vss sky130_fd_pr__nfet_01v8 L=0.5u W=1u
M11867 o7 ibias vss vss sky130_fd_pr__nfet_01v8 L=0.5u W=1u
M11868 o7 ibias vss vss sky130_fd_pr__nfet_01v8 L=0.5u W=1u
M11869 o7 ibias vss vss sky130_fd_pr__nfet_01v8 L=0.5u W=1u
M11870 o7 ibias vss vss sky130_fd_pr__nfet_01v8 L=0.5u W=1u
M11871 o7 ibias vss vss sky130_fd_pr__nfet_01v8 L=0.5u W=1u
M11872 o7 ibias vss vss sky130_fd_pr__nfet_01v8 L=0.5u W=1u
M11873 o7 ibias vss vss sky130_fd_pr__nfet_01v8 L=0.5u W=1u
M11874 o7 ibias vss vss sky130_fd_pr__nfet_01v8 L=0.5u W=1u
M11875 o7 ibias vss vss sky130_fd_pr__nfet_01v8 L=0.5u W=1u
M11876 o7 ibias vss vss sky130_fd_pr__nfet_01v8 L=0.5u W=1u
M11877 o7 ibias vss vss sky130_fd_pr__nfet_01v8 L=0.5u W=1u
M11878 o7 ibias vss vss sky130_fd_pr__nfet_01v8 L=0.5u W=1u
M11879 o7 ibias vss vss sky130_fd_pr__nfet_01v8 L=0.5u W=1u
M11880 o7 ibias vss vss sky130_fd_pr__nfet_01v8 L=0.5u W=1u
M11881 o7 ibias vss vss sky130_fd_pr__nfet_01v8 L=0.5u W=1u
M11882 o7 ibias vss vss sky130_fd_pr__nfet_01v8 L=0.5u W=1u
M11883 o7 ibias vss vss sky130_fd_pr__nfet_01v8 L=0.5u W=1u
M11884 o7 ibias vss vss sky130_fd_pr__nfet_01v8 L=0.5u W=1u
M11885 o7 ibias vss vss sky130_fd_pr__nfet_01v8 L=0.5u W=1u
M11886 o7 ibias vss vss sky130_fd_pr__nfet_01v8 L=0.5u W=1u
M11887 o7 ibias vss vss sky130_fd_pr__nfet_01v8 L=0.5u W=1u
M11888 o7 ibias vss vss sky130_fd_pr__nfet_01v8 L=0.5u W=1u
M11889 o7 ibias vss vss sky130_fd_pr__nfet_01v8 L=0.5u W=1u
M11890 o7 ibias vss vss sky130_fd_pr__nfet_01v8 L=0.5u W=1u
M11891 o7 ibias vss vss sky130_fd_pr__nfet_01v8 L=0.5u W=1u
M11892 o7 ibias vss vss sky130_fd_pr__nfet_01v8 L=0.5u W=1u
M11893 o7 ibias vss vss sky130_fd_pr__nfet_01v8 L=0.5u W=1u
M11894 o7 ibias vss vss sky130_fd_pr__nfet_01v8 L=0.5u W=1u
M11895 o7 ibias vss vss sky130_fd_pr__nfet_01v8 L=0.5u W=1u
M11896 o7 ibias vss vss sky130_fd_pr__nfet_01v8 L=0.5u W=1u
M11897 o7 ibias vss vss sky130_fd_pr__nfet_01v8 L=0.5u W=1u
M11898 o7 ibias vss vss sky130_fd_pr__nfet_01v8 L=0.5u W=1u
M11899 o7 ibias vss vss sky130_fd_pr__nfet_01v8 L=0.5u W=1u
M11900 o7 ibias vss vss sky130_fd_pr__nfet_01v8 L=0.5u W=1u
M11901 o7 ibias vss vss sky130_fd_pr__nfet_01v8 L=0.5u W=1u
M11902 o7 ibias vss vss sky130_fd_pr__nfet_01v8 L=0.5u W=1u
M11903 o7 ibias vss vss sky130_fd_pr__nfet_01v8 L=0.5u W=1u
M11904 o7 ibias vss vss sky130_fd_pr__nfet_01v8 L=0.5u W=1u
M11905 o7 ibias vss vss sky130_fd_pr__nfet_01v8 L=0.5u W=1u
M11906 o7 ibias vss vss sky130_fd_pr__nfet_01v8 L=0.5u W=1u
M11907 o7 ibias vss vss sky130_fd_pr__nfet_01v8 L=0.5u W=1u
M11908 o7 ibias vss vss sky130_fd_pr__nfet_01v8 L=0.5u W=1u
M11909 o7 ibias vss vss sky130_fd_pr__nfet_01v8 L=0.5u W=1u
M11910 o7 ibias vss vss sky130_fd_pr__nfet_01v8 L=0.5u W=1u
M11911 o7 ibias vss vss sky130_fd_pr__nfet_01v8 L=0.5u W=1u
M11912 o7 ibias vss vss sky130_fd_pr__nfet_01v8 L=0.5u W=1u
M11913 o7 ibias vss vss sky130_fd_pr__nfet_01v8 L=0.5u W=1u
M11914 o7 ibias vss vss sky130_fd_pr__nfet_01v8 L=0.5u W=1u
M11915 o7 ibias vss vss sky130_fd_pr__nfet_01v8 L=0.5u W=1u
M11916 o7 ibias vss vss sky130_fd_pr__nfet_01v8 L=0.5u W=1u
M11917 o7 ibias vss vss sky130_fd_pr__nfet_01v8 L=0.5u W=1u
M11918 o7 ibias vss vss sky130_fd_pr__nfet_01v8 L=0.5u W=1u
M11919 o7 ibias vss vss sky130_fd_pr__nfet_01v8 L=0.5u W=1u
M11920 o7 ibias vss vss sky130_fd_pr__nfet_01v8 L=0.5u W=1u
M11921 o7 ibias vss vss sky130_fd_pr__nfet_01v8 L=0.5u W=1u
M11922 o7 ibias vss vss sky130_fd_pr__nfet_01v8 L=0.5u W=1u
M11923 o7 ibias vss vss sky130_fd_pr__nfet_01v8 L=0.5u W=1u
M11924 o7 ibias vss vss sky130_fd_pr__nfet_01v8 L=0.5u W=1u
M11925 o7 ibias vss vss sky130_fd_pr__nfet_01v8 L=0.5u W=1u
M11926 o7 ibias vss vss sky130_fd_pr__nfet_01v8 L=0.5u W=1u
M11927 o7 ibias vss vss sky130_fd_pr__nfet_01v8 L=0.5u W=1u
M11928 o7 ibias vss vss sky130_fd_pr__nfet_01v8 L=0.5u W=1u
M11929 o7 ibias vss vss sky130_fd_pr__nfet_01v8 L=0.5u W=1u
M11930 o7 ibias vss vss sky130_fd_pr__nfet_01v8 L=0.5u W=1u
M11931 o7 ibias vss vss sky130_fd_pr__nfet_01v8 L=0.5u W=1u
M11932 o7 ibias vss vss sky130_fd_pr__nfet_01v8 L=0.5u W=1u
M11933 o7 ibias vss vss sky130_fd_pr__nfet_01v8 L=0.5u W=1u
M11934 o7 ibias vss vss sky130_fd_pr__nfet_01v8 L=0.5u W=1u
M11935 o7 ibias vss vss sky130_fd_pr__nfet_01v8 L=0.5u W=1u
M11936 o7 ibias vss vss sky130_fd_pr__nfet_01v8 L=0.5u W=1u
M11937 o7 ibias vss vss sky130_fd_pr__nfet_01v8 L=0.5u W=1u
M11938 o7 ibias vss vss sky130_fd_pr__nfet_01v8 L=0.5u W=1u
M11939 o7 ibias vss vss sky130_fd_pr__nfet_01v8 L=0.5u W=1u
M11940 o7 ibias vss vss sky130_fd_pr__nfet_01v8 L=0.5u W=1u
M11941 o7 ibias vss vss sky130_fd_pr__nfet_01v8 L=0.5u W=1u
M11942 o7 ibias vss vss sky130_fd_pr__nfet_01v8 L=0.5u W=1u
M11943 o7 ibias vss vss sky130_fd_pr__nfet_01v8 L=0.5u W=1u
M11944 o7 ibias vss vss sky130_fd_pr__nfet_01v8 L=0.5u W=1u
M11945 o7 ibias vss vss sky130_fd_pr__nfet_01v8 L=0.5u W=1u
M11946 o7 ibias vss vss sky130_fd_pr__nfet_01v8 L=0.5u W=1u
M11947 o7 ibias vss vss sky130_fd_pr__nfet_01v8 L=0.5u W=1u
M11948 o7 ibias vss vss sky130_fd_pr__nfet_01v8 L=0.5u W=1u
M11949 o7 ibias vss vss sky130_fd_pr__nfet_01v8 L=0.5u W=1u
M11950 o7 ibias vss vss sky130_fd_pr__nfet_01v8 L=0.5u W=1u
M11951 o7 ibias vss vss sky130_fd_pr__nfet_01v8 L=0.5u W=1u
M11952 o7 ibias vss vss sky130_fd_pr__nfet_01v8 L=0.5u W=1u
M11953 o7 ibias vss vss sky130_fd_pr__nfet_01v8 L=0.5u W=1u
M11954 o7 ibias vss vss sky130_fd_pr__nfet_01v8 L=0.5u W=1u
M11955 o7 ibias vss vss sky130_fd_pr__nfet_01v8 L=0.5u W=1u
M11956 o7 ibias vss vss sky130_fd_pr__nfet_01v8 L=0.5u W=1u
M11957 o7 ibias vss vss sky130_fd_pr__nfet_01v8 L=0.5u W=1u
M11958 o7 ibias vss vss sky130_fd_pr__nfet_01v8 L=0.5u W=1u
M11959 o7 ibias vss vss sky130_fd_pr__nfet_01v8 L=0.5u W=1u
M11960 o7 ibias vss vss sky130_fd_pr__nfet_01v8 L=0.5u W=1u
M11961 o7 ibias vss vss sky130_fd_pr__nfet_01v8 L=0.5u W=1u
M11962 o7 ibias vss vss sky130_fd_pr__nfet_01v8 L=0.5u W=1u
M11963 o7 ibias vss vss sky130_fd_pr__nfet_01v8 L=0.5u W=1u
M11964 o7 ibias vss vss sky130_fd_pr__nfet_01v8 L=0.5u W=1u
M11965 o7 ibias vss vss sky130_fd_pr__nfet_01v8 L=0.5u W=1u
M11966 o7 ibias vss vss sky130_fd_pr__nfet_01v8 L=0.5u W=1u
M11967 o7 ibias vss vss sky130_fd_pr__nfet_01v8 L=0.5u W=1u
M11968 o7 ibias vss vss sky130_fd_pr__nfet_01v8 L=0.5u W=1u
M11969 o7 ibias vss vss sky130_fd_pr__nfet_01v8 L=0.5u W=1u
M11970 o7 ibias vss vss sky130_fd_pr__nfet_01v8 L=0.5u W=1u
M11971 o7 ibias vss vss sky130_fd_pr__nfet_01v8 L=0.5u W=1u
M11972 o7 ibias vss vss sky130_fd_pr__nfet_01v8 L=0.5u W=1u
M11973 o7 ibias vss vss sky130_fd_pr__nfet_01v8 L=0.5u W=1u
M11974 o7 ibias vss vss sky130_fd_pr__nfet_01v8 L=0.5u W=1u
M11975 o7 ibias vss vss sky130_fd_pr__nfet_01v8 L=0.5u W=1u
M11976 o7 ibias vss vss sky130_fd_pr__nfet_01v8 L=0.5u W=1u
M11977 o7 ibias vss vss sky130_fd_pr__nfet_01v8 L=0.5u W=1u
M11978 o7 ibias vss vss sky130_fd_pr__nfet_01v8 L=0.5u W=1u
M11979 o7 ibias vss vss sky130_fd_pr__nfet_01v8 L=0.5u W=1u
M11980 o7 ibias vss vss sky130_fd_pr__nfet_01v8 L=0.5u W=1u
M11981 o7 ibias vss vss sky130_fd_pr__nfet_01v8 L=0.5u W=1u
M11982 o7 ibias vss vss sky130_fd_pr__nfet_01v8 L=0.5u W=1u
M11983 o7 ibias vss vss sky130_fd_pr__nfet_01v8 L=0.5u W=1u
M11984 o7 ibias vss vss sky130_fd_pr__nfet_01v8 L=0.5u W=1u
M11985 o7 ibias vss vss sky130_fd_pr__nfet_01v8 L=0.5u W=1u
M11986 o7 ibias vss vss sky130_fd_pr__nfet_01v8 L=0.5u W=1u
M11987 o7 ibias vss vss sky130_fd_pr__nfet_01v8 L=0.5u W=1u
M11988 o7 ibias vss vss sky130_fd_pr__nfet_01v8 L=0.5u W=1u
M11989 o7 ibias vss vss sky130_fd_pr__nfet_01v8 L=0.5u W=1u
M11990 o7 ibias vss vss sky130_fd_pr__nfet_01v8 L=0.5u W=1u
M11991 o7 ibias vss vss sky130_fd_pr__nfet_01v8 L=0.5u W=1u
M11992 o7 ibias vss vss sky130_fd_pr__nfet_01v8 L=0.5u W=1u
M11993 o7 ibias vss vss sky130_fd_pr__nfet_01v8 L=0.5u W=1u
M11994 o7 ibias vss vss sky130_fd_pr__nfet_01v8 L=0.5u W=1u
M11995 o7 ibias vss vss sky130_fd_pr__nfet_01v8 L=0.5u W=1u
M11996 o7 ibias vss vss sky130_fd_pr__nfet_01v8 L=0.5u W=1u
M11997 o7 ibias vss vss sky130_fd_pr__nfet_01v8 L=0.5u W=1u
M11998 o7 ibias vss vss sky130_fd_pr__nfet_01v8 L=0.5u W=1u
M11999 o7 ibias vss vss sky130_fd_pr__nfet_01v8 L=0.5u W=1u
M12000 o7 ibias vss vss sky130_fd_pr__nfet_01v8 L=0.5u W=1u
M12001 o7 ibias vss vss sky130_fd_pr__nfet_01v8 L=0.5u W=1u
M12002 o7 ibias vss vss sky130_fd_pr__nfet_01v8 L=0.5u W=1u
M12003 o7 ibias vss vss sky130_fd_pr__nfet_01v8 L=0.5u W=1u
M12004 o7 ibias vss vss sky130_fd_pr__nfet_01v8 L=0.5u W=1u
M12005 o7 ibias vss vss sky130_fd_pr__nfet_01v8 L=0.5u W=1u
M12006 o7 ibias vss vss sky130_fd_pr__nfet_01v8 L=0.5u W=1u
M12007 o7 ibias vss vss sky130_fd_pr__nfet_01v8 L=0.5u W=1u
M12008 o7 ibias vss vss sky130_fd_pr__nfet_01v8 L=0.5u W=1u
M12009 o7 ibias vss vss sky130_fd_pr__nfet_01v8 L=0.5u W=1u
M12010 o7 ibias vss vss sky130_fd_pr__nfet_01v8 L=0.5u W=1u
M12011 o7 ibias vss vss sky130_fd_pr__nfet_01v8 L=0.5u W=1u
M12012 o7 ibias vss vss sky130_fd_pr__nfet_01v8 L=0.5u W=1u
M12013 o7 ibias vss vss sky130_fd_pr__nfet_01v8 L=0.5u W=1u
M12014 o7 ibias vss vss sky130_fd_pr__nfet_01v8 L=0.5u W=1u
M12015 o7 ibias vss vss sky130_fd_pr__nfet_01v8 L=0.5u W=1u
M12016 o7 ibias vss vss sky130_fd_pr__nfet_01v8 L=0.5u W=1u
M12017 o7 ibias vss vss sky130_fd_pr__nfet_01v8 L=0.5u W=1u
M12018 o7 ibias vss vss sky130_fd_pr__nfet_01v8 L=0.5u W=1u
M12019 o7 ibias vss vss sky130_fd_pr__nfet_01v8 L=0.5u W=1u
M12020 o7 ibias vss vss sky130_fd_pr__nfet_01v8 L=0.5u W=1u
M12021 o7 ibias vss vss sky130_fd_pr__nfet_01v8 L=0.5u W=1u
M12022 o7 ibias vss vss sky130_fd_pr__nfet_01v8 L=0.5u W=1u
M12023 o7 ibias vss vss sky130_fd_pr__nfet_01v8 L=0.5u W=1u
M12024 o7 ibias vss vss sky130_fd_pr__nfet_01v8 L=0.5u W=1u
M12025 o7 ibias vss vss sky130_fd_pr__nfet_01v8 L=0.5u W=1u
M12026 o7 ibias vss vss sky130_fd_pr__nfet_01v8 L=0.5u W=1u
M12027 o7 ibias vss vss sky130_fd_pr__nfet_01v8 L=0.5u W=1u
M12028 o7 ibias vss vss sky130_fd_pr__nfet_01v8 L=0.5u W=1u
M12029 o7 ibias vss vss sky130_fd_pr__nfet_01v8 L=0.5u W=1u
M12030 o7 ibias vss vss sky130_fd_pr__nfet_01v8 L=0.5u W=1u
M12031 o7 ibias vss vss sky130_fd_pr__nfet_01v8 L=0.5u W=1u
M12032 o7 ibias vss vss sky130_fd_pr__nfet_01v8 L=0.5u W=1u
M12033 o7 ibias vss vss sky130_fd_pr__nfet_01v8 L=0.5u W=1u
M12034 o7 ibias vss vss sky130_fd_pr__nfet_01v8 L=0.5u W=1u
M12035 o7 ibias vss vss sky130_fd_pr__nfet_01v8 L=0.5u W=1u
M12036 o7 ibias vss vss sky130_fd_pr__nfet_01v8 L=0.5u W=1u
M12037 o7 ibias vss vss sky130_fd_pr__nfet_01v8 L=0.5u W=1u
M12038 o7 ibias vss vss sky130_fd_pr__nfet_01v8 L=0.5u W=1u
M12039 o7 ibias vss vss sky130_fd_pr__nfet_01v8 L=0.5u W=1u
M12040 o7 ibias vss vss sky130_fd_pr__nfet_01v8 L=0.5u W=1u
M12041 o7 ibias vss vss sky130_fd_pr__nfet_01v8 L=0.5u W=1u
M12042 o7 ibias vss vss sky130_fd_pr__nfet_01v8 L=0.5u W=1u
M12043 o7 ibias vss vss sky130_fd_pr__nfet_01v8 L=0.5u W=1u
M12044 o7 ibias vss vss sky130_fd_pr__nfet_01v8 L=0.5u W=1u
M12045 o7 ibias vss vss sky130_fd_pr__nfet_01v8 L=0.5u W=1u
M12046 o7 ibias vss vss sky130_fd_pr__nfet_01v8 L=0.5u W=1u
M12047 o7 ibias vss vss sky130_fd_pr__nfet_01v8 L=0.5u W=1u
M12048 o7 ibias vss vss sky130_fd_pr__nfet_01v8 L=0.5u W=1u
M12049 o7 ibias vss vss sky130_fd_pr__nfet_01v8 L=0.5u W=1u
M12050 o7 ibias vss vss sky130_fd_pr__nfet_01v8 L=0.5u W=1u
M12051 o7 ibias vss vss sky130_fd_pr__nfet_01v8 L=0.5u W=1u
M12052 o7 ibias vss vss sky130_fd_pr__nfet_01v8 L=0.5u W=1u
M12053 o7 ibias vss vss sky130_fd_pr__nfet_01v8 L=0.5u W=1u
M12054 o7 ibias vss vss sky130_fd_pr__nfet_01v8 L=0.5u W=1u
M12055 o7 ibias vss vss sky130_fd_pr__nfet_01v8 L=0.5u W=1u
M12056 o7 ibias vss vss sky130_fd_pr__nfet_01v8 L=0.5u W=1u
M12057 o7 ibias vss vss sky130_fd_pr__nfet_01v8 L=0.5u W=1u
M12058 o7 ibias vss vss sky130_fd_pr__nfet_01v8 L=0.5u W=1u
M12059 o7 ibias vss vss sky130_fd_pr__nfet_01v8 L=0.5u W=1u
M12060 o7 ibias vss vss sky130_fd_pr__nfet_01v8 L=0.5u W=1u
M12061 o7 ibias vss vss sky130_fd_pr__nfet_01v8 L=0.5u W=1u
M12062 o7 ibias vss vss sky130_fd_pr__nfet_01v8 L=0.5u W=1u
M12063 o7 ibias vss vss sky130_fd_pr__nfet_01v8 L=0.5u W=1u
M12064 o7 ibias vss vss sky130_fd_pr__nfet_01v8 L=0.5u W=1u
M12065 o7 ibias vss vss sky130_fd_pr__nfet_01v8 L=0.5u W=1u
M12066 o7 ibias vss vss sky130_fd_pr__nfet_01v8 L=0.5u W=1u
M12067 o7 ibias vss vss sky130_fd_pr__nfet_01v8 L=0.5u W=1u
M12068 o7 ibias vss vss sky130_fd_pr__nfet_01v8 L=0.5u W=1u
M12069 o7 ibias vss vss sky130_fd_pr__nfet_01v8 L=0.5u W=1u
M12070 o7 ibias vss vss sky130_fd_pr__nfet_01v8 L=0.5u W=1u
M12071 o7 ibias vss vss sky130_fd_pr__nfet_01v8 L=0.5u W=1u
M12072 o7 ibias vss vss sky130_fd_pr__nfet_01v8 L=0.5u W=1u
M12073 o7 ibias vss vss sky130_fd_pr__nfet_01v8 L=0.5u W=1u
M12074 o7 ibias vss vss sky130_fd_pr__nfet_01v8 L=0.5u W=1u
M12075 o7 ibias vss vss sky130_fd_pr__nfet_01v8 L=0.5u W=1u
M12076 o7 ibias vss vss sky130_fd_pr__nfet_01v8 L=0.5u W=1u
M12077 o7 ibias vss vss sky130_fd_pr__nfet_01v8 L=0.5u W=1u
M12078 o7 ibias vss vss sky130_fd_pr__nfet_01v8 L=0.5u W=1u
M12079 o7 ibias vss vss sky130_fd_pr__nfet_01v8 L=0.5u W=1u
M12080 o7 ibias vss vss sky130_fd_pr__nfet_01v8 L=0.5u W=1u
M12081 o7 ibias vss vss sky130_fd_pr__nfet_01v8 L=0.5u W=1u
M12082 o7 ibias vss vss sky130_fd_pr__nfet_01v8 L=0.5u W=1u
M12083 o7 ibias vss vss sky130_fd_pr__nfet_01v8 L=0.5u W=1u
M12084 o7 ibias vss vss sky130_fd_pr__nfet_01v8 L=0.5u W=1u
M12085 o7 ibias vss vss sky130_fd_pr__nfet_01v8 L=0.5u W=1u
M12086 o7 ibias vss vss sky130_fd_pr__nfet_01v8 L=0.5u W=1u
M12087 o7 ibias vss vss sky130_fd_pr__nfet_01v8 L=0.5u W=1u
M12088 o7 ibias vss vss sky130_fd_pr__nfet_01v8 L=0.5u W=1u
M12089 o7 ibias vss vss sky130_fd_pr__nfet_01v8 L=0.5u W=1u
M12090 o7 ibias vss vss sky130_fd_pr__nfet_01v8 L=0.5u W=1u
M12091 o7 ibias vss vss sky130_fd_pr__nfet_01v8 L=0.5u W=1u
M12092 o7 ibias vss vss sky130_fd_pr__nfet_01v8 L=0.5u W=1u
M12093 o7 ibias vss vss sky130_fd_pr__nfet_01v8 L=0.5u W=1u
M12094 o7 ibias vss vss sky130_fd_pr__nfet_01v8 L=0.5u W=1u
M12095 o7 ibias vss vss sky130_fd_pr__nfet_01v8 L=0.5u W=1u
M12096 o7 ibias vss vss sky130_fd_pr__nfet_01v8 L=0.5u W=1u
M12097 o7 ibias vss vss sky130_fd_pr__nfet_01v8 L=0.5u W=1u
M12098 o7 ibias vss vss sky130_fd_pr__nfet_01v8 L=0.5u W=1u
M12099 o7 ibias vss vss sky130_fd_pr__nfet_01v8 L=0.5u W=1u
M12100 o7 ibias vss vss sky130_fd_pr__nfet_01v8 L=0.5u W=1u
M12101 o7 ibias vss vss sky130_fd_pr__nfet_01v8 L=0.5u W=1u
M12102 o7 ibias vss vss sky130_fd_pr__nfet_01v8 L=0.5u W=1u
M12103 o7 ibias vss vss sky130_fd_pr__nfet_01v8 L=0.5u W=1u
M12104 o7 ibias vss vss sky130_fd_pr__nfet_01v8 L=0.5u W=1u
M12105 o7 ibias vss vss sky130_fd_pr__nfet_01v8 L=0.5u W=1u
M12106 o7 ibias vss vss sky130_fd_pr__nfet_01v8 L=0.5u W=1u
M12107 o7 ibias vss vss sky130_fd_pr__nfet_01v8 L=0.5u W=1u
M12108 o7 ibias vss vss sky130_fd_pr__nfet_01v8 L=0.5u W=1u
M12109 o7 ibias vss vss sky130_fd_pr__nfet_01v8 L=0.5u W=1u
M12110 o7 ibias vss vss sky130_fd_pr__nfet_01v8 L=0.5u W=1u
M12111 o7 ibias vss vss sky130_fd_pr__nfet_01v8 L=0.5u W=1u
M12112 o7 ibias vss vss sky130_fd_pr__nfet_01v8 L=0.5u W=1u
M12113 o7 ibias vss vss sky130_fd_pr__nfet_01v8 L=0.5u W=1u
M12114 o7 ibias vss vss sky130_fd_pr__nfet_01v8 L=0.5u W=1u
M12115 o7 ibias vss vss sky130_fd_pr__nfet_01v8 L=0.5u W=1u
M12116 o7 ibias vss vss sky130_fd_pr__nfet_01v8 L=0.5u W=1u
M12117 o7 ibias vss vss sky130_fd_pr__nfet_01v8 L=0.5u W=1u
M12118 o7 ibias vss vss sky130_fd_pr__nfet_01v8 L=0.5u W=1u
M12119 o7 ibias vss vss sky130_fd_pr__nfet_01v8 L=0.5u W=1u
M12120 o7 ibias vss vss sky130_fd_pr__nfet_01v8 L=0.5u W=1u
M12121 o7 ibias vss vss sky130_fd_pr__nfet_01v8 L=0.5u W=1u
M12122 o7 ibias vss vss sky130_fd_pr__nfet_01v8 L=0.5u W=1u
M12123 o7 ibias vss vss sky130_fd_pr__nfet_01v8 L=0.5u W=1u
M12124 o7 ibias vss vss sky130_fd_pr__nfet_01v8 L=0.5u W=1u
M12125 o7 ibias vss vss sky130_fd_pr__nfet_01v8 L=0.5u W=1u
M12126 o7 ibias vss vss sky130_fd_pr__nfet_01v8 L=0.5u W=1u
M12127 o7 ibias vss vss sky130_fd_pr__nfet_01v8 L=0.5u W=1u
M12128 o7 ibias vss vss sky130_fd_pr__nfet_01v8 L=0.5u W=1u
M12129 o7 ibias vss vss sky130_fd_pr__nfet_01v8 L=0.5u W=1u
M12130 o7 ibias vss vss sky130_fd_pr__nfet_01v8 L=0.5u W=1u
M12131 o7 ibias vss vss sky130_fd_pr__nfet_01v8 L=0.5u W=1u
M12132 o7 ibias vss vss sky130_fd_pr__nfet_01v8 L=0.5u W=1u
M12133 o7 ibias vss vss sky130_fd_pr__nfet_01v8 L=0.5u W=1u
M12134 o7 ibias vss vss sky130_fd_pr__nfet_01v8 L=0.5u W=1u
M12135 o7 ibias vss vss sky130_fd_pr__nfet_01v8 L=0.5u W=1u
M12136 o7 ibias vss vss sky130_fd_pr__nfet_01v8 L=0.5u W=1u
M12137 o7 ibias vss vss sky130_fd_pr__nfet_01v8 L=0.5u W=1u
M12138 o7 ibias vss vss sky130_fd_pr__nfet_01v8 L=0.5u W=1u
M12139 o7 ibias vss vss sky130_fd_pr__nfet_01v8 L=0.5u W=1u
M12140 o7 ibias vss vss sky130_fd_pr__nfet_01v8 L=0.5u W=1u
M12141 o7 ibias vss vss sky130_fd_pr__nfet_01v8 L=0.5u W=1u
M12142 o7 ibias vss vss sky130_fd_pr__nfet_01v8 L=0.5u W=1u
M12143 o7 ibias vss vss sky130_fd_pr__nfet_01v8 L=0.5u W=1u
M12144 o7 ibias vss vss sky130_fd_pr__nfet_01v8 L=0.5u W=1u
M12145 o7 ibias vss vss sky130_fd_pr__nfet_01v8 L=0.5u W=1u
M12146 o7 ibias vss vss sky130_fd_pr__nfet_01v8 L=0.5u W=1u
M12147 o7 ibias vss vss sky130_fd_pr__nfet_01v8 L=0.5u W=1u
M12148 o7 ibias vss vss sky130_fd_pr__nfet_01v8 L=0.5u W=1u
M12149 o7 ibias vss vss sky130_fd_pr__nfet_01v8 L=0.5u W=1u
M12150 o7 ibias vss vss sky130_fd_pr__nfet_01v8 L=0.5u W=1u
M12151 o7 ibias vss vss sky130_fd_pr__nfet_01v8 L=0.5u W=1u
M12152 o7 ibias vss vss sky130_fd_pr__nfet_01v8 L=0.5u W=1u
M12153 o7 ibias vss vss sky130_fd_pr__nfet_01v8 L=0.5u W=1u
M12154 o7 ibias vss vss sky130_fd_pr__nfet_01v8 L=0.5u W=1u
M12155 o7 ibias vss vss sky130_fd_pr__nfet_01v8 L=0.5u W=1u
M12156 o7 ibias vss vss sky130_fd_pr__nfet_01v8 L=0.5u W=1u
M12157 o7 ibias vss vss sky130_fd_pr__nfet_01v8 L=0.5u W=1u
M12158 o7 ibias vss vss sky130_fd_pr__nfet_01v8 L=0.5u W=1u
M12159 o7 ibias vss vss sky130_fd_pr__nfet_01v8 L=0.5u W=1u
M12160 o7 ibias vss vss sky130_fd_pr__nfet_01v8 L=0.5u W=1u
M12161 o7 ibias vss vss sky130_fd_pr__nfet_01v8 L=0.5u W=1u
M12162 o7 ibias vss vss sky130_fd_pr__nfet_01v8 L=0.5u W=1u
M12163 o7 ibias vss vss sky130_fd_pr__nfet_01v8 L=0.5u W=1u
M12164 o7 ibias vss vss sky130_fd_pr__nfet_01v8 L=0.5u W=1u
M12165 o7 ibias vss vss sky130_fd_pr__nfet_01v8 L=0.5u W=1u
M12166 o7 ibias vss vss sky130_fd_pr__nfet_01v8 L=0.5u W=1u
M12167 o7 ibias vss vss sky130_fd_pr__nfet_01v8 L=0.5u W=1u
M12168 o7 ibias vss vss sky130_fd_pr__nfet_01v8 L=0.5u W=1u
M12169 o7 ibias vss vss sky130_fd_pr__nfet_01v8 L=0.5u W=1u
M12170 o7 ibias vss vss sky130_fd_pr__nfet_01v8 L=0.5u W=1u
M12171 o7 ibias vss vss sky130_fd_pr__nfet_01v8 L=0.5u W=1u
M12172 o7 ibias vss vss sky130_fd_pr__nfet_01v8 L=0.5u W=1u
M12173 o7 ibias vss vss sky130_fd_pr__nfet_01v8 L=0.5u W=1u
M12174 o7 ibias vss vss sky130_fd_pr__nfet_01v8 L=0.5u W=1u
M12175 o7 ibias vss vss sky130_fd_pr__nfet_01v8 L=0.5u W=1u
M12176 o7 ibias vss vss sky130_fd_pr__nfet_01v8 L=0.5u W=1u
M12177 o7 ibias vss vss sky130_fd_pr__nfet_01v8 L=0.5u W=1u
M12178 o7 ibias vss vss sky130_fd_pr__nfet_01v8 L=0.5u W=1u
M12179 o7 ibias vss vss sky130_fd_pr__nfet_01v8 L=0.5u W=1u
M12180 o7 ibias vss vss sky130_fd_pr__nfet_01v8 L=0.5u W=1u
M12181 o7 ibias vss vss sky130_fd_pr__nfet_01v8 L=0.5u W=1u
M12182 o7 ibias vss vss sky130_fd_pr__nfet_01v8 L=0.5u W=1u
M12183 o7 ibias vss vss sky130_fd_pr__nfet_01v8 L=0.5u W=1u
M12184 o7 ibias vss vss sky130_fd_pr__nfet_01v8 L=0.5u W=1u
M12185 o7 ibias vss vss sky130_fd_pr__nfet_01v8 L=0.5u W=1u
M12186 o7 ibias vss vss sky130_fd_pr__nfet_01v8 L=0.5u W=1u
M12187 o7 ibias vss vss sky130_fd_pr__nfet_01v8 L=0.5u W=1u
M12188 o7 ibias vss vss sky130_fd_pr__nfet_01v8 L=0.5u W=1u
M12189 o7 ibias vss vss sky130_fd_pr__nfet_01v8 L=0.5u W=1u
M12190 o7 ibias vss vss sky130_fd_pr__nfet_01v8 L=0.5u W=1u
M12191 o7 ibias vss vss sky130_fd_pr__nfet_01v8 L=0.5u W=1u
M12192 o7 ibias vss vss sky130_fd_pr__nfet_01v8 L=0.5u W=1u
M12193 o7 ibias vss vss sky130_fd_pr__nfet_01v8 L=0.5u W=1u
M12194 o7 ibias vss vss sky130_fd_pr__nfet_01v8 L=0.5u W=1u
M12195 o7 ibias vss vss sky130_fd_pr__nfet_01v8 L=0.5u W=1u
M12196 o7 ibias vss vss sky130_fd_pr__nfet_01v8 L=0.5u W=1u
M12197 o7 ibias vss vss sky130_fd_pr__nfet_01v8 L=0.5u W=1u
M12198 o7 ibias vss vss sky130_fd_pr__nfet_01v8 L=0.5u W=1u
M12199 o7 ibias vss vss sky130_fd_pr__nfet_01v8 L=0.5u W=1u
M12200 o7 ibias vss vss sky130_fd_pr__nfet_01v8 L=0.5u W=1u
M12201 o7 ibias vss vss sky130_fd_pr__nfet_01v8 L=0.5u W=1u
M12202 o7 ibias vss vss sky130_fd_pr__nfet_01v8 L=0.5u W=1u
M12203 o7 ibias vss vss sky130_fd_pr__nfet_01v8 L=0.5u W=1u
M12204 o7 ibias vss vss sky130_fd_pr__nfet_01v8 L=0.5u W=1u
M12205 o7 ibias vss vss sky130_fd_pr__nfet_01v8 L=0.5u W=1u
M12206 o7 ibias vss vss sky130_fd_pr__nfet_01v8 L=0.5u W=1u
M12207 o7 ibias vss vss sky130_fd_pr__nfet_01v8 L=0.5u W=1u
M12208 o7 ibias vss vss sky130_fd_pr__nfet_01v8 L=0.5u W=1u
M12209 o7 ibias vss vss sky130_fd_pr__nfet_01v8 L=0.5u W=1u
M12210 o7 ibias vss vss sky130_fd_pr__nfet_01v8 L=0.5u W=1u
M12211 o7 ibias vss vss sky130_fd_pr__nfet_01v8 L=0.5u W=1u
M12212 o7 ibias vss vss sky130_fd_pr__nfet_01v8 L=0.5u W=1u
M12213 o7 ibias vss vss sky130_fd_pr__nfet_01v8 L=0.5u W=1u
M12214 o7 ibias vss vss sky130_fd_pr__nfet_01v8 L=0.5u W=1u
M12215 o7 ibias vss vss sky130_fd_pr__nfet_01v8 L=0.5u W=1u
M12216 o7 ibias vss vss sky130_fd_pr__nfet_01v8 L=0.5u W=1u
M12217 o7 ibias vss vss sky130_fd_pr__nfet_01v8 L=0.5u W=1u
M12218 o7 ibias vss vss sky130_fd_pr__nfet_01v8 L=0.5u W=1u
M12219 o7 ibias vss vss sky130_fd_pr__nfet_01v8 L=0.5u W=1u
M12220 o7 ibias vss vss sky130_fd_pr__nfet_01v8 L=0.5u W=1u
M12221 o7 ibias vss vss sky130_fd_pr__nfet_01v8 L=0.5u W=1u
M12222 o7 ibias vss vss sky130_fd_pr__nfet_01v8 L=0.5u W=1u
M12223 o7 ibias vss vss sky130_fd_pr__nfet_01v8 L=0.5u W=1u
M12224 o7 ibias vss vss sky130_fd_pr__nfet_01v8 L=0.5u W=1u
M12225 o7 ibias vss vss sky130_fd_pr__nfet_01v8 L=0.5u W=1u
M12226 o7 ibias vss vss sky130_fd_pr__nfet_01v8 L=0.5u W=1u
M12227 o7 ibias vss vss sky130_fd_pr__nfet_01v8 L=0.5u W=1u
M12228 o7 ibias vss vss sky130_fd_pr__nfet_01v8 L=0.5u W=1u
M12229 o7 ibias vss vss sky130_fd_pr__nfet_01v8 L=0.5u W=1u
M12230 o7 ibias vss vss sky130_fd_pr__nfet_01v8 L=0.5u W=1u
M12231 o7 ibias vss vss sky130_fd_pr__nfet_01v8 L=0.5u W=1u
M12232 o7 ibias vss vss sky130_fd_pr__nfet_01v8 L=0.5u W=1u
M12233 o7 ibias vss vss sky130_fd_pr__nfet_01v8 L=0.5u W=1u
M12234 o7 ibias vss vss sky130_fd_pr__nfet_01v8 L=0.5u W=1u
M12235 o7 ibias vss vss sky130_fd_pr__nfet_01v8 L=0.5u W=1u
M12236 o7 ibias vss vss sky130_fd_pr__nfet_01v8 L=0.5u W=1u
M12237 o7 ibias vss vss sky130_fd_pr__nfet_01v8 L=0.5u W=1u
M12238 o7 ibias vss vss sky130_fd_pr__nfet_01v8 L=0.5u W=1u
M12239 o7 ibias vss vss sky130_fd_pr__nfet_01v8 L=0.5u W=1u
M12240 o7 ibias vss vss sky130_fd_pr__nfet_01v8 L=0.5u W=1u
M12241 o7 ibias vss vss sky130_fd_pr__nfet_01v8 L=0.5u W=1u
M12242 o7 ibias vss vss sky130_fd_pr__nfet_01v8 L=0.5u W=1u
M12243 o7 ibias vss vss sky130_fd_pr__nfet_01v8 L=0.5u W=1u
M12244 o7 ibias vss vss sky130_fd_pr__nfet_01v8 L=0.5u W=1u
M12245 o7 ibias vss vss sky130_fd_pr__nfet_01v8 L=0.5u W=1u
M12246 o7 ibias vss vss sky130_fd_pr__nfet_01v8 L=0.5u W=1u
M12247 o7 ibias vss vss sky130_fd_pr__nfet_01v8 L=0.5u W=1u
M12248 o7 ibias vss vss sky130_fd_pr__nfet_01v8 L=0.5u W=1u
M12249 o7 ibias vss vss sky130_fd_pr__nfet_01v8 L=0.5u W=1u
M12250 o7 ibias vss vss sky130_fd_pr__nfet_01v8 L=0.5u W=1u
M12251 o7 ibias vss vss sky130_fd_pr__nfet_01v8 L=0.5u W=1u
M12252 o7 ibias vss vss sky130_fd_pr__nfet_01v8 L=0.5u W=1u
M12253 o7 ibias vss vss sky130_fd_pr__nfet_01v8 L=0.5u W=1u
M12254 o7 ibias vss vss sky130_fd_pr__nfet_01v8 L=0.5u W=1u
M12255 o7 ibias vss vss sky130_fd_pr__nfet_01v8 L=0.5u W=1u
M12256 o7 ibias vss vss sky130_fd_pr__nfet_01v8 L=0.5u W=1u
M12257 o7 ibias vss vss sky130_fd_pr__nfet_01v8 L=0.5u W=1u
M12258 o7 ibias vss vss sky130_fd_pr__nfet_01v8 L=0.5u W=1u
M12259 o7 ibias vss vss sky130_fd_pr__nfet_01v8 L=0.5u W=1u
M12260 o7 ibias vss vss sky130_fd_pr__nfet_01v8 L=0.5u W=1u
M12261 o7 ibias vss vss sky130_fd_pr__nfet_01v8 L=0.5u W=1u
M12262 o7 ibias vss vss sky130_fd_pr__nfet_01v8 L=0.5u W=1u
M12263 o7 ibias vss vss sky130_fd_pr__nfet_01v8 L=0.5u W=1u
M12264 o7 ibias vss vss sky130_fd_pr__nfet_01v8 L=0.5u W=1u
M12265 o7 ibias vss vss sky130_fd_pr__nfet_01v8 L=0.5u W=1u
M12266 o7 ibias vss vss sky130_fd_pr__nfet_01v8 L=0.5u W=1u
M12267 o7 ibias vss vss sky130_fd_pr__nfet_01v8 L=0.5u W=1u
M12268 o7 ibias vss vss sky130_fd_pr__nfet_01v8 L=0.5u W=1u
M12269 o7 ibias vss vss sky130_fd_pr__nfet_01v8 L=0.5u W=1u
M12270 o7 ibias vss vss sky130_fd_pr__nfet_01v8 L=0.5u W=1u
M12271 o7 ibias vss vss sky130_fd_pr__nfet_01v8 L=0.5u W=1u
M12272 o7 ibias vss vss sky130_fd_pr__nfet_01v8 L=0.5u W=1u
M12273 o7 ibias vss vss sky130_fd_pr__nfet_01v8 L=0.5u W=1u
M12274 o7 ibias vss vss sky130_fd_pr__nfet_01v8 L=0.5u W=1u
M12275 o7 ibias vss vss sky130_fd_pr__nfet_01v8 L=0.5u W=1u
M12276 o7 ibias vss vss sky130_fd_pr__nfet_01v8 L=0.5u W=1u
M12277 o7 ibias vss vss sky130_fd_pr__nfet_01v8 L=0.5u W=1u
M12278 o7 ibias vss vss sky130_fd_pr__nfet_01v8 L=0.5u W=1u
M12279 o7 ibias vss vss sky130_fd_pr__nfet_01v8 L=0.5u W=1u
M12280 o7 ibias vss vss sky130_fd_pr__nfet_01v8 L=0.5u W=1u
M12281 o7 ibias vss vss sky130_fd_pr__nfet_01v8 L=0.5u W=1u
M12282 o7 ibias vss vss sky130_fd_pr__nfet_01v8 L=0.5u W=1u
M12283 o7 ibias vss vss sky130_fd_pr__nfet_01v8 L=0.5u W=1u
M12284 o7 ibias vss vss sky130_fd_pr__nfet_01v8 L=0.5u W=1u
M12285 o7 ibias vss vss sky130_fd_pr__nfet_01v8 L=0.5u W=1u
M12286 o7 ibias vss vss sky130_fd_pr__nfet_01v8 L=0.5u W=1u
M12287 o7 ibias vss vss sky130_fd_pr__nfet_01v8 L=0.5u W=1u
M12288 o7 ibias vss vss sky130_fd_pr__nfet_01v8 L=0.5u W=1u
M12289 o7 ibias vss vss sky130_fd_pr__nfet_01v8 L=0.5u W=1u
M12290 o7 ibias vss vss sky130_fd_pr__nfet_01v8 L=0.5u W=1u
M12291 o7 ibias vss vss sky130_fd_pr__nfet_01v8 L=0.5u W=1u
M12292 o7 ibias vss vss sky130_fd_pr__nfet_01v8 L=0.5u W=1u
M12293 o7 ibias vss vss sky130_fd_pr__nfet_01v8 L=0.5u W=1u
M12294 o7 ibias vss vss sky130_fd_pr__nfet_01v8 L=0.5u W=1u
M12295 o7 ibias vss vss sky130_fd_pr__nfet_01v8 L=0.5u W=1u
M12296 o7 ibias vss vss sky130_fd_pr__nfet_01v8 L=0.5u W=1u
M12297 o7 ibias vss vss sky130_fd_pr__nfet_01v8 L=0.5u W=1u
M12298 o7 ibias vss vss sky130_fd_pr__nfet_01v8 L=0.5u W=1u
M12299 o7 ibias vss vss sky130_fd_pr__nfet_01v8 L=0.5u W=1u
M12300 o7 ibias vss vss sky130_fd_pr__nfet_01v8 L=0.5u W=1u
M12301 o7 ibias vss vss sky130_fd_pr__nfet_01v8 L=0.5u W=1u
M12302 o7 ibias vss vss sky130_fd_pr__nfet_01v8 L=0.5u W=1u
M12303 o7 ibias vss vss sky130_fd_pr__nfet_01v8 L=0.5u W=1u
M12304 o7 ibias vss vss sky130_fd_pr__nfet_01v8 L=0.5u W=1u
M12305 o7 ibias vss vss sky130_fd_pr__nfet_01v8 L=0.5u W=1u
M12306 o7 ibias vss vss sky130_fd_pr__nfet_01v8 L=0.5u W=1u
M12307 o7 ibias vss vss sky130_fd_pr__nfet_01v8 L=0.5u W=1u
M12308 o7 ibias vss vss sky130_fd_pr__nfet_01v8 L=0.5u W=1u
M12309 o7 ibias vss vss sky130_fd_pr__nfet_01v8 L=0.5u W=1u
M12310 o7 ibias vss vss sky130_fd_pr__nfet_01v8 L=0.5u W=1u
M12311 o7 ibias vss vss sky130_fd_pr__nfet_01v8 L=0.5u W=1u
M12312 o7 ibias vss vss sky130_fd_pr__nfet_01v8 L=0.5u W=1u
M12313 o7 ibias vss vss sky130_fd_pr__nfet_01v8 L=0.5u W=1u
M12314 o7 ibias vss vss sky130_fd_pr__nfet_01v8 L=0.5u W=1u
M12315 o7 ibias vss vss sky130_fd_pr__nfet_01v8 L=0.5u W=1u
M12316 o7 ibias vss vss sky130_fd_pr__nfet_01v8 L=0.5u W=1u
M12317 o7 ibias vss vss sky130_fd_pr__nfet_01v8 L=0.5u W=1u
M12318 o7 ibias vss vss sky130_fd_pr__nfet_01v8 L=0.5u W=1u
M12319 o7 ibias vss vss sky130_fd_pr__nfet_01v8 L=0.5u W=1u
M12320 o7 ibias vss vss sky130_fd_pr__nfet_01v8 L=0.5u W=1u
M12321 o7 ibias vss vss sky130_fd_pr__nfet_01v8 L=0.5u W=1u
M12322 o7 ibias vss vss sky130_fd_pr__nfet_01v8 L=0.5u W=1u
M12323 o7 ibias vss vss sky130_fd_pr__nfet_01v8 L=0.5u W=1u
M12324 o7 ibias vss vss sky130_fd_pr__nfet_01v8 L=0.5u W=1u
M12325 o7 ibias vss vss sky130_fd_pr__nfet_01v8 L=0.5u W=1u
M12326 o7 ibias vss vss sky130_fd_pr__nfet_01v8 L=0.5u W=1u
M12327 o7 ibias vss vss sky130_fd_pr__nfet_01v8 L=0.5u W=1u
M12328 o7 ibias vss vss sky130_fd_pr__nfet_01v8 L=0.5u W=1u
M12329 o7 ibias vss vss sky130_fd_pr__nfet_01v8 L=0.5u W=1u
M12330 o7 ibias vss vss sky130_fd_pr__nfet_01v8 L=0.5u W=1u
M12331 o7 ibias vss vss sky130_fd_pr__nfet_01v8 L=0.5u W=1u
M12332 o7 ibias vss vss sky130_fd_pr__nfet_01v8 L=0.5u W=1u
M12333 o7 ibias vss vss sky130_fd_pr__nfet_01v8 L=0.5u W=1u
M12334 o7 ibias vss vss sky130_fd_pr__nfet_01v8 L=0.5u W=1u
M12335 o7 ibias vss vss sky130_fd_pr__nfet_01v8 L=0.5u W=1u
M12336 o7 ibias vss vss sky130_fd_pr__nfet_01v8 L=0.5u W=1u
M12337 o7 ibias vss vss sky130_fd_pr__nfet_01v8 L=0.5u W=1u
M12338 o7 ibias vss vss sky130_fd_pr__nfet_01v8 L=0.5u W=1u
M12339 o7 ibias vss vss sky130_fd_pr__nfet_01v8 L=0.5u W=1u
M12340 o7 ibias vss vss sky130_fd_pr__nfet_01v8 L=0.5u W=1u
M12341 o7 ibias vss vss sky130_fd_pr__nfet_01v8 L=0.5u W=1u
M12342 o7 ibias vss vss sky130_fd_pr__nfet_01v8 L=0.5u W=1u
M12343 o7 ibias vss vss sky130_fd_pr__nfet_01v8 L=0.5u W=1u
M12344 o7 ibias vss vss sky130_fd_pr__nfet_01v8 L=0.5u W=1u
M12345 o7 ibias vss vss sky130_fd_pr__nfet_01v8 L=0.5u W=1u
M12346 o7 ibias vss vss sky130_fd_pr__nfet_01v8 L=0.5u W=1u
M12347 o7 ibias vss vss sky130_fd_pr__nfet_01v8 L=0.5u W=1u
M12348 o7 ibias vss vss sky130_fd_pr__nfet_01v8 L=0.5u W=1u
M12349 o7 ibias vss vss sky130_fd_pr__nfet_01v8 L=0.5u W=1u
M12350 o7 ibias vss vss sky130_fd_pr__nfet_01v8 L=0.5u W=1u
M12351 o7 ibias vss vss sky130_fd_pr__nfet_01v8 L=0.5u W=1u
M12352 o7 ibias vss vss sky130_fd_pr__nfet_01v8 L=0.5u W=1u
M12353 o7 ibias vss vss sky130_fd_pr__nfet_01v8 L=0.5u W=1u
M12354 o7 ibias vss vss sky130_fd_pr__nfet_01v8 L=0.5u W=1u
M12355 o7 ibias vss vss sky130_fd_pr__nfet_01v8 L=0.5u W=1u
M12356 o7 ibias vss vss sky130_fd_pr__nfet_01v8 L=0.5u W=1u
M12357 o7 ibias vss vss sky130_fd_pr__nfet_01v8 L=0.5u W=1u
M12358 o7 ibias vss vss sky130_fd_pr__nfet_01v8 L=0.5u W=1u
M12359 o7 ibias vss vss sky130_fd_pr__nfet_01v8 L=0.5u W=1u
M12360 o7 ibias vss vss sky130_fd_pr__nfet_01v8 L=0.5u W=1u
M12361 o7 ibias vss vss sky130_fd_pr__nfet_01v8 L=0.5u W=1u
M12362 o7 ibias vss vss sky130_fd_pr__nfet_01v8 L=0.5u W=1u
M12363 o7 ibias vss vss sky130_fd_pr__nfet_01v8 L=0.5u W=1u
M12364 o7 ibias vss vss sky130_fd_pr__nfet_01v8 L=0.5u W=1u
M12365 o7 ibias vss vss sky130_fd_pr__nfet_01v8 L=0.5u W=1u
M12366 o7 ibias vss vss sky130_fd_pr__nfet_01v8 L=0.5u W=1u
M12367 o7 ibias vss vss sky130_fd_pr__nfet_01v8 L=0.5u W=1u
M12368 o7 ibias vss vss sky130_fd_pr__nfet_01v8 L=0.5u W=1u
M12369 o7 ibias vss vss sky130_fd_pr__nfet_01v8 L=0.5u W=1u
M12370 o7 ibias vss vss sky130_fd_pr__nfet_01v8 L=0.5u W=1u
M12371 o7 ibias vss vss sky130_fd_pr__nfet_01v8 L=0.5u W=1u
M12372 o7 ibias vss vss sky130_fd_pr__nfet_01v8 L=0.5u W=1u
M12373 o7 ibias vss vss sky130_fd_pr__nfet_01v8 L=0.5u W=1u
M12374 o7 ibias vss vss sky130_fd_pr__nfet_01v8 L=0.5u W=1u
M12375 o7 ibias vss vss sky130_fd_pr__nfet_01v8 L=0.5u W=1u
M12376 o7 ibias vss vss sky130_fd_pr__nfet_01v8 L=0.5u W=1u
M12377 o7 ibias vss vss sky130_fd_pr__nfet_01v8 L=0.5u W=1u
M12378 o7 ibias vss vss sky130_fd_pr__nfet_01v8 L=0.5u W=1u
M12379 o7 ibias vss vss sky130_fd_pr__nfet_01v8 L=0.5u W=1u
M12380 o7 ibias vss vss sky130_fd_pr__nfet_01v8 L=0.5u W=1u
M12381 o7 ibias vss vss sky130_fd_pr__nfet_01v8 L=0.5u W=1u
M12382 o7 ibias vss vss sky130_fd_pr__nfet_01v8 L=0.5u W=1u
M12383 o7 ibias vss vss sky130_fd_pr__nfet_01v8 L=0.5u W=1u
M12384 o7 ibias vss vss sky130_fd_pr__nfet_01v8 L=0.5u W=1u
M12385 o7 ibias vss vss sky130_fd_pr__nfet_01v8 L=0.5u W=1u
M12386 o7 ibias vss vss sky130_fd_pr__nfet_01v8 L=0.5u W=1u
M12387 o7 ibias vss vss sky130_fd_pr__nfet_01v8 L=0.5u W=1u
M12388 o7 ibias vss vss sky130_fd_pr__nfet_01v8 L=0.5u W=1u
M12389 o7 ibias vss vss sky130_fd_pr__nfet_01v8 L=0.5u W=1u
M12390 o7 ibias vss vss sky130_fd_pr__nfet_01v8 L=0.5u W=1u
M12391 o7 ibias vss vss sky130_fd_pr__nfet_01v8 L=0.5u W=1u
M12392 o7 ibias vss vss sky130_fd_pr__nfet_01v8 L=0.5u W=1u
M12393 o7 ibias vss vss sky130_fd_pr__nfet_01v8 L=0.5u W=1u
M12394 o7 ibias vss vss sky130_fd_pr__nfet_01v8 L=0.5u W=1u
M12395 o7 ibias vss vss sky130_fd_pr__nfet_01v8 L=0.5u W=1u
M12396 o7 ibias vss vss sky130_fd_pr__nfet_01v8 L=0.5u W=1u
M12397 o7 ibias vss vss sky130_fd_pr__nfet_01v8 L=0.5u W=1u
M12398 o7 ibias vss vss sky130_fd_pr__nfet_01v8 L=0.5u W=1u
M12399 o7 ibias vss vss sky130_fd_pr__nfet_01v8 L=0.5u W=1u
M12400 o7 ibias vss vss sky130_fd_pr__nfet_01v8 L=0.5u W=1u
M12401 o7 ibias vss vss sky130_fd_pr__nfet_01v8 L=0.5u W=1u
M12402 o7 ibias vss vss sky130_fd_pr__nfet_01v8 L=0.5u W=1u
M12403 o7 ibias vss vss sky130_fd_pr__nfet_01v8 L=0.5u W=1u
M12404 o7 ibias vss vss sky130_fd_pr__nfet_01v8 L=0.5u W=1u
M12405 o7 ibias vss vss sky130_fd_pr__nfet_01v8 L=0.5u W=1u
M12406 o7 ibias vss vss sky130_fd_pr__nfet_01v8 L=0.5u W=1u
M12407 o7 ibias vss vss sky130_fd_pr__nfet_01v8 L=0.5u W=1u
M12408 o7 ibias vss vss sky130_fd_pr__nfet_01v8 L=0.5u W=1u
M12409 o7 ibias vss vss sky130_fd_pr__nfet_01v8 L=0.5u W=1u
M12410 o7 ibias vss vss sky130_fd_pr__nfet_01v8 L=0.5u W=1u
M12411 o7 ibias vss vss sky130_fd_pr__nfet_01v8 L=0.5u W=1u
M12412 o7 ibias vss vss sky130_fd_pr__nfet_01v8 L=0.5u W=1u
M12413 o7 ibias vss vss sky130_fd_pr__nfet_01v8 L=0.5u W=1u
M12414 o7 ibias vss vss sky130_fd_pr__nfet_01v8 L=0.5u W=1u
M12415 o7 ibias vss vss sky130_fd_pr__nfet_01v8 L=0.5u W=1u
M12416 o7 ibias vss vss sky130_fd_pr__nfet_01v8 L=0.5u W=1u
M12417 o7 ibias vss vss sky130_fd_pr__nfet_01v8 L=0.5u W=1u
M12418 o7 ibias vss vss sky130_fd_pr__nfet_01v8 L=0.5u W=1u
M12419 o7 ibias vss vss sky130_fd_pr__nfet_01v8 L=0.5u W=1u
M12420 o7 ibias vss vss sky130_fd_pr__nfet_01v8 L=0.5u W=1u
M12421 o7 ibias vss vss sky130_fd_pr__nfet_01v8 L=0.5u W=1u
M12422 o7 ibias vss vss sky130_fd_pr__nfet_01v8 L=0.5u W=1u
M12423 o7 ibias vss vss sky130_fd_pr__nfet_01v8 L=0.5u W=1u
M12424 o7 ibias vss vss sky130_fd_pr__nfet_01v8 L=0.5u W=1u
M12425 o7 ibias vss vss sky130_fd_pr__nfet_01v8 L=0.5u W=1u
M12426 o7 ibias vss vss sky130_fd_pr__nfet_01v8 L=0.5u W=1u
M12427 o7 ibias vss vss sky130_fd_pr__nfet_01v8 L=0.5u W=1u
M12428 o7 ibias vss vss sky130_fd_pr__nfet_01v8 L=0.5u W=1u
M12429 o7 ibias vss vss sky130_fd_pr__nfet_01v8 L=0.5u W=1u
M12430 o7 ibias vss vss sky130_fd_pr__nfet_01v8 L=0.5u W=1u
M12431 o7 ibias vss vss sky130_fd_pr__nfet_01v8 L=0.5u W=1u
M12432 o7 ibias vss vss sky130_fd_pr__nfet_01v8 L=0.5u W=1u
M12433 o7 ibias vss vss sky130_fd_pr__nfet_01v8 L=0.5u W=1u
M12434 o7 ibias vss vss sky130_fd_pr__nfet_01v8 L=0.5u W=1u
M12435 o7 ibias vss vss sky130_fd_pr__nfet_01v8 L=0.5u W=1u
M12436 o7 ibias vss vss sky130_fd_pr__nfet_01v8 L=0.5u W=1u
M12437 o7 ibias vss vss sky130_fd_pr__nfet_01v8 L=0.5u W=1u
M12438 o7 ibias vss vss sky130_fd_pr__nfet_01v8 L=0.5u W=1u
M12439 o7 ibias vss vss sky130_fd_pr__nfet_01v8 L=0.5u W=1u
M12440 o7 ibias vss vss sky130_fd_pr__nfet_01v8 L=0.5u W=1u
M12441 o7 ibias vss vss sky130_fd_pr__nfet_01v8 L=0.5u W=1u
M12442 o7 ibias vss vss sky130_fd_pr__nfet_01v8 L=0.5u W=1u
M12443 o7 ibias vss vss sky130_fd_pr__nfet_01v8 L=0.5u W=1u
M12444 o7 ibias vss vss sky130_fd_pr__nfet_01v8 L=0.5u W=1u
M12445 o7 ibias vss vss sky130_fd_pr__nfet_01v8 L=0.5u W=1u
M12446 o7 ibias vss vss sky130_fd_pr__nfet_01v8 L=0.5u W=1u
M12447 o7 ibias vss vss sky130_fd_pr__nfet_01v8 L=0.5u W=1u
M12448 o7 ibias vss vss sky130_fd_pr__nfet_01v8 L=0.5u W=1u
M12449 o7 ibias vss vss sky130_fd_pr__nfet_01v8 L=0.5u W=1u
M12450 o7 ibias vss vss sky130_fd_pr__nfet_01v8 L=0.5u W=1u
M12451 o7 ibias vss vss sky130_fd_pr__nfet_01v8 L=0.5u W=1u
M12452 o7 ibias vss vss sky130_fd_pr__nfet_01v8 L=0.5u W=1u
M12453 o7 ibias vss vss sky130_fd_pr__nfet_01v8 L=0.5u W=1u
M12454 o7 ibias vss vss sky130_fd_pr__nfet_01v8 L=0.5u W=1u
M12455 o7 ibias vss vss sky130_fd_pr__nfet_01v8 L=0.5u W=1u
M12456 o7 ibias vss vss sky130_fd_pr__nfet_01v8 L=0.5u W=1u
M12457 o7 ibias vss vss sky130_fd_pr__nfet_01v8 L=0.5u W=1u
M12458 o7 ibias vss vss sky130_fd_pr__nfet_01v8 L=0.5u W=1u
M12459 o7 ibias vss vss sky130_fd_pr__nfet_01v8 L=0.5u W=1u
M12460 o7 ibias vss vss sky130_fd_pr__nfet_01v8 L=0.5u W=1u
M12461 o7 ibias vss vss sky130_fd_pr__nfet_01v8 L=0.5u W=1u
M12462 o7 ibias vss vss sky130_fd_pr__nfet_01v8 L=0.5u W=1u
M12463 o7 ibias vss vss sky130_fd_pr__nfet_01v8 L=0.5u W=1u
M12464 o7 ibias vss vss sky130_fd_pr__nfet_01v8 L=0.5u W=1u
M12465 o7 ibias vss vss sky130_fd_pr__nfet_01v8 L=0.5u W=1u
M12466 o7 ibias vss vss sky130_fd_pr__nfet_01v8 L=0.5u W=1u
M12467 o7 ibias vss vss sky130_fd_pr__nfet_01v8 L=0.5u W=1u
M12468 o7 ibias vss vss sky130_fd_pr__nfet_01v8 L=0.5u W=1u
M12469 o7 ibias vss vss sky130_fd_pr__nfet_01v8 L=0.5u W=1u
M12470 o7 ibias vss vss sky130_fd_pr__nfet_01v8 L=0.5u W=1u
M12471 o7 ibias vss vss sky130_fd_pr__nfet_01v8 L=0.5u W=1u
M12472 o7 ibias vss vss sky130_fd_pr__nfet_01v8 L=0.5u W=1u
M12473 o7 ibias vss vss sky130_fd_pr__nfet_01v8 L=0.5u W=1u
M12474 o7 ibias vss vss sky130_fd_pr__nfet_01v8 L=0.5u W=1u
M12475 o7 ibias vss vss sky130_fd_pr__nfet_01v8 L=0.5u W=1u
M12476 o7 ibias vss vss sky130_fd_pr__nfet_01v8 L=0.5u W=1u
M12477 o7 ibias vss vss sky130_fd_pr__nfet_01v8 L=0.5u W=1u
M12478 o7 ibias vss vss sky130_fd_pr__nfet_01v8 L=0.5u W=1u
M12479 o7 ibias vss vss sky130_fd_pr__nfet_01v8 L=0.5u W=1u
M12480 o7 ibias vss vss sky130_fd_pr__nfet_01v8 L=0.5u W=1u
M12481 o7 ibias vss vss sky130_fd_pr__nfet_01v8 L=0.5u W=1u
M12482 o7 ibias vss vss sky130_fd_pr__nfet_01v8 L=0.5u W=1u
M12483 o7 ibias vss vss sky130_fd_pr__nfet_01v8 L=0.5u W=1u
M12484 o7 ibias vss vss sky130_fd_pr__nfet_01v8 L=0.5u W=1u
M12485 o7 ibias vss vss sky130_fd_pr__nfet_01v8 L=0.5u W=1u
M12486 o7 ibias vss vss sky130_fd_pr__nfet_01v8 L=0.5u W=1u
M12487 o7 ibias vss vss sky130_fd_pr__nfet_01v8 L=0.5u W=1u
M12488 o7 ibias vss vss sky130_fd_pr__nfet_01v8 L=0.5u W=1u
M12489 o7 ibias vss vss sky130_fd_pr__nfet_01v8 L=0.5u W=1u
M12490 o7 ibias vss vss sky130_fd_pr__nfet_01v8 L=0.5u W=1u
M12491 o7 ibias vss vss sky130_fd_pr__nfet_01v8 L=0.5u W=1u
M12492 o7 ibias vss vss sky130_fd_pr__nfet_01v8 L=0.5u W=1u
M12493 o7 ibias vss vss sky130_fd_pr__nfet_01v8 L=0.5u W=1u
M12494 o7 ibias vss vss sky130_fd_pr__nfet_01v8 L=0.5u W=1u
M12495 o7 ibias vss vss sky130_fd_pr__nfet_01v8 L=0.5u W=1u
M12496 o7 ibias vss vss sky130_fd_pr__nfet_01v8 L=0.5u W=1u
M12497 o7 ibias vss vss sky130_fd_pr__nfet_01v8 L=0.5u W=1u
M12498 o7 ibias vss vss sky130_fd_pr__nfet_01v8 L=0.5u W=1u
M12499 o7 ibias vss vss sky130_fd_pr__nfet_01v8 L=0.5u W=1u
M12500 o7 ibias vss vss sky130_fd_pr__nfet_01v8 L=0.5u W=1u
M12501 o7 ibias vss vss sky130_fd_pr__nfet_01v8 L=0.5u W=1u
M12502 o7 ibias vss vss sky130_fd_pr__nfet_01v8 L=0.5u W=1u
M12503 o7 ibias vss vss sky130_fd_pr__nfet_01v8 L=0.5u W=1u
M12504 o7 ibias vss vss sky130_fd_pr__nfet_01v8 L=0.5u W=1u
M12505 o7 ibias vss vss sky130_fd_pr__nfet_01v8 L=0.5u W=1u
M12506 o7 ibias vss vss sky130_fd_pr__nfet_01v8 L=0.5u W=1u
M12507 o7 ibias vss vss sky130_fd_pr__nfet_01v8 L=0.5u W=1u
M12508 o7 ibias vss vss sky130_fd_pr__nfet_01v8 L=0.5u W=1u
M12509 o7 ibias vss vss sky130_fd_pr__nfet_01v8 L=0.5u W=1u
M12510 o7 ibias vss vss sky130_fd_pr__nfet_01v8 L=0.5u W=1u
M12511 o7 ibias vss vss sky130_fd_pr__nfet_01v8 L=0.5u W=1u
M12512 o7 ibias vss vss sky130_fd_pr__nfet_01v8 L=0.5u W=1u
M12513 o7 ibias vss vss sky130_fd_pr__nfet_01v8 L=0.5u W=1u
M12514 o7 ibias vss vss sky130_fd_pr__nfet_01v8 L=0.5u W=1u
M12515 o7 ibias vss vss sky130_fd_pr__nfet_01v8 L=0.5u W=1u
M12516 o7 ibias vss vss sky130_fd_pr__nfet_01v8 L=0.5u W=1u
M12517 o7 ibias vss vss sky130_fd_pr__nfet_01v8 L=0.5u W=1u
M12518 o7 ibias vss vss sky130_fd_pr__nfet_01v8 L=0.5u W=1u
M12519 o7 ibias vss vss sky130_fd_pr__nfet_01v8 L=0.5u W=1u
M12520 o7 ibias vss vss sky130_fd_pr__nfet_01v8 L=0.5u W=1u
M12521 o7 ibias vss vss sky130_fd_pr__nfet_01v8 L=0.5u W=1u
M12522 o7 ibias vss vss sky130_fd_pr__nfet_01v8 L=0.5u W=1u
M12523 o7 ibias vss vss sky130_fd_pr__nfet_01v8 L=0.5u W=1u
M12524 o7 ibias vss vss sky130_fd_pr__nfet_01v8 L=0.5u W=1u
M12525 o7 ibias vss vss sky130_fd_pr__nfet_01v8 L=0.5u W=1u
M12526 o7 ibias vss vss sky130_fd_pr__nfet_01v8 L=0.5u W=1u
M12527 o7 ibias vss vss sky130_fd_pr__nfet_01v8 L=0.5u W=1u
M12528 o7 ibias vss vss sky130_fd_pr__nfet_01v8 L=0.5u W=1u
M12529 o7 ibias vss vss sky130_fd_pr__nfet_01v8 L=0.5u W=1u
M12530 o7 ibias vss vss sky130_fd_pr__nfet_01v8 L=0.5u W=1u
M12531 o7 ibias vss vss sky130_fd_pr__nfet_01v8 L=0.5u W=1u
M12532 o7 ibias vss vss sky130_fd_pr__nfet_01v8 L=0.5u W=1u
M12533 o7 ibias vss vss sky130_fd_pr__nfet_01v8 L=0.5u W=1u
M12534 o7 ibias vss vss sky130_fd_pr__nfet_01v8 L=0.5u W=1u
M12535 o7 ibias vss vss sky130_fd_pr__nfet_01v8 L=0.5u W=1u
M12536 o7 ibias vss vss sky130_fd_pr__nfet_01v8 L=0.5u W=1u
M12537 o7 ibias vss vss sky130_fd_pr__nfet_01v8 L=0.5u W=1u
M12538 o7 ibias vss vss sky130_fd_pr__nfet_01v8 L=0.5u W=1u
M12539 o7 ibias vss vss sky130_fd_pr__nfet_01v8 L=0.5u W=1u
M12540 o7 ibias vss vss sky130_fd_pr__nfet_01v8 L=0.5u W=1u
M12541 o7 ibias vss vss sky130_fd_pr__nfet_01v8 L=0.5u W=1u
M12542 o7 ibias vss vss sky130_fd_pr__nfet_01v8 L=0.5u W=1u
M12543 o7 ibias vss vss sky130_fd_pr__nfet_01v8 L=0.5u W=1u
M12544 o7 ibias vss vss sky130_fd_pr__nfet_01v8 L=0.5u W=1u
M12545 o7 ibias vss vss sky130_fd_pr__nfet_01v8 L=0.5u W=1u
M12546 o7 ibias vss vss sky130_fd_pr__nfet_01v8 L=0.5u W=1u
M12547 o7 ibias vss vss sky130_fd_pr__nfet_01v8 L=0.5u W=1u
M12548 o7 ibias vss vss sky130_fd_pr__nfet_01v8 L=0.5u W=1u
M12549 o7 ibias vss vss sky130_fd_pr__nfet_01v8 L=0.5u W=1u
M12550 o7 ibias vss vss sky130_fd_pr__nfet_01v8 L=0.5u W=1u
M12551 o7 ibias vss vss sky130_fd_pr__nfet_01v8 L=0.5u W=1u
M12552 o7 ibias vss vss sky130_fd_pr__nfet_01v8 L=0.5u W=1u
M12553 o7 ibias vss vss sky130_fd_pr__nfet_01v8 L=0.5u W=1u
M12554 o7 ibias vss vss sky130_fd_pr__nfet_01v8 L=0.5u W=1u
M12555 o7 ibias vss vss sky130_fd_pr__nfet_01v8 L=0.5u W=1u
M12556 o7 ibias vss vss sky130_fd_pr__nfet_01v8 L=0.5u W=1u
M12557 o7 ibias vss vss sky130_fd_pr__nfet_01v8 L=0.5u W=1u
M12558 o7 ibias vss vss sky130_fd_pr__nfet_01v8 L=0.5u W=1u
M12559 o7 ibias vss vss sky130_fd_pr__nfet_01v8 L=0.5u W=1u
M12560 o7 ibias vss vss sky130_fd_pr__nfet_01v8 L=0.5u W=1u
M12561 o7 ibias vss vss sky130_fd_pr__nfet_01v8 L=0.5u W=1u
M12562 o7 ibias vss vss sky130_fd_pr__nfet_01v8 L=0.5u W=1u
M12563 o7 ibias vss vss sky130_fd_pr__nfet_01v8 L=0.5u W=1u
M12564 o7 ibias vss vss sky130_fd_pr__nfet_01v8 L=0.5u W=1u
M12565 o7 ibias vss vss sky130_fd_pr__nfet_01v8 L=0.5u W=1u
M12566 o7 ibias vss vss sky130_fd_pr__nfet_01v8 L=0.5u W=1u
M12567 o7 ibias vss vss sky130_fd_pr__nfet_01v8 L=0.5u W=1u
M12568 o7 ibias vss vss sky130_fd_pr__nfet_01v8 L=0.5u W=1u
M12569 o7 ibias vss vss sky130_fd_pr__nfet_01v8 L=0.5u W=1u
M12570 o7 ibias vss vss sky130_fd_pr__nfet_01v8 L=0.5u W=1u
M12571 o7 ibias vss vss sky130_fd_pr__nfet_01v8 L=0.5u W=1u
M12572 o7 ibias vss vss sky130_fd_pr__nfet_01v8 L=0.5u W=1u
M12573 o7 ibias vss vss sky130_fd_pr__nfet_01v8 L=0.5u W=1u
M12574 o7 ibias vss vss sky130_fd_pr__nfet_01v8 L=0.5u W=1u
M12575 o7 ibias vss vss sky130_fd_pr__nfet_01v8 L=0.5u W=1u
M12576 o7 ibias vss vss sky130_fd_pr__nfet_01v8 L=0.5u W=1u
M12577 o7 ibias vss vss sky130_fd_pr__nfet_01v8 L=0.5u W=1u
M12578 o7 ibias vss vss sky130_fd_pr__nfet_01v8 L=0.5u W=1u
M12579 o7 ibias vss vss sky130_fd_pr__nfet_01v8 L=0.5u W=1u
M12580 o7 ibias vss vss sky130_fd_pr__nfet_01v8 L=0.5u W=1u
M12581 o7 ibias vss vss sky130_fd_pr__nfet_01v8 L=0.5u W=1u
M12582 o7 ibias vss vss sky130_fd_pr__nfet_01v8 L=0.5u W=1u
M12583 o7 ibias vss vss sky130_fd_pr__nfet_01v8 L=0.5u W=1u
M12584 o7 ibias vss vss sky130_fd_pr__nfet_01v8 L=0.5u W=1u
M12585 o7 ibias vss vss sky130_fd_pr__nfet_01v8 L=0.5u W=1u
M12586 o7 ibias vss vss sky130_fd_pr__nfet_01v8 L=0.5u W=1u
M12587 o7 ibias vss vss sky130_fd_pr__nfet_01v8 L=0.5u W=1u
M12588 o7 ibias vss vss sky130_fd_pr__nfet_01v8 L=0.5u W=1u
M12589 o7 ibias vss vss sky130_fd_pr__nfet_01v8 L=0.5u W=1u
M12590 o7 ibias vss vss sky130_fd_pr__nfet_01v8 L=0.5u W=1u
M12591 o7 ibias vss vss sky130_fd_pr__nfet_01v8 L=0.5u W=1u
M12592 o7 ibias vss vss sky130_fd_pr__nfet_01v8 L=0.5u W=1u
M12593 o7 ibias vss vss sky130_fd_pr__nfet_01v8 L=0.5u W=1u
M12594 o7 ibias vss vss sky130_fd_pr__nfet_01v8 L=0.5u W=1u
M12595 o7 ibias vss vss sky130_fd_pr__nfet_01v8 L=0.5u W=1u
M12596 o7 ibias vss vss sky130_fd_pr__nfet_01v8 L=0.5u W=1u
M12597 o7 ibias vss vss sky130_fd_pr__nfet_01v8 L=0.5u W=1u
M12598 o7 ibias vss vss sky130_fd_pr__nfet_01v8 L=0.5u W=1u
M12599 o7 ibias vss vss sky130_fd_pr__nfet_01v8 L=0.5u W=1u
M12600 o7 ibias vss vss sky130_fd_pr__nfet_01v8 L=0.5u W=1u
M12601 o7 ibias vss vss sky130_fd_pr__nfet_01v8 L=0.5u W=1u
M12602 o7 ibias vss vss sky130_fd_pr__nfet_01v8 L=0.5u W=1u
M12603 o7 ibias vss vss sky130_fd_pr__nfet_01v8 L=0.5u W=1u
M12604 o7 ibias vss vss sky130_fd_pr__nfet_01v8 L=0.5u W=1u
M12605 o7 ibias vss vss sky130_fd_pr__nfet_01v8 L=0.5u W=1u
M12606 o7 ibias vss vss sky130_fd_pr__nfet_01v8 L=0.5u W=1u
M12607 o7 ibias vss vss sky130_fd_pr__nfet_01v8 L=0.5u W=1u
M12608 o7 ibias vss vss sky130_fd_pr__nfet_01v8 L=0.5u W=1u
M12609 o7 ibias vss vss sky130_fd_pr__nfet_01v8 L=0.5u W=1u
M12610 o7 ibias vss vss sky130_fd_pr__nfet_01v8 L=0.5u W=1u
M12611 o7 ibias vss vss sky130_fd_pr__nfet_01v8 L=0.5u W=1u
M12612 o7 ibias vss vss sky130_fd_pr__nfet_01v8 L=0.5u W=1u
M12613 o7 ibias vss vss sky130_fd_pr__nfet_01v8 L=0.5u W=1u
M12614 o7 ibias vss vss sky130_fd_pr__nfet_01v8 L=0.5u W=1u
M12615 o7 ibias vss vss sky130_fd_pr__nfet_01v8 L=0.5u W=1u
M12616 o7 ibias vss vss sky130_fd_pr__nfet_01v8 L=0.5u W=1u
M12617 o7 ibias vss vss sky130_fd_pr__nfet_01v8 L=0.5u W=1u
M12618 o7 ibias vss vss sky130_fd_pr__nfet_01v8 L=0.5u W=1u
M12619 o7 ibias vss vss sky130_fd_pr__nfet_01v8 L=0.5u W=1u
M12620 o7 ibias vss vss sky130_fd_pr__nfet_01v8 L=0.5u W=1u
M12621 o7 ibias vss vss sky130_fd_pr__nfet_01v8 L=0.5u W=1u
M12622 o7 ibias vss vss sky130_fd_pr__nfet_01v8 L=0.5u W=1u
M12623 o7 ibias vss vss sky130_fd_pr__nfet_01v8 L=0.5u W=1u
M12624 o7 ibias vss vss sky130_fd_pr__nfet_01v8 L=0.5u W=1u
M12625 o7 ibias vss vss sky130_fd_pr__nfet_01v8 L=0.5u W=1u
M12626 o7 ibias vss vss sky130_fd_pr__nfet_01v8 L=0.5u W=1u
M12627 o7 ibias vss vss sky130_fd_pr__nfet_01v8 L=0.5u W=1u
M12628 o7 ibias vss vss sky130_fd_pr__nfet_01v8 L=0.5u W=1u
M12629 o7 ibias vss vss sky130_fd_pr__nfet_01v8 L=0.5u W=1u
M12630 o7 ibias vss vss sky130_fd_pr__nfet_01v8 L=0.5u W=1u
M12631 o7 ibias vss vss sky130_fd_pr__nfet_01v8 L=0.5u W=1u
M12632 o7 ibias vss vss sky130_fd_pr__nfet_01v8 L=0.5u W=1u
M12633 o7 ibias vss vss sky130_fd_pr__nfet_01v8 L=0.5u W=1u
M12634 o7 ibias vss vss sky130_fd_pr__nfet_01v8 L=0.5u W=1u
M12635 o7 ibias vss vss sky130_fd_pr__nfet_01v8 L=0.5u W=1u
M12636 o7 ibias vss vss sky130_fd_pr__nfet_01v8 L=0.5u W=1u
M12637 o7 ibias vss vss sky130_fd_pr__nfet_01v8 L=0.5u W=1u
M12638 o7 ibias vss vss sky130_fd_pr__nfet_01v8 L=0.5u W=1u
M12639 o7 ibias vss vss sky130_fd_pr__nfet_01v8 L=0.5u W=1u
M12640 o7 ibias vss vss sky130_fd_pr__nfet_01v8 L=0.5u W=1u
M12641 o7 ibias vss vss sky130_fd_pr__nfet_01v8 L=0.5u W=1u
M12642 o7 ibias vss vss sky130_fd_pr__nfet_01v8 L=0.5u W=1u
M12643 o7 ibias vss vss sky130_fd_pr__nfet_01v8 L=0.5u W=1u
M12644 o7 ibias vss vss sky130_fd_pr__nfet_01v8 L=0.5u W=1u
M12645 o7 ibias vss vss sky130_fd_pr__nfet_01v8 L=0.5u W=1u
M12646 o7 ibias vss vss sky130_fd_pr__nfet_01v8 L=0.5u W=1u
M12647 o7 ibias vss vss sky130_fd_pr__nfet_01v8 L=0.5u W=1u
M12648 o7 ibias vss vss sky130_fd_pr__nfet_01v8 L=0.5u W=1u
M12649 o7 ibias vss vss sky130_fd_pr__nfet_01v8 L=0.5u W=1u
M12650 o7 ibias vss vss sky130_fd_pr__nfet_01v8 L=0.5u W=1u
M12651 o7 ibias vss vss sky130_fd_pr__nfet_01v8 L=0.5u W=1u
M12652 o7 ibias vss vss sky130_fd_pr__nfet_01v8 L=0.5u W=1u
M12653 o7 ibias vss vss sky130_fd_pr__nfet_01v8 L=0.5u W=1u
M12654 o7 ibias vss vss sky130_fd_pr__nfet_01v8 L=0.5u W=1u
M12655 o7 ibias vss vss sky130_fd_pr__nfet_01v8 L=0.5u W=1u
M12656 o7 ibias vss vss sky130_fd_pr__nfet_01v8 L=0.5u W=1u
M12657 o7 ibias vss vss sky130_fd_pr__nfet_01v8 L=0.5u W=1u
M12658 o7 ibias vss vss sky130_fd_pr__nfet_01v8 L=0.5u W=1u
M12659 o7 ibias vss vss sky130_fd_pr__nfet_01v8 L=0.5u W=1u
M12660 o7 ibias vss vss sky130_fd_pr__nfet_01v8 L=0.5u W=1u
M12661 o7 ibias vss vss sky130_fd_pr__nfet_01v8 L=0.5u W=1u
M12662 o7 ibias vss vss sky130_fd_pr__nfet_01v8 L=0.5u W=1u
M12663 o7 ibias vss vss sky130_fd_pr__nfet_01v8 L=0.5u W=1u
M12664 o7 ibias vss vss sky130_fd_pr__nfet_01v8 L=0.5u W=1u
M12665 o7 ibias vss vss sky130_fd_pr__nfet_01v8 L=0.5u W=1u
M12666 o7 ibias vss vss sky130_fd_pr__nfet_01v8 L=0.5u W=1u
M12667 o7 ibias vss vss sky130_fd_pr__nfet_01v8 L=0.5u W=1u
M12668 o7 ibias vss vss sky130_fd_pr__nfet_01v8 L=0.5u W=1u
M12669 o7 ibias vss vss sky130_fd_pr__nfet_01v8 L=0.5u W=1u
M12670 o7 ibias vss vss sky130_fd_pr__nfet_01v8 L=0.5u W=1u
M12671 o7 ibias vss vss sky130_fd_pr__nfet_01v8 L=0.5u W=1u
M12672 o7 ibias vss vss sky130_fd_pr__nfet_01v8 L=0.5u W=1u
M12673 o7 ibias vss vss sky130_fd_pr__nfet_01v8 L=0.5u W=1u
M12674 o7 ibias vss vss sky130_fd_pr__nfet_01v8 L=0.5u W=1u
M12675 o7 ibias vss vss sky130_fd_pr__nfet_01v8 L=0.5u W=1u
M12676 o7 ibias vss vss sky130_fd_pr__nfet_01v8 L=0.5u W=1u
M12677 o7 ibias vss vss sky130_fd_pr__nfet_01v8 L=0.5u W=1u
M12678 o7 ibias vss vss sky130_fd_pr__nfet_01v8 L=0.5u W=1u
M12679 o7 ibias vss vss sky130_fd_pr__nfet_01v8 L=0.5u W=1u
M12680 o7 ibias vss vss sky130_fd_pr__nfet_01v8 L=0.5u W=1u
M12681 o7 ibias vss vss sky130_fd_pr__nfet_01v8 L=0.5u W=1u
M12682 o7 ibias vss vss sky130_fd_pr__nfet_01v8 L=0.5u W=1u
M12683 o7 ibias vss vss sky130_fd_pr__nfet_01v8 L=0.5u W=1u
M12684 o7 ibias vss vss sky130_fd_pr__nfet_01v8 L=0.5u W=1u
M12685 o7 ibias vss vss sky130_fd_pr__nfet_01v8 L=0.5u W=1u
M12686 o7 ibias vss vss sky130_fd_pr__nfet_01v8 L=0.5u W=1u
M12687 o7 ibias vss vss sky130_fd_pr__nfet_01v8 L=0.5u W=1u
M12688 o7 ibias vss vss sky130_fd_pr__nfet_01v8 L=0.5u W=1u
M12689 o7 ibias vss vss sky130_fd_pr__nfet_01v8 L=0.5u W=1u
M12690 o7 ibias vss vss sky130_fd_pr__nfet_01v8 L=0.5u W=1u
M12691 o7 ibias vss vss sky130_fd_pr__nfet_01v8 L=0.5u W=1u
M12692 o7 ibias vss vss sky130_fd_pr__nfet_01v8 L=0.5u W=1u
M12693 o7 ibias vss vss sky130_fd_pr__nfet_01v8 L=0.5u W=1u
M12694 o7 ibias vss vss sky130_fd_pr__nfet_01v8 L=0.5u W=1u
M12695 o7 ibias vss vss sky130_fd_pr__nfet_01v8 L=0.5u W=1u
M12696 o7 ibias vss vss sky130_fd_pr__nfet_01v8 L=0.5u W=1u
M12697 o7 ibias vss vss sky130_fd_pr__nfet_01v8 L=0.5u W=1u
M12698 o7 ibias vss vss sky130_fd_pr__nfet_01v8 L=0.5u W=1u
M12699 o7 ibias vss vss sky130_fd_pr__nfet_01v8 L=0.5u W=1u
M12700 o7 ibias vss vss sky130_fd_pr__nfet_01v8 L=0.5u W=1u
M12701 o7 ibias vss vss sky130_fd_pr__nfet_01v8 L=0.5u W=1u
M12702 o7 ibias vss vss sky130_fd_pr__nfet_01v8 L=0.5u W=1u
M12703 o7 ibias vss vss sky130_fd_pr__nfet_01v8 L=0.5u W=1u
M12704 o7 ibias vss vss sky130_fd_pr__nfet_01v8 L=0.5u W=1u
M12705 o7 ibias vss vss sky130_fd_pr__nfet_01v8 L=0.5u W=1u
M12706 o7 ibias vss vss sky130_fd_pr__nfet_01v8 L=0.5u W=1u
M12707 o7 ibias vss vss sky130_fd_pr__nfet_01v8 L=0.5u W=1u
M12708 o7 ibias vss vss sky130_fd_pr__nfet_01v8 L=0.5u W=1u
M12709 o7 ibias vss vss sky130_fd_pr__nfet_01v8 L=0.5u W=1u
M12710 o7 ibias vss vss sky130_fd_pr__nfet_01v8 L=0.5u W=1u
M12711 o7 ibias vss vss sky130_fd_pr__nfet_01v8 L=0.5u W=1u
M12712 o7 ibias vss vss sky130_fd_pr__nfet_01v8 L=0.5u W=1u
M12713 o7 ibias vss vss sky130_fd_pr__nfet_01v8 L=0.5u W=1u
M12714 o7 ibias vss vss sky130_fd_pr__nfet_01v8 L=0.5u W=1u
M12715 o7 ibias vss vss sky130_fd_pr__nfet_01v8 L=0.5u W=1u
M12716 o7 ibias vss vss sky130_fd_pr__nfet_01v8 L=0.5u W=1u
M12717 o7 ibias vss vss sky130_fd_pr__nfet_01v8 L=0.5u W=1u
M12718 o7 ibias vss vss sky130_fd_pr__nfet_01v8 L=0.5u W=1u
M12719 o7 ibias vss vss sky130_fd_pr__nfet_01v8 L=0.5u W=1u
M12720 o7 ibias vss vss sky130_fd_pr__nfet_01v8 L=0.5u W=1u
M12721 o7 ibias vss vss sky130_fd_pr__nfet_01v8 L=0.5u W=1u
M12722 o7 ibias vss vss sky130_fd_pr__nfet_01v8 L=0.5u W=1u
M12723 o7 ibias vss vss sky130_fd_pr__nfet_01v8 L=0.5u W=1u
M12724 o7 ibias vss vss sky130_fd_pr__nfet_01v8 L=0.5u W=1u
M12725 o7 ibias vss vss sky130_fd_pr__nfet_01v8 L=0.5u W=1u
M12726 o7 ibias vss vss sky130_fd_pr__nfet_01v8 L=0.5u W=1u
M12727 o7 ibias vss vss sky130_fd_pr__nfet_01v8 L=0.5u W=1u
M12728 o7 ibias vss vss sky130_fd_pr__nfet_01v8 L=0.5u W=1u
M12729 o7 ibias vss vss sky130_fd_pr__nfet_01v8 L=0.5u W=1u
M12730 o7 ibias vss vss sky130_fd_pr__nfet_01v8 L=0.5u W=1u
M12731 o7 ibias vss vss sky130_fd_pr__nfet_01v8 L=0.5u W=1u
M12732 o7 ibias vss vss sky130_fd_pr__nfet_01v8 L=0.5u W=1u
M12733 o7 ibias vss vss sky130_fd_pr__nfet_01v8 L=0.5u W=1u
M12734 o7 ibias vss vss sky130_fd_pr__nfet_01v8 L=0.5u W=1u
M12735 o7 ibias vss vss sky130_fd_pr__nfet_01v8 L=0.5u W=1u
M12736 o7 ibias vss vss sky130_fd_pr__nfet_01v8 L=0.5u W=1u
M12737 o7 ibias vss vss sky130_fd_pr__nfet_01v8 L=0.5u W=1u
M12738 o7 ibias vss vss sky130_fd_pr__nfet_01v8 L=0.5u W=1u
M12739 o7 ibias vss vss sky130_fd_pr__nfet_01v8 L=0.5u W=1u
M12740 o7 ibias vss vss sky130_fd_pr__nfet_01v8 L=0.5u W=1u
M12741 o7 ibias vss vss sky130_fd_pr__nfet_01v8 L=0.5u W=1u
M12742 o7 ibias vss vss sky130_fd_pr__nfet_01v8 L=0.5u W=1u
M12743 o7 ibias vss vss sky130_fd_pr__nfet_01v8 L=0.5u W=1u
M12744 o7 ibias vss vss sky130_fd_pr__nfet_01v8 L=0.5u W=1u
M12745 o7 ibias vss vss sky130_fd_pr__nfet_01v8 L=0.5u W=1u
M12746 o7 ibias vss vss sky130_fd_pr__nfet_01v8 L=0.5u W=1u
M12747 o7 ibias vss vss sky130_fd_pr__nfet_01v8 L=0.5u W=1u
M12748 o7 ibias vss vss sky130_fd_pr__nfet_01v8 L=0.5u W=1u
M12749 o7 ibias vss vss sky130_fd_pr__nfet_01v8 L=0.5u W=1u
M12750 o7 ibias vss vss sky130_fd_pr__nfet_01v8 L=0.5u W=1u
M12751 o7 ibias vss vss sky130_fd_pr__nfet_01v8 L=0.5u W=1u
M12752 o7 ibias vss vss sky130_fd_pr__nfet_01v8 L=0.5u W=1u
M12753 o7 ibias vss vss sky130_fd_pr__nfet_01v8 L=0.5u W=1u
M12754 o7 ibias vss vss sky130_fd_pr__nfet_01v8 L=0.5u W=1u
M12755 o7 ibias vss vss sky130_fd_pr__nfet_01v8 L=0.5u W=1u
M12756 o7 ibias vss vss sky130_fd_pr__nfet_01v8 L=0.5u W=1u
M12757 o7 ibias vss vss sky130_fd_pr__nfet_01v8 L=0.5u W=1u
M12758 o7 ibias vss vss sky130_fd_pr__nfet_01v8 L=0.5u W=1u
M12759 o7 ibias vss vss sky130_fd_pr__nfet_01v8 L=0.5u W=1u
M12760 o7 ibias vss vss sky130_fd_pr__nfet_01v8 L=0.5u W=1u
M12761 o7 ibias vss vss sky130_fd_pr__nfet_01v8 L=0.5u W=1u
M12762 o7 ibias vss vss sky130_fd_pr__nfet_01v8 L=0.5u W=1u
M12763 o7 ibias vss vss sky130_fd_pr__nfet_01v8 L=0.5u W=1u
M12764 o7 ibias vss vss sky130_fd_pr__nfet_01v8 L=0.5u W=1u
M12765 o7 ibias vss vss sky130_fd_pr__nfet_01v8 L=0.5u W=1u
M12766 o7 ibias vss vss sky130_fd_pr__nfet_01v8 L=0.5u W=1u
M12767 o7 ibias vss vss sky130_fd_pr__nfet_01v8 L=0.5u W=1u
M12768 o7 ibias vss vss sky130_fd_pr__nfet_01v8 L=0.5u W=1u
M12769 o7 ibias vss vss sky130_fd_pr__nfet_01v8 L=0.5u W=1u
M12770 o7 ibias vss vss sky130_fd_pr__nfet_01v8 L=0.5u W=1u
M12771 o7 ibias vss vss sky130_fd_pr__nfet_01v8 L=0.5u W=1u
M12772 o7 ibias vss vss sky130_fd_pr__nfet_01v8 L=0.5u W=1u
M12773 o7 ibias vss vss sky130_fd_pr__nfet_01v8 L=0.5u W=1u
M12774 o7 ibias vss vss sky130_fd_pr__nfet_01v8 L=0.5u W=1u
M12775 o7 ibias vss vss sky130_fd_pr__nfet_01v8 L=0.5u W=1u
M12776 o7 ibias vss vss sky130_fd_pr__nfet_01v8 L=0.5u W=1u
M12777 o7 ibias vss vss sky130_fd_pr__nfet_01v8 L=0.5u W=1u
M12778 o7 ibias vss vss sky130_fd_pr__nfet_01v8 L=0.5u W=1u
M12779 o7 ibias vss vss sky130_fd_pr__nfet_01v8 L=0.5u W=1u
M12780 o7 ibias vss vss sky130_fd_pr__nfet_01v8 L=0.5u W=1u
M12781 o7 ibias vss vss sky130_fd_pr__nfet_01v8 L=0.5u W=1u
M12782 o7 ibias vss vss sky130_fd_pr__nfet_01v8 L=0.5u W=1u
M12783 o7 ibias vss vss sky130_fd_pr__nfet_01v8 L=0.5u W=1u
M12784 o7 ibias vss vss sky130_fd_pr__nfet_01v8 L=0.5u W=1u
M12785 o7 ibias vss vss sky130_fd_pr__nfet_01v8 L=0.5u W=1u
M12786 o7 ibias vss vss sky130_fd_pr__nfet_01v8 L=0.5u W=1u
M12787 o7 ibias vss vss sky130_fd_pr__nfet_01v8 L=0.5u W=1u
M12788 o7 ibias vss vss sky130_fd_pr__nfet_01v8 L=0.5u W=1u
M12789 o7 ibias vss vss sky130_fd_pr__nfet_01v8 L=0.5u W=1u
M12790 o7 ibias vss vss sky130_fd_pr__nfet_01v8 L=0.5u W=1u
M12791 o7 ibias vss vss sky130_fd_pr__nfet_01v8 L=0.5u W=1u
M12792 o7 ibias vss vss sky130_fd_pr__nfet_01v8 L=0.5u W=1u
M12793 o7 ibias vss vss sky130_fd_pr__nfet_01v8 L=0.5u W=1u
M12794 o7 ibias vss vss sky130_fd_pr__nfet_01v8 L=0.5u W=1u
M12795 o7 ibias vss vss sky130_fd_pr__nfet_01v8 L=0.5u W=1u
M12796 o7 ibias vss vss sky130_fd_pr__nfet_01v8 L=0.5u W=1u
M12797 o7 ibias vss vss sky130_fd_pr__nfet_01v8 L=0.5u W=1u
M12798 o7 ibias vss vss sky130_fd_pr__nfet_01v8 L=0.5u W=1u
M12799 o7 ibias vss vss sky130_fd_pr__nfet_01v8 L=0.5u W=1u
M12800 o7 ibias vss vss sky130_fd_pr__nfet_01v8 L=0.5u W=1u
M12801 o7 ibias vss vss sky130_fd_pr__nfet_01v8 L=0.5u W=1u
M12802 o7 ibias vss vss sky130_fd_pr__nfet_01v8 L=0.5u W=1u
M12803 o7 ibias vss vss sky130_fd_pr__nfet_01v8 L=0.5u W=1u
M12804 o7 ibias vss vss sky130_fd_pr__nfet_01v8 L=0.5u W=1u
M12805 o7 ibias vss vss sky130_fd_pr__nfet_01v8 L=0.5u W=1u
M12806 o7 ibias vss vss sky130_fd_pr__nfet_01v8 L=0.5u W=1u
M12807 o7 ibias vss vss sky130_fd_pr__nfet_01v8 L=0.5u W=1u
M12808 o7 ibias vss vss sky130_fd_pr__nfet_01v8 L=0.5u W=1u
M12809 o7 ibias vss vss sky130_fd_pr__nfet_01v8 L=0.5u W=1u
M12810 o7 ibias vss vss sky130_fd_pr__nfet_01v8 L=0.5u W=1u
M12811 o7 ibias vss vss sky130_fd_pr__nfet_01v8 L=0.5u W=1u
M12812 o7 ibias vss vss sky130_fd_pr__nfet_01v8 L=0.5u W=1u
M12813 o7 ibias vss vss sky130_fd_pr__nfet_01v8 L=0.5u W=1u
M12814 o7 ibias vss vss sky130_fd_pr__nfet_01v8 L=0.5u W=1u
M12815 o7 ibias vss vss sky130_fd_pr__nfet_01v8 L=0.5u W=1u
M12816 o7 ibias vss vss sky130_fd_pr__nfet_01v8 L=0.5u W=1u
M12817 o7 ibias vss vss sky130_fd_pr__nfet_01v8 L=0.5u W=1u
M12818 o7 ibias vss vss sky130_fd_pr__nfet_01v8 L=0.5u W=1u
M12819 o7 ibias vss vss sky130_fd_pr__nfet_01v8 L=0.5u W=1u
M12820 o7 ibias vss vss sky130_fd_pr__nfet_01v8 L=0.5u W=1u
M12821 o7 ibias vss vss sky130_fd_pr__nfet_01v8 L=0.5u W=1u
M12822 o7 ibias vss vss sky130_fd_pr__nfet_01v8 L=0.5u W=1u
M12823 o7 ibias vss vss sky130_fd_pr__nfet_01v8 L=0.5u W=1u
M12824 o7 ibias vss vss sky130_fd_pr__nfet_01v8 L=0.5u W=1u
M12825 o7 ibias vss vss sky130_fd_pr__nfet_01v8 L=0.5u W=1u
M12826 o7 ibias vss vss sky130_fd_pr__nfet_01v8 L=0.5u W=1u
M12827 o7 ibias vss vss sky130_fd_pr__nfet_01v8 L=0.5u W=1u
M12828 o7 ibias vss vss sky130_fd_pr__nfet_01v8 L=0.5u W=1u
M12829 o7 ibias vss vss sky130_fd_pr__nfet_01v8 L=0.5u W=1u
M12830 o7 ibias vss vss sky130_fd_pr__nfet_01v8 L=0.5u W=1u
M12831 o7 ibias vss vss sky130_fd_pr__nfet_01v8 L=0.5u W=1u
M12832 o7 ibias vss vss sky130_fd_pr__nfet_01v8 L=0.5u W=1u
M12833 o7 ibias vss vss sky130_fd_pr__nfet_01v8 L=0.5u W=1u
M12834 o7 ibias vss vss sky130_fd_pr__nfet_01v8 L=0.5u W=1u
M12835 o7 ibias vss vss sky130_fd_pr__nfet_01v8 L=0.5u W=1u
M12836 o7 ibias vss vss sky130_fd_pr__nfet_01v8 L=0.5u W=1u
M12837 o7 ibias vss vss sky130_fd_pr__nfet_01v8 L=0.5u W=1u
M12838 o7 ibias vss vss sky130_fd_pr__nfet_01v8 L=0.5u W=1u
M12839 o7 ibias vss vss sky130_fd_pr__nfet_01v8 L=0.5u W=1u
M12840 o7 ibias vss vss sky130_fd_pr__nfet_01v8 L=0.5u W=1u
M12841 o7 ibias vss vss sky130_fd_pr__nfet_01v8 L=0.5u W=1u
M12842 o7 ibias vss vss sky130_fd_pr__nfet_01v8 L=0.5u W=1u
M12843 o7 ibias vss vss sky130_fd_pr__nfet_01v8 L=0.5u W=1u
M12844 o7 ibias vss vss sky130_fd_pr__nfet_01v8 L=0.5u W=1u
M12845 o7 ibias vss vss sky130_fd_pr__nfet_01v8 L=0.5u W=1u
M12846 o7 ibias vss vss sky130_fd_pr__nfet_01v8 L=0.5u W=1u
M12847 o7 ibias vss vss sky130_fd_pr__nfet_01v8 L=0.5u W=1u
M12848 o7 ibias vss vss sky130_fd_pr__nfet_01v8 L=0.5u W=1u
M12849 o7 ibias vss vss sky130_fd_pr__nfet_01v8 L=0.5u W=1u
M12850 o7 ibias vss vss sky130_fd_pr__nfet_01v8 L=0.5u W=1u
M12851 o7 ibias vss vss sky130_fd_pr__nfet_01v8 L=0.5u W=1u
M12852 o7 ibias vss vss sky130_fd_pr__nfet_01v8 L=0.5u W=1u
M12853 o7 ibias vss vss sky130_fd_pr__nfet_01v8 L=0.5u W=1u
M12854 o7 ibias vss vss sky130_fd_pr__nfet_01v8 L=0.5u W=1u
M12855 o7 ibias vss vss sky130_fd_pr__nfet_01v8 L=0.5u W=1u
M12856 o7 ibias vss vss sky130_fd_pr__nfet_01v8 L=0.5u W=1u
M12857 o7 ibias vss vss sky130_fd_pr__nfet_01v8 L=0.5u W=1u
M12858 o7 ibias vss vss sky130_fd_pr__nfet_01v8 L=0.5u W=1u
M12859 o7 ibias vss vss sky130_fd_pr__nfet_01v8 L=0.5u W=1u
M12860 o7 ibias vss vss sky130_fd_pr__nfet_01v8 L=0.5u W=1u
M12861 o7 ibias vss vss sky130_fd_pr__nfet_01v8 L=0.5u W=1u
M12862 o7 ibias vss vss sky130_fd_pr__nfet_01v8 L=0.5u W=1u
M12863 o7 ibias vss vss sky130_fd_pr__nfet_01v8 L=0.5u W=1u
M12864 o7 ibias vss vss sky130_fd_pr__nfet_01v8 L=0.5u W=1u
M12865 o7 ibias vss vss sky130_fd_pr__nfet_01v8 L=0.5u W=1u
M12866 o7 ibias vss vss sky130_fd_pr__nfet_01v8 L=0.5u W=1u
M12867 o7 ibias vss vss sky130_fd_pr__nfet_01v8 L=0.5u W=1u
M12868 o7 ibias vss vss sky130_fd_pr__nfet_01v8 L=0.5u W=1u
M12869 o7 ibias vss vss sky130_fd_pr__nfet_01v8 L=0.5u W=1u
M12870 o7 ibias vss vss sky130_fd_pr__nfet_01v8 L=0.5u W=1u
M12871 o7 ibias vss vss sky130_fd_pr__nfet_01v8 L=0.5u W=1u
M12872 o7 ibias vss vss sky130_fd_pr__nfet_01v8 L=0.5u W=1u
M12873 o7 ibias vss vss sky130_fd_pr__nfet_01v8 L=0.5u W=1u
M12874 o7 ibias vss vss sky130_fd_pr__nfet_01v8 L=0.5u W=1u
M12875 o7 ibias vss vss sky130_fd_pr__nfet_01v8 L=0.5u W=1u
M12876 o7 ibias vss vss sky130_fd_pr__nfet_01v8 L=0.5u W=1u
M12877 o7 ibias vss vss sky130_fd_pr__nfet_01v8 L=0.5u W=1u
M12878 o7 ibias vss vss sky130_fd_pr__nfet_01v8 L=0.5u W=1u
M12879 o7 ibias vss vss sky130_fd_pr__nfet_01v8 L=0.5u W=1u
M12880 o7 ibias vss vss sky130_fd_pr__nfet_01v8 L=0.5u W=1u
M12881 o7 ibias vss vss sky130_fd_pr__nfet_01v8 L=0.5u W=1u
M12882 o7 ibias vss vss sky130_fd_pr__nfet_01v8 L=0.5u W=1u
M12883 o7 ibias vss vss sky130_fd_pr__nfet_01v8 L=0.5u W=1u
M12884 o7 ibias vss vss sky130_fd_pr__nfet_01v8 L=0.5u W=1u
M12885 o7 ibias vss vss sky130_fd_pr__nfet_01v8 L=0.5u W=1u
M12886 o7 ibias vss vss sky130_fd_pr__nfet_01v8 L=0.5u W=1u
M12887 o7 ibias vss vss sky130_fd_pr__nfet_01v8 L=0.5u W=1u
M12888 o7 ibias vss vss sky130_fd_pr__nfet_01v8 L=0.5u W=1u
M12889 o7 ibias vss vss sky130_fd_pr__nfet_01v8 L=0.5u W=1u
M12890 o7 ibias vss vss sky130_fd_pr__nfet_01v8 L=0.5u W=1u
M12891 o7 ibias vss vss sky130_fd_pr__nfet_01v8 L=0.5u W=1u
M12892 o7 ibias vss vss sky130_fd_pr__nfet_01v8 L=0.5u W=1u
M12893 o7 ibias vss vss sky130_fd_pr__nfet_01v8 L=0.5u W=1u
M12894 o7 ibias vss vss sky130_fd_pr__nfet_01v8 L=0.5u W=1u
M12895 o7 ibias vss vss sky130_fd_pr__nfet_01v8 L=0.5u W=1u
M12896 o7 ibias vss vss sky130_fd_pr__nfet_01v8 L=0.5u W=1u
M12897 o7 ibias vss vss sky130_fd_pr__nfet_01v8 L=0.5u W=1u
M12898 o7 ibias vss vss sky130_fd_pr__nfet_01v8 L=0.5u W=1u
M12899 o7 ibias vss vss sky130_fd_pr__nfet_01v8 L=0.5u W=1u
M12900 o7 ibias vss vss sky130_fd_pr__nfet_01v8 L=0.5u W=1u
M12901 o7 ibias vss vss sky130_fd_pr__nfet_01v8 L=0.5u W=1u
M12902 o7 ibias vss vss sky130_fd_pr__nfet_01v8 L=0.5u W=1u
M12903 o7 ibias vss vss sky130_fd_pr__nfet_01v8 L=0.5u W=1u
M12904 o7 ibias vss vss sky130_fd_pr__nfet_01v8 L=0.5u W=1u
M12905 o7 ibias vss vss sky130_fd_pr__nfet_01v8 L=0.5u W=1u
M12906 o7 ibias vss vss sky130_fd_pr__nfet_01v8 L=0.5u W=1u
M12907 o7 ibias vss vss sky130_fd_pr__nfet_01v8 L=0.5u W=1u
M12908 o7 ibias vss vss sky130_fd_pr__nfet_01v8 L=0.5u W=1u
M12909 o7 ibias vss vss sky130_fd_pr__nfet_01v8 L=0.5u W=1u
M12910 o7 ibias vss vss sky130_fd_pr__nfet_01v8 L=0.5u W=1u
M12911 o7 ibias vss vss sky130_fd_pr__nfet_01v8 L=0.5u W=1u
M12912 o7 ibias vss vss sky130_fd_pr__nfet_01v8 L=0.5u W=1u
M12913 o7 ibias vss vss sky130_fd_pr__nfet_01v8 L=0.5u W=1u
M12914 o7 ibias vss vss sky130_fd_pr__nfet_01v8 L=0.5u W=1u
M12915 o7 ibias vss vss sky130_fd_pr__nfet_01v8 L=0.5u W=1u
M12916 o7 ibias vss vss sky130_fd_pr__nfet_01v8 L=0.5u W=1u
M12917 o7 ibias vss vss sky130_fd_pr__nfet_01v8 L=0.5u W=1u
M12918 o7 ibias vss vss sky130_fd_pr__nfet_01v8 L=0.5u W=1u
M12919 o7 ibias vss vss sky130_fd_pr__nfet_01v8 L=0.5u W=1u
M12920 o7 ibias vss vss sky130_fd_pr__nfet_01v8 L=0.5u W=1u
M12921 o7 ibias vss vss sky130_fd_pr__nfet_01v8 L=0.5u W=1u
M12922 o7 ibias vss vss sky130_fd_pr__nfet_01v8 L=0.5u W=1u
M12923 o7 ibias vss vss sky130_fd_pr__nfet_01v8 L=0.5u W=1u
M12924 o7 ibias vss vss sky130_fd_pr__nfet_01v8 L=0.5u W=1u
M12925 o7 ibias vss vss sky130_fd_pr__nfet_01v8 L=0.5u W=1u
M12926 o7 ibias vss vss sky130_fd_pr__nfet_01v8 L=0.5u W=1u
M12927 o7 ibias vss vss sky130_fd_pr__nfet_01v8 L=0.5u W=1u
M12928 o7 ibias vss vss sky130_fd_pr__nfet_01v8 L=0.5u W=1u
M12929 o7 ibias vss vss sky130_fd_pr__nfet_01v8 L=0.5u W=1u
M12930 o7 ibias vss vss sky130_fd_pr__nfet_01v8 L=0.5u W=1u
M12931 o7 ibias vss vss sky130_fd_pr__nfet_01v8 L=0.5u W=1u
M12932 o7 ibias vss vss sky130_fd_pr__nfet_01v8 L=0.5u W=1u
M12933 o7 ibias vss vss sky130_fd_pr__nfet_01v8 L=0.5u W=1u
M12934 o7 ibias vss vss sky130_fd_pr__nfet_01v8 L=0.5u W=1u
M12935 o7 ibias vss vss sky130_fd_pr__nfet_01v8 L=0.5u W=1u
M12936 o7 ibias vss vss sky130_fd_pr__nfet_01v8 L=0.5u W=1u
M12937 o7 ibias vss vss sky130_fd_pr__nfet_01v8 L=0.5u W=1u
M12938 o7 ibias vss vss sky130_fd_pr__nfet_01v8 L=0.5u W=1u
M12939 o7 ibias vss vss sky130_fd_pr__nfet_01v8 L=0.5u W=1u
M12940 o7 ibias vss vss sky130_fd_pr__nfet_01v8 L=0.5u W=1u
M12941 o7 ibias vss vss sky130_fd_pr__nfet_01v8 L=0.5u W=1u
M12942 o7 ibias vss vss sky130_fd_pr__nfet_01v8 L=0.5u W=1u
M12943 o7 ibias vss vss sky130_fd_pr__nfet_01v8 L=0.5u W=1u
M12944 o7 ibias vss vss sky130_fd_pr__nfet_01v8 L=0.5u W=1u
M12945 o7 ibias vss vss sky130_fd_pr__nfet_01v8 L=0.5u W=1u
M12946 o7 ibias vss vss sky130_fd_pr__nfet_01v8 L=0.5u W=1u
M12947 o7 ibias vss vss sky130_fd_pr__nfet_01v8 L=0.5u W=1u
M12948 o7 ibias vss vss sky130_fd_pr__nfet_01v8 L=0.5u W=1u
M12949 o7 ibias vss vss sky130_fd_pr__nfet_01v8 L=0.5u W=1u
M12950 o7 ibias vss vss sky130_fd_pr__nfet_01v8 L=0.5u W=1u
M12951 o7 ibias vss vss sky130_fd_pr__nfet_01v8 L=0.5u W=1u
M12952 o7 ibias vss vss sky130_fd_pr__nfet_01v8 L=0.5u W=1u
M12953 o7 ibias vss vss sky130_fd_pr__nfet_01v8 L=0.5u W=1u
M12954 o7 ibias vss vss sky130_fd_pr__nfet_01v8 L=0.5u W=1u
M12955 o7 ibias vss vss sky130_fd_pr__nfet_01v8 L=0.5u W=1u
M12956 o7 ibias vss vss sky130_fd_pr__nfet_01v8 L=0.5u W=1u
M12957 o7 ibias vss vss sky130_fd_pr__nfet_01v8 L=0.5u W=1u
M12958 o7 ibias vss vss sky130_fd_pr__nfet_01v8 L=0.5u W=1u
M12959 o7 ibias vss vss sky130_fd_pr__nfet_01v8 L=0.5u W=1u
M12960 o7 ibias vss vss sky130_fd_pr__nfet_01v8 L=0.5u W=1u
M12961 o7 ibias vss vss sky130_fd_pr__nfet_01v8 L=0.5u W=1u
M12962 o7 ibias vss vss sky130_fd_pr__nfet_01v8 L=0.5u W=1u
M12963 o7 ibias vss vss sky130_fd_pr__nfet_01v8 L=0.5u W=1u
M12964 o7 ibias vss vss sky130_fd_pr__nfet_01v8 L=0.5u W=1u
M12965 o7 ibias vss vss sky130_fd_pr__nfet_01v8 L=0.5u W=1u
M12966 o7 ibias vss vss sky130_fd_pr__nfet_01v8 L=0.5u W=1u
M12967 o7 ibias vss vss sky130_fd_pr__nfet_01v8 L=0.5u W=1u
M12968 o7 ibias vss vss sky130_fd_pr__nfet_01v8 L=0.5u W=1u
M12969 o7 ibias vss vss sky130_fd_pr__nfet_01v8 L=0.5u W=1u
M12970 o7 ibias vss vss sky130_fd_pr__nfet_01v8 L=0.5u W=1u
M12971 o7 ibias vss vss sky130_fd_pr__nfet_01v8 L=0.5u W=1u
M12972 o7 ibias vss vss sky130_fd_pr__nfet_01v8 L=0.5u W=1u
M12973 o7 ibias vss vss sky130_fd_pr__nfet_01v8 L=0.5u W=1u
M12974 o7 ibias vss vss sky130_fd_pr__nfet_01v8 L=0.5u W=1u
M12975 o7 ibias vss vss sky130_fd_pr__nfet_01v8 L=0.5u W=1u
M12976 o7 ibias vss vss sky130_fd_pr__nfet_01v8 L=0.5u W=1u
M12977 o7 ibias vss vss sky130_fd_pr__nfet_01v8 L=0.5u W=1u
M12978 o7 ibias vss vss sky130_fd_pr__nfet_01v8 L=0.5u W=1u
M12979 o7 ibias vss vss sky130_fd_pr__nfet_01v8 L=0.5u W=1u
M12980 o7 ibias vss vss sky130_fd_pr__nfet_01v8 L=0.5u W=1u
M12981 o7 ibias vss vss sky130_fd_pr__nfet_01v8 L=0.5u W=1u
M12982 o7 ibias vss vss sky130_fd_pr__nfet_01v8 L=0.5u W=1u
M12983 o7 ibias vss vss sky130_fd_pr__nfet_01v8 L=0.5u W=1u
M12984 o7 ibias vss vss sky130_fd_pr__nfet_01v8 L=0.5u W=1u
M12985 o7 ibias vss vss sky130_fd_pr__nfet_01v8 L=0.5u W=1u
M12986 o7 ibias vss vss sky130_fd_pr__nfet_01v8 L=0.5u W=1u
M12987 o7 ibias vss vss sky130_fd_pr__nfet_01v8 L=0.5u W=1u
M12988 o7 ibias vss vss sky130_fd_pr__nfet_01v8 L=0.5u W=1u
M12989 o7 ibias vss vss sky130_fd_pr__nfet_01v8 L=0.5u W=1u
M12990 o7 ibias vss vss sky130_fd_pr__nfet_01v8 L=0.5u W=1u
M12991 o7 ibias vss vss sky130_fd_pr__nfet_01v8 L=0.5u W=1u
M12992 o7 ibias vss vss sky130_fd_pr__nfet_01v8 L=0.5u W=1u
M12993 o7 ibias vss vss sky130_fd_pr__nfet_01v8 L=0.5u W=1u
M12994 o7 ibias vss vss sky130_fd_pr__nfet_01v8 L=0.5u W=1u
M12995 o7 ibias vss vss sky130_fd_pr__nfet_01v8 L=0.5u W=1u
M12996 o7 ibias vss vss sky130_fd_pr__nfet_01v8 L=0.5u W=1u
M12997 o7 ibias vss vss sky130_fd_pr__nfet_01v8 L=0.5u W=1u
M12998 o7 ibias vss vss sky130_fd_pr__nfet_01v8 L=0.5u W=1u
M12999 o7 ibias vss vss sky130_fd_pr__nfet_01v8 L=0.5u W=1u
M13000 o7 ibias vss vss sky130_fd_pr__nfet_01v8 L=0.5u W=1u
M13001 o7 ibias vss vss sky130_fd_pr__nfet_01v8 L=0.5u W=1u
M13002 o7 ibias vss vss sky130_fd_pr__nfet_01v8 L=0.5u W=1u
M13003 o7 ibias vss vss sky130_fd_pr__nfet_01v8 L=0.5u W=1u
M13004 o7 ibias vss vss sky130_fd_pr__nfet_01v8 L=0.5u W=1u
M13005 o7 ibias vss vss sky130_fd_pr__nfet_01v8 L=0.5u W=1u
M13006 o7 ibias vss vss sky130_fd_pr__nfet_01v8 L=0.5u W=1u
M13007 o7 ibias vss vss sky130_fd_pr__nfet_01v8 L=0.5u W=1u
M13008 o7 ibias vss vss sky130_fd_pr__nfet_01v8 L=0.5u W=1u
M13009 o7 ibias vss vss sky130_fd_pr__nfet_01v8 L=0.5u W=1u
M13010 o7 ibias vss vss sky130_fd_pr__nfet_01v8 L=0.5u W=1u
M13011 o7 ibias vss vss sky130_fd_pr__nfet_01v8 L=0.5u W=1u
M13012 o7 ibias vss vss sky130_fd_pr__nfet_01v8 L=0.5u W=1u
M13013 o7 ibias vss vss sky130_fd_pr__nfet_01v8 L=0.5u W=1u
M13014 o7 ibias vss vss sky130_fd_pr__nfet_01v8 L=0.5u W=1u
M13015 o7 ibias vss vss sky130_fd_pr__nfet_01v8 L=0.5u W=1u
M13016 o7 ibias vss vss sky130_fd_pr__nfet_01v8 L=0.5u W=1u
M13017 o7 ibias vss vss sky130_fd_pr__nfet_01v8 L=0.5u W=1u
M13018 o7 ibias vss vss sky130_fd_pr__nfet_01v8 L=0.5u W=1u
M13019 o7 ibias vss vss sky130_fd_pr__nfet_01v8 L=0.5u W=1u
M13020 o7 ibias vss vss sky130_fd_pr__nfet_01v8 L=0.5u W=1u
M13021 o7 ibias vss vss sky130_fd_pr__nfet_01v8 L=0.5u W=1u
M13022 o7 ibias vss vss sky130_fd_pr__nfet_01v8 L=0.5u W=1u
M13023 o7 ibias vss vss sky130_fd_pr__nfet_01v8 L=0.5u W=1u
M13024 o7 ibias vss vss sky130_fd_pr__nfet_01v8 L=0.5u W=1u
M13025 o7 ibias vss vss sky130_fd_pr__nfet_01v8 L=0.5u W=1u
M13026 o7 ibias vss vss sky130_fd_pr__nfet_01v8 L=0.5u W=1u
M13027 o7 ibias vss vss sky130_fd_pr__nfet_01v8 L=0.5u W=1u
M13028 o7 ibias vss vss sky130_fd_pr__nfet_01v8 L=0.5u W=1u
M13029 o7 ibias vss vss sky130_fd_pr__nfet_01v8 L=0.5u W=1u
M13030 o7 ibias vss vss sky130_fd_pr__nfet_01v8 L=0.5u W=1u
M13031 o7 ibias vss vss sky130_fd_pr__nfet_01v8 L=0.5u W=1u
M13032 o7 ibias vss vss sky130_fd_pr__nfet_01v8 L=0.5u W=1u
M13033 o7 ibias vss vss sky130_fd_pr__nfet_01v8 L=0.5u W=1u
M13034 o7 ibias vss vss sky130_fd_pr__nfet_01v8 L=0.5u W=1u
M13035 o7 ibias vss vss sky130_fd_pr__nfet_01v8 L=0.5u W=1u
M13036 o7 ibias vss vss sky130_fd_pr__nfet_01v8 L=0.5u W=1u
M13037 o7 ibias vss vss sky130_fd_pr__nfet_01v8 L=0.5u W=1u
M13038 o7 ibias vss vss sky130_fd_pr__nfet_01v8 L=0.5u W=1u
M13039 o7 ibias vss vss sky130_fd_pr__nfet_01v8 L=0.5u W=1u
M13040 o7 ibias vss vss sky130_fd_pr__nfet_01v8 L=0.5u W=1u
M13041 o7 ibias vss vss sky130_fd_pr__nfet_01v8 L=0.5u W=1u
M13042 o7 ibias vss vss sky130_fd_pr__nfet_01v8 L=0.5u W=1u
M13043 o7 ibias vss vss sky130_fd_pr__nfet_01v8 L=0.5u W=1u
M13044 o7 ibias vss vss sky130_fd_pr__nfet_01v8 L=0.5u W=1u
M13045 o7 ibias vss vss sky130_fd_pr__nfet_01v8 L=0.5u W=1u
M13046 o7 ibias vss vss sky130_fd_pr__nfet_01v8 L=0.5u W=1u
M13047 o7 ibias vss vss sky130_fd_pr__nfet_01v8 L=0.5u W=1u
M13048 o7 ibias vss vss sky130_fd_pr__nfet_01v8 L=0.5u W=1u
M13049 o7 ibias vss vss sky130_fd_pr__nfet_01v8 L=0.5u W=1u
M13050 o7 ibias vss vss sky130_fd_pr__nfet_01v8 L=0.5u W=1u
M13051 o7 ibias vss vss sky130_fd_pr__nfet_01v8 L=0.5u W=1u
M13052 o7 ibias vss vss sky130_fd_pr__nfet_01v8 L=0.5u W=1u
M13053 o7 ibias vss vss sky130_fd_pr__nfet_01v8 L=0.5u W=1u
M13054 o7 ibias vss vss sky130_fd_pr__nfet_01v8 L=0.5u W=1u
M13055 o7 ibias vss vss sky130_fd_pr__nfet_01v8 L=0.5u W=1u
M13056 o7 ibias vss vss sky130_fd_pr__nfet_01v8 L=0.5u W=1u
M13057 o7 ibias vss vss sky130_fd_pr__nfet_01v8 L=0.5u W=1u
M13058 o7 ibias vss vss sky130_fd_pr__nfet_01v8 L=0.5u W=1u
M13059 o7 ibias vss vss sky130_fd_pr__nfet_01v8 L=0.5u W=1u
M13060 o7 ibias vss vss sky130_fd_pr__nfet_01v8 L=0.5u W=1u
M13061 o7 ibias vss vss sky130_fd_pr__nfet_01v8 L=0.5u W=1u
M13062 o7 ibias vss vss sky130_fd_pr__nfet_01v8 L=0.5u W=1u
M13063 o7 ibias vss vss sky130_fd_pr__nfet_01v8 L=0.5u W=1u
M13064 o7 ibias vss vss sky130_fd_pr__nfet_01v8 L=0.5u W=1u
M13065 o7 ibias vss vss sky130_fd_pr__nfet_01v8 L=0.5u W=1u
M13066 o7 ibias vss vss sky130_fd_pr__nfet_01v8 L=0.5u W=1u
M13067 o7 ibias vss vss sky130_fd_pr__nfet_01v8 L=0.5u W=1u
M13068 o7 ibias vss vss sky130_fd_pr__nfet_01v8 L=0.5u W=1u
M13069 o7 ibias vss vss sky130_fd_pr__nfet_01v8 L=0.5u W=1u
M13070 o7 ibias vss vss sky130_fd_pr__nfet_01v8 L=0.5u W=1u
M13071 o7 ibias vss vss sky130_fd_pr__nfet_01v8 L=0.5u W=1u
M13072 o7 ibias vss vss sky130_fd_pr__nfet_01v8 L=0.5u W=1u
M13073 o7 ibias vss vss sky130_fd_pr__nfet_01v8 L=0.5u W=1u
M13074 o7 ibias vss vss sky130_fd_pr__nfet_01v8 L=0.5u W=1u
M13075 o7 ibias vss vss sky130_fd_pr__nfet_01v8 L=0.5u W=1u
M13076 o7 ibias vss vss sky130_fd_pr__nfet_01v8 L=0.5u W=1u
M13077 o7 ibias vss vss sky130_fd_pr__nfet_01v8 L=0.5u W=1u
M13078 o7 ibias vss vss sky130_fd_pr__nfet_01v8 L=0.5u W=1u
M13079 o7 ibias vss vss sky130_fd_pr__nfet_01v8 L=0.5u W=1u
M13080 o7 ibias vss vss sky130_fd_pr__nfet_01v8 L=0.5u W=1u
M13081 o7 ibias vss vss sky130_fd_pr__nfet_01v8 L=0.5u W=1u
M13082 o7 ibias vss vss sky130_fd_pr__nfet_01v8 L=0.5u W=1u
M13083 o7 ibias vss vss sky130_fd_pr__nfet_01v8 L=0.5u W=1u
M13084 o7 ibias vss vss sky130_fd_pr__nfet_01v8 L=0.5u W=1u
M13085 o7 ibias vss vss sky130_fd_pr__nfet_01v8 L=0.5u W=1u
M13086 o7 ibias vss vss sky130_fd_pr__nfet_01v8 L=0.5u W=1u
M13087 o7 ibias vss vss sky130_fd_pr__nfet_01v8 L=0.5u W=1u
M13088 o7 ibias vss vss sky130_fd_pr__nfet_01v8 L=0.5u W=1u
M13089 o7 ibias vss vss sky130_fd_pr__nfet_01v8 L=0.5u W=1u
M13090 o7 ibias vss vss sky130_fd_pr__nfet_01v8 L=0.5u W=1u
M13091 o7 ibias vss vss sky130_fd_pr__nfet_01v8 L=0.5u W=1u
M13092 o7 ibias vss vss sky130_fd_pr__nfet_01v8 L=0.5u W=1u
M13093 o7 ibias vss vss sky130_fd_pr__nfet_01v8 L=0.5u W=1u
M13094 o7 ibias vss vss sky130_fd_pr__nfet_01v8 L=0.5u W=1u
M13095 o7 ibias vss vss sky130_fd_pr__nfet_01v8 L=0.5u W=1u
M13096 o7 ibias vss vss sky130_fd_pr__nfet_01v8 L=0.5u W=1u
M13097 o7 ibias vss vss sky130_fd_pr__nfet_01v8 L=0.5u W=1u
M13098 o7 ibias vss vss sky130_fd_pr__nfet_01v8 L=0.5u W=1u
M13099 o7 ibias vss vss sky130_fd_pr__nfet_01v8 L=0.5u W=1u
M13100 o7 ibias vss vss sky130_fd_pr__nfet_01v8 L=0.5u W=1u
M13101 o7 ibias vss vss sky130_fd_pr__nfet_01v8 L=0.5u W=1u
M13102 o7 ibias vss vss sky130_fd_pr__nfet_01v8 L=0.5u W=1u
M13103 o7 ibias vss vss sky130_fd_pr__nfet_01v8 L=0.5u W=1u
M13104 o7 ibias vss vss sky130_fd_pr__nfet_01v8 L=0.5u W=1u
M13105 o7 ibias vss vss sky130_fd_pr__nfet_01v8 L=0.5u W=1u
M13106 o7 ibias vss vss sky130_fd_pr__nfet_01v8 L=0.5u W=1u
M13107 o7 ibias vss vss sky130_fd_pr__nfet_01v8 L=0.5u W=1u
M13108 o7 ibias vss vss sky130_fd_pr__nfet_01v8 L=0.5u W=1u
M13109 o7 ibias vss vss sky130_fd_pr__nfet_01v8 L=0.5u W=1u
M13110 o7 ibias vss vss sky130_fd_pr__nfet_01v8 L=0.5u W=1u
M13111 o7 ibias vss vss sky130_fd_pr__nfet_01v8 L=0.5u W=1u
M13112 o7 ibias vss vss sky130_fd_pr__nfet_01v8 L=0.5u W=1u
M13113 o7 ibias vss vss sky130_fd_pr__nfet_01v8 L=0.5u W=1u
M13114 o7 ibias vss vss sky130_fd_pr__nfet_01v8 L=0.5u W=1u
M13115 o7 ibias vss vss sky130_fd_pr__nfet_01v8 L=0.5u W=1u
M13116 o7 ibias vss vss sky130_fd_pr__nfet_01v8 L=0.5u W=1u
M13117 o7 ibias vss vss sky130_fd_pr__nfet_01v8 L=0.5u W=1u
M13118 o7 ibias vss vss sky130_fd_pr__nfet_01v8 L=0.5u W=1u
M13119 o7 ibias vss vss sky130_fd_pr__nfet_01v8 L=0.5u W=1u
M13120 o7 ibias vss vss sky130_fd_pr__nfet_01v8 L=0.5u W=1u
M13121 o7 ibias vss vss sky130_fd_pr__nfet_01v8 L=0.5u W=1u
M13122 o7 ibias vss vss sky130_fd_pr__nfet_01v8 L=0.5u W=1u
M13123 o7 ibias vss vss sky130_fd_pr__nfet_01v8 L=0.5u W=1u
M13124 o7 ibias vss vss sky130_fd_pr__nfet_01v8 L=0.5u W=1u
M13125 o7 ibias vss vss sky130_fd_pr__nfet_01v8 L=0.5u W=1u
M13126 o7 ibias vss vss sky130_fd_pr__nfet_01v8 L=0.5u W=1u
M13127 o7 ibias vss vss sky130_fd_pr__nfet_01v8 L=0.5u W=1u
M13128 o7 ibias vss vss sky130_fd_pr__nfet_01v8 L=0.5u W=1u
M13129 o7 ibias vss vss sky130_fd_pr__nfet_01v8 L=0.5u W=1u
M13130 o7 ibias vss vss sky130_fd_pr__nfet_01v8 L=0.5u W=1u
M13131 o7 ibias vss vss sky130_fd_pr__nfet_01v8 L=0.5u W=1u
M13132 o7 ibias vss vss sky130_fd_pr__nfet_01v8 L=0.5u W=1u
M13133 o7 ibias vss vss sky130_fd_pr__nfet_01v8 L=0.5u W=1u
M13134 o7 ibias vss vss sky130_fd_pr__nfet_01v8 L=0.5u W=1u
M13135 o7 ibias vss vss sky130_fd_pr__nfet_01v8 L=0.5u W=1u
M13136 o7 ibias vss vss sky130_fd_pr__nfet_01v8 L=0.5u W=1u
M13137 o7 ibias vss vss sky130_fd_pr__nfet_01v8 L=0.5u W=1u
M13138 o7 ibias vss vss sky130_fd_pr__nfet_01v8 L=0.5u W=1u
M13139 o7 ibias vss vss sky130_fd_pr__nfet_01v8 L=0.5u W=1u
M13140 o7 ibias vss vss sky130_fd_pr__nfet_01v8 L=0.5u W=1u
M13141 o7 ibias vss vss sky130_fd_pr__nfet_01v8 L=0.5u W=1u
M13142 o7 ibias vss vss sky130_fd_pr__nfet_01v8 L=0.5u W=1u
M13143 o7 ibias vss vss sky130_fd_pr__nfet_01v8 L=0.5u W=1u
M13144 o7 ibias vss vss sky130_fd_pr__nfet_01v8 L=0.5u W=1u
M13145 o7 ibias vss vss sky130_fd_pr__nfet_01v8 L=0.5u W=1u
M13146 o7 ibias vss vss sky130_fd_pr__nfet_01v8 L=0.5u W=1u
M13147 o7 ibias vss vss sky130_fd_pr__nfet_01v8 L=0.5u W=1u
M13148 o7 ibias vss vss sky130_fd_pr__nfet_01v8 L=0.5u W=1u
M13149 o7 ibias vss vss sky130_fd_pr__nfet_01v8 L=0.5u W=1u
M13150 o7 ibias vss vss sky130_fd_pr__nfet_01v8 L=0.5u W=1u
M13151 o7 ibias vss vss sky130_fd_pr__nfet_01v8 L=0.5u W=1u
M13152 o7 ibias vss vss sky130_fd_pr__nfet_01v8 L=0.5u W=1u
M13153 o7 ibias vss vss sky130_fd_pr__nfet_01v8 L=0.5u W=1u
M13154 o7 ibias vss vss sky130_fd_pr__nfet_01v8 L=0.5u W=1u
M13155 o7 ibias vss vss sky130_fd_pr__nfet_01v8 L=0.5u W=1u
M13156 o7 ibias vss vss sky130_fd_pr__nfet_01v8 L=0.5u W=1u
M13157 o7 ibias vss vss sky130_fd_pr__nfet_01v8 L=0.5u W=1u
M13158 o7 ibias vss vss sky130_fd_pr__nfet_01v8 L=0.5u W=1u
M13159 o7 ibias vss vss sky130_fd_pr__nfet_01v8 L=0.5u W=1u
M13160 o7 ibias vss vss sky130_fd_pr__nfet_01v8 L=0.5u W=1u
M13161 o7 ibias vss vss sky130_fd_pr__nfet_01v8 L=0.5u W=1u
M13162 o7 ibias vss vss sky130_fd_pr__nfet_01v8 L=0.5u W=1u
M13163 o7 ibias vss vss sky130_fd_pr__nfet_01v8 L=0.5u W=1u
M13164 o7 ibias vss vss sky130_fd_pr__nfet_01v8 L=0.5u W=1u
M13165 o7 ibias vss vss sky130_fd_pr__nfet_01v8 L=0.5u W=1u
M13166 o7 ibias vss vss sky130_fd_pr__nfet_01v8 L=0.5u W=1u
M13167 o7 ibias vss vss sky130_fd_pr__nfet_01v8 L=0.5u W=1u
M13168 o7 ibias vss vss sky130_fd_pr__nfet_01v8 L=0.5u W=1u
M13169 o7 ibias vss vss sky130_fd_pr__nfet_01v8 L=0.5u W=1u
M13170 o7 ibias vss vss sky130_fd_pr__nfet_01v8 L=0.5u W=1u
M13171 o7 ibias vss vss sky130_fd_pr__nfet_01v8 L=0.5u W=1u
M13172 o7 ibias vss vss sky130_fd_pr__nfet_01v8 L=0.5u W=1u
M13173 o7 ibias vss vss sky130_fd_pr__nfet_01v8 L=0.5u W=1u
M13174 o7 ibias vss vss sky130_fd_pr__nfet_01v8 L=0.5u W=1u
M13175 o7 ibias vss vss sky130_fd_pr__nfet_01v8 L=0.5u W=1u
M13176 o7 ibias vss vss sky130_fd_pr__nfet_01v8 L=0.5u W=1u
M13177 o7 ibias vss vss sky130_fd_pr__nfet_01v8 L=0.5u W=1u
M13178 o7 ibias vss vss sky130_fd_pr__nfet_01v8 L=0.5u W=1u
M13179 o7 ibias vss vss sky130_fd_pr__nfet_01v8 L=0.5u W=1u
M13180 o7 ibias vss vss sky130_fd_pr__nfet_01v8 L=0.5u W=1u
M13181 o7 ibias vss vss sky130_fd_pr__nfet_01v8 L=0.5u W=1u
M13182 o7 ibias vss vss sky130_fd_pr__nfet_01v8 L=0.5u W=1u
M13183 o7 ibias vss vss sky130_fd_pr__nfet_01v8 L=0.5u W=1u
M13184 o7 ibias vss vss sky130_fd_pr__nfet_01v8 L=0.5u W=1u
M13185 o7 ibias vss vss sky130_fd_pr__nfet_01v8 L=0.5u W=1u
M13186 o7 ibias vss vss sky130_fd_pr__nfet_01v8 L=0.5u W=1u
M13187 o7 ibias vss vss sky130_fd_pr__nfet_01v8 L=0.5u W=1u
M13188 o7 ibias vss vss sky130_fd_pr__nfet_01v8 L=0.5u W=1u
M13189 o7 ibias vss vss sky130_fd_pr__nfet_01v8 L=0.5u W=1u
M13190 o7 ibias vss vss sky130_fd_pr__nfet_01v8 L=0.5u W=1u
M13191 o7 ibias vss vss sky130_fd_pr__nfet_01v8 L=0.5u W=1u
M13192 o7 ibias vss vss sky130_fd_pr__nfet_01v8 L=0.5u W=1u
M13193 o7 ibias vss vss sky130_fd_pr__nfet_01v8 L=0.5u W=1u
M13194 o7 ibias vss vss sky130_fd_pr__nfet_01v8 L=0.5u W=1u
M13195 o7 ibias vss vss sky130_fd_pr__nfet_01v8 L=0.5u W=1u
M13196 o7 ibias vss vss sky130_fd_pr__nfet_01v8 L=0.5u W=1u
M13197 o7 ibias vss vss sky130_fd_pr__nfet_01v8 L=0.5u W=1u
M13198 o7 ibias vss vss sky130_fd_pr__nfet_01v8 L=0.5u W=1u
M13199 o7 ibias vss vss sky130_fd_pr__nfet_01v8 L=0.5u W=1u
M13200 o7 ibias vss vss sky130_fd_pr__nfet_01v8 L=0.5u W=1u
M13201 o7 ibias vss vss sky130_fd_pr__nfet_01v8 L=0.5u W=1u
M13202 o7 ibias vss vss sky130_fd_pr__nfet_01v8 L=0.5u W=1u
M13203 o7 ibias vss vss sky130_fd_pr__nfet_01v8 L=0.5u W=1u
M13204 o7 ibias vss vss sky130_fd_pr__nfet_01v8 L=0.5u W=1u
M13205 o7 ibias vss vss sky130_fd_pr__nfet_01v8 L=0.5u W=1u
M13206 o7 ibias vss vss sky130_fd_pr__nfet_01v8 L=0.5u W=1u
M13207 o7 ibias vss vss sky130_fd_pr__nfet_01v8 L=0.5u W=1u
M13208 o7 ibias vss vss sky130_fd_pr__nfet_01v8 L=0.5u W=1u
M13209 o7 ibias vss vss sky130_fd_pr__nfet_01v8 L=0.5u W=1u
M13210 o7 ibias vss vss sky130_fd_pr__nfet_01v8 L=0.5u W=1u
M13211 o7 ibias vss vss sky130_fd_pr__nfet_01v8 L=0.5u W=1u
M13212 o7 ibias vss vss sky130_fd_pr__nfet_01v8 L=0.5u W=1u
M13213 o7 ibias vss vss sky130_fd_pr__nfet_01v8 L=0.5u W=1u
M13214 o7 ibias vss vss sky130_fd_pr__nfet_01v8 L=0.5u W=1u
M13215 o7 ibias vss vss sky130_fd_pr__nfet_01v8 L=0.5u W=1u
M13216 o7 ibias vss vss sky130_fd_pr__nfet_01v8 L=0.5u W=1u
M13217 o7 ibias vss vss sky130_fd_pr__nfet_01v8 L=0.5u W=1u
M13218 o7 ibias vss vss sky130_fd_pr__nfet_01v8 L=0.5u W=1u
M13219 o7 ibias vss vss sky130_fd_pr__nfet_01v8 L=0.5u W=1u
M13220 o7 ibias vss vss sky130_fd_pr__nfet_01v8 L=0.5u W=1u
M13221 o7 ibias vss vss sky130_fd_pr__nfet_01v8 L=0.5u W=1u
M13222 o7 ibias vss vss sky130_fd_pr__nfet_01v8 L=0.5u W=1u
M13223 o7 ibias vss vss sky130_fd_pr__nfet_01v8 L=0.5u W=1u
M13224 o7 ibias vss vss sky130_fd_pr__nfet_01v8 L=0.5u W=1u
M13225 o7 ibias vss vss sky130_fd_pr__nfet_01v8 L=0.5u W=1u
M13226 o7 ibias vss vss sky130_fd_pr__nfet_01v8 L=0.5u W=1u
M13227 o7 ibias vss vss sky130_fd_pr__nfet_01v8 L=0.5u W=1u
M13228 o7 ibias vss vss sky130_fd_pr__nfet_01v8 L=0.5u W=1u
M13229 o7 ibias vss vss sky130_fd_pr__nfet_01v8 L=0.5u W=1u
M13230 o7 ibias vss vss sky130_fd_pr__nfet_01v8 L=0.5u W=1u
M13231 o7 ibias vss vss sky130_fd_pr__nfet_01v8 L=0.5u W=1u
M13232 o7 ibias vss vss sky130_fd_pr__nfet_01v8 L=0.5u W=1u
M13233 o7 ibias vss vss sky130_fd_pr__nfet_01v8 L=0.5u W=1u
M13234 o7 ibias vss vss sky130_fd_pr__nfet_01v8 L=0.5u W=1u
M13235 o7 ibias vss vss sky130_fd_pr__nfet_01v8 L=0.5u W=1u
M13236 o7 ibias vss vss sky130_fd_pr__nfet_01v8 L=0.5u W=1u
M13237 o7 ibias vss vss sky130_fd_pr__nfet_01v8 L=0.5u W=1u
M13238 o7 ibias vss vss sky130_fd_pr__nfet_01v8 L=0.5u W=1u
M13239 o7 ibias vss vss sky130_fd_pr__nfet_01v8 L=0.5u W=1u
M13240 o7 ibias vss vss sky130_fd_pr__nfet_01v8 L=0.5u W=1u
M13241 o7 ibias vss vss sky130_fd_pr__nfet_01v8 L=0.5u W=1u
M13242 o7 ibias vss vss sky130_fd_pr__nfet_01v8 L=0.5u W=1u
M13243 o7 ibias vss vss sky130_fd_pr__nfet_01v8 L=0.5u W=1u
M13244 o7 ibias vss vss sky130_fd_pr__nfet_01v8 L=0.5u W=1u
M13245 o7 ibias vss vss sky130_fd_pr__nfet_01v8 L=0.5u W=1u
M13246 o7 ibias vss vss sky130_fd_pr__nfet_01v8 L=0.5u W=1u
M13247 o7 ibias vss vss sky130_fd_pr__nfet_01v8 L=0.5u W=1u
M13248 o7 ibias vss vss sky130_fd_pr__nfet_01v8 L=0.5u W=1u
M13249 o7 ibias vss vss sky130_fd_pr__nfet_01v8 L=0.5u W=1u
M13250 o7 ibias vss vss sky130_fd_pr__nfet_01v8 L=0.5u W=1u
M13251 o7 ibias vss vss sky130_fd_pr__nfet_01v8 L=0.5u W=1u
M13252 o7 ibias vss vss sky130_fd_pr__nfet_01v8 L=0.5u W=1u
M13253 o7 ibias vss vss sky130_fd_pr__nfet_01v8 L=0.5u W=1u
M13254 o7 ibias vss vss sky130_fd_pr__nfet_01v8 L=0.5u W=1u
M13255 o7 ibias vss vss sky130_fd_pr__nfet_01v8 L=0.5u W=1u
M13256 o7 ibias vss vss sky130_fd_pr__nfet_01v8 L=0.5u W=1u
M13257 o7 ibias vss vss sky130_fd_pr__nfet_01v8 L=0.5u W=1u
M13258 o7 ibias vss vss sky130_fd_pr__nfet_01v8 L=0.5u W=1u
M13259 o7 ibias vss vss sky130_fd_pr__nfet_01v8 L=0.5u W=1u
M13260 o7 ibias vss vss sky130_fd_pr__nfet_01v8 L=0.5u W=1u
M13261 o7 ibias vss vss sky130_fd_pr__nfet_01v8 L=0.5u W=1u
M13262 o7 ibias vss vss sky130_fd_pr__nfet_01v8 L=0.5u W=1u
M13263 o7 ibias vss vss sky130_fd_pr__nfet_01v8 L=0.5u W=1u
M13264 o7 ibias vss vss sky130_fd_pr__nfet_01v8 L=0.5u W=1u
M13265 o7 ibias vss vss sky130_fd_pr__nfet_01v8 L=0.5u W=1u
M13266 o7 ibias vss vss sky130_fd_pr__nfet_01v8 L=0.5u W=1u
M13267 o7 ibias vss vss sky130_fd_pr__nfet_01v8 L=0.5u W=1u
M13268 o7 ibias vss vss sky130_fd_pr__nfet_01v8 L=0.5u W=1u
M13269 o7 ibias vss vss sky130_fd_pr__nfet_01v8 L=0.5u W=1u
M13270 o7 ibias vss vss sky130_fd_pr__nfet_01v8 L=0.5u W=1u
M13271 o7 ibias vss vss sky130_fd_pr__nfet_01v8 L=0.5u W=1u
M13272 o7 ibias vss vss sky130_fd_pr__nfet_01v8 L=0.5u W=1u
M13273 o7 ibias vss vss sky130_fd_pr__nfet_01v8 L=0.5u W=1u
M13274 o7 ibias vss vss sky130_fd_pr__nfet_01v8 L=0.5u W=1u
M13275 o7 ibias vss vss sky130_fd_pr__nfet_01v8 L=0.5u W=1u
M13276 o7 ibias vss vss sky130_fd_pr__nfet_01v8 L=0.5u W=1u
M13277 o7 ibias vss vss sky130_fd_pr__nfet_01v8 L=0.5u W=1u
M13278 o7 ibias vss vss sky130_fd_pr__nfet_01v8 L=0.5u W=1u
M13279 o7 ibias vss vss sky130_fd_pr__nfet_01v8 L=0.5u W=1u
M13280 o7 ibias vss vss sky130_fd_pr__nfet_01v8 L=0.5u W=1u
M13281 o7 ibias vss vss sky130_fd_pr__nfet_01v8 L=0.5u W=1u
M13282 o7 ibias vss vss sky130_fd_pr__nfet_01v8 L=0.5u W=1u
M13283 o7 ibias vss vss sky130_fd_pr__nfet_01v8 L=0.5u W=1u
M13284 o7 ibias vss vss sky130_fd_pr__nfet_01v8 L=0.5u W=1u
M13285 o7 ibias vss vss sky130_fd_pr__nfet_01v8 L=0.5u W=1u
M13286 o7 ibias vss vss sky130_fd_pr__nfet_01v8 L=0.5u W=1u
M13287 o7 ibias vss vss sky130_fd_pr__nfet_01v8 L=0.5u W=1u
M13288 o7 ibias vss vss sky130_fd_pr__nfet_01v8 L=0.5u W=1u
M13289 o7 ibias vss vss sky130_fd_pr__nfet_01v8 L=0.5u W=1u
M13290 o7 ibias vss vss sky130_fd_pr__nfet_01v8 L=0.5u W=1u
M13291 o7 ibias vss vss sky130_fd_pr__nfet_01v8 L=0.5u W=1u
M13292 o7 ibias vss vss sky130_fd_pr__nfet_01v8 L=0.5u W=1u
M13293 o7 ibias vss vss sky130_fd_pr__nfet_01v8 L=0.5u W=1u
M13294 o7 ibias vss vss sky130_fd_pr__nfet_01v8 L=0.5u W=1u
M13295 o7 ibias vss vss sky130_fd_pr__nfet_01v8 L=0.5u W=1u
M13296 o7 ibias vss vss sky130_fd_pr__nfet_01v8 L=0.5u W=1u
M13297 o7 ibias vss vss sky130_fd_pr__nfet_01v8 L=0.5u W=1u
M13298 o7 ibias vss vss sky130_fd_pr__nfet_01v8 L=0.5u W=1u
M13299 o7 ibias vss vss sky130_fd_pr__nfet_01v8 L=0.5u W=1u
M13300 o7 ibias vss vss sky130_fd_pr__nfet_01v8 L=0.5u W=1u
M13301 o7 ibias vss vss sky130_fd_pr__nfet_01v8 L=0.5u W=1u
M13302 o7 ibias vss vss sky130_fd_pr__nfet_01v8 L=0.5u W=1u
M13303 o7 ibias vss vss sky130_fd_pr__nfet_01v8 L=0.5u W=1u
M13304 o7 ibias vss vss sky130_fd_pr__nfet_01v8 L=0.5u W=1u
M13305 o7 ibias vss vss sky130_fd_pr__nfet_01v8 L=0.5u W=1u
M13306 o7 ibias vss vss sky130_fd_pr__nfet_01v8 L=0.5u W=1u
M13307 o7 ibias vss vss sky130_fd_pr__nfet_01v8 L=0.5u W=1u
M13308 o7 ibias vss vss sky130_fd_pr__nfet_01v8 L=0.5u W=1u
M13309 o7 ibias vss vss sky130_fd_pr__nfet_01v8 L=0.5u W=1u
M13310 o7 ibias vss vss sky130_fd_pr__nfet_01v8 L=0.5u W=1u
M13311 o7 ibias vss vss sky130_fd_pr__nfet_01v8 L=0.5u W=1u
M13312 o7 ibias vss vss sky130_fd_pr__nfet_01v8 L=0.5u W=1u
M13313 o7 ibias vss vss sky130_fd_pr__nfet_01v8 L=0.5u W=1u
M13314 o7 ibias vss vss sky130_fd_pr__nfet_01v8 L=0.5u W=1u
M13315 o7 ibias vss vss sky130_fd_pr__nfet_01v8 L=0.5u W=1u
M13316 o7 ibias vss vss sky130_fd_pr__nfet_01v8 L=0.5u W=1u
M13317 o7 ibias vss vss sky130_fd_pr__nfet_01v8 L=0.5u W=1u
M13318 o7 ibias vss vss sky130_fd_pr__nfet_01v8 L=0.5u W=1u
M13319 o7 ibias vss vss sky130_fd_pr__nfet_01v8 L=0.5u W=1u
M13320 o7 ibias vss vss sky130_fd_pr__nfet_01v8 L=0.5u W=1u
M13321 o7 ibias vss vss sky130_fd_pr__nfet_01v8 L=0.5u W=1u
M13322 o7 ibias vss vss sky130_fd_pr__nfet_01v8 L=0.5u W=1u
M13323 o7 ibias vss vss sky130_fd_pr__nfet_01v8 L=0.5u W=1u
M13324 o7 ibias vss vss sky130_fd_pr__nfet_01v8 L=0.5u W=1u
M13325 o7 ibias vss vss sky130_fd_pr__nfet_01v8 L=0.5u W=1u
M13326 o7 ibias vss vss sky130_fd_pr__nfet_01v8 L=0.5u W=1u
M13327 o7 ibias vss vss sky130_fd_pr__nfet_01v8 L=0.5u W=1u
M13328 o7 ibias vss vss sky130_fd_pr__nfet_01v8 L=0.5u W=1u
M13329 o7 ibias vss vss sky130_fd_pr__nfet_01v8 L=0.5u W=1u
M13330 o7 ibias vss vss sky130_fd_pr__nfet_01v8 L=0.5u W=1u
M13331 o7 ibias vss vss sky130_fd_pr__nfet_01v8 L=0.5u W=1u
M13332 o7 ibias vss vss sky130_fd_pr__nfet_01v8 L=0.5u W=1u
M13333 o7 ibias vss vss sky130_fd_pr__nfet_01v8 L=0.5u W=1u
M13334 o7 ibias vss vss sky130_fd_pr__nfet_01v8 L=0.5u W=1u
M13335 o7 ibias vss vss sky130_fd_pr__nfet_01v8 L=0.5u W=1u
M13336 o7 ibias vss vss sky130_fd_pr__nfet_01v8 L=0.5u W=1u
M13337 o7 ibias vss vss sky130_fd_pr__nfet_01v8 L=0.5u W=1u
M13338 o7 ibias vss vss sky130_fd_pr__nfet_01v8 L=0.5u W=1u
M13339 o7 ibias vss vss sky130_fd_pr__nfet_01v8 L=0.5u W=1u
M13340 o7 ibias vss vss sky130_fd_pr__nfet_01v8 L=0.5u W=1u
M13341 o7 ibias vss vss sky130_fd_pr__nfet_01v8 L=0.5u W=1u
M13342 o7 ibias vss vss sky130_fd_pr__nfet_01v8 L=0.5u W=1u
M13343 o7 ibias vss vss sky130_fd_pr__nfet_01v8 L=0.5u W=1u
M13344 o7 ibias vss vss sky130_fd_pr__nfet_01v8 L=0.5u W=1u
M13345 o7 ibias vss vss sky130_fd_pr__nfet_01v8 L=0.5u W=1u
M13346 o7 ibias vss vss sky130_fd_pr__nfet_01v8 L=0.5u W=1u
M13347 o7 ibias vss vss sky130_fd_pr__nfet_01v8 L=0.5u W=1u
M13348 o7 ibias vss vss sky130_fd_pr__nfet_01v8 L=0.5u W=1u
M13349 o7 ibias vss vss sky130_fd_pr__nfet_01v8 L=0.5u W=1u
M13350 o7 ibias vss vss sky130_fd_pr__nfet_01v8 L=0.5u W=1u
M13351 o7 ibias vss vss sky130_fd_pr__nfet_01v8 L=0.5u W=1u
M13352 o7 ibias vss vss sky130_fd_pr__nfet_01v8 L=0.5u W=1u
M13353 o7 ibias vss vss sky130_fd_pr__nfet_01v8 L=0.5u W=1u
M13354 o7 ibias vss vss sky130_fd_pr__nfet_01v8 L=0.5u W=1u
M13355 o7 ibias vss vss sky130_fd_pr__nfet_01v8 L=0.5u W=1u
M13356 o7 ibias vss vss sky130_fd_pr__nfet_01v8 L=0.5u W=1u
M13357 o7 ibias vss vss sky130_fd_pr__nfet_01v8 L=0.5u W=1u
M13358 o7 ibias vss vss sky130_fd_pr__nfet_01v8 L=0.5u W=1u
M13359 o7 ibias vss vss sky130_fd_pr__nfet_01v8 L=0.5u W=1u
M13360 o7 ibias vss vss sky130_fd_pr__nfet_01v8 L=0.5u W=1u
M13361 o7 ibias vss vss sky130_fd_pr__nfet_01v8 L=0.5u W=1u
M13362 o7 ibias vss vss sky130_fd_pr__nfet_01v8 L=0.5u W=1u
M13363 o7 ibias vss vss sky130_fd_pr__nfet_01v8 L=0.5u W=1u
M13364 o7 ibias vss vss sky130_fd_pr__nfet_01v8 L=0.5u W=1u
M13365 o7 ibias vss vss sky130_fd_pr__nfet_01v8 L=0.5u W=1u
M13366 o7 ibias vss vss sky130_fd_pr__nfet_01v8 L=0.5u W=1u
M13367 o7 ibias vss vss sky130_fd_pr__nfet_01v8 L=0.5u W=1u
M13368 o7 ibias vss vss sky130_fd_pr__nfet_01v8 L=0.5u W=1u
M13369 o7 ibias vss vss sky130_fd_pr__nfet_01v8 L=0.5u W=1u
M13370 o7 ibias vss vss sky130_fd_pr__nfet_01v8 L=0.5u W=1u
M13371 o7 ibias vss vss sky130_fd_pr__nfet_01v8 L=0.5u W=1u
M13372 o7 ibias vss vss sky130_fd_pr__nfet_01v8 L=0.5u W=1u
M13373 o7 ibias vss vss sky130_fd_pr__nfet_01v8 L=0.5u W=1u
M13374 o7 ibias vss vss sky130_fd_pr__nfet_01v8 L=0.5u W=1u
M13375 o7 ibias vss vss sky130_fd_pr__nfet_01v8 L=0.5u W=1u
M13376 o7 ibias vss vss sky130_fd_pr__nfet_01v8 L=0.5u W=1u
M13377 o7 ibias vss vss sky130_fd_pr__nfet_01v8 L=0.5u W=1u
M13378 o7 ibias vss vss sky130_fd_pr__nfet_01v8 L=0.5u W=1u
M13379 o7 ibias vss vss sky130_fd_pr__nfet_01v8 L=0.5u W=1u
M13380 o7 ibias vss vss sky130_fd_pr__nfet_01v8 L=0.5u W=1u
M13381 o7 ibias vss vss sky130_fd_pr__nfet_01v8 L=0.5u W=1u
M13382 o7 ibias vss vss sky130_fd_pr__nfet_01v8 L=0.5u W=1u
M13383 o7 ibias vss vss sky130_fd_pr__nfet_01v8 L=0.5u W=1u
M13384 o7 ibias vss vss sky130_fd_pr__nfet_01v8 L=0.5u W=1u
M13385 o7 ibias vss vss sky130_fd_pr__nfet_01v8 L=0.5u W=1u
M13386 o7 ibias vss vss sky130_fd_pr__nfet_01v8 L=0.5u W=1u
M13387 o7 ibias vss vss sky130_fd_pr__nfet_01v8 L=0.5u W=1u
M13388 o7 ibias vss vss sky130_fd_pr__nfet_01v8 L=0.5u W=1u
M13389 o7 ibias vss vss sky130_fd_pr__nfet_01v8 L=0.5u W=1u
M13390 o7 ibias vss vss sky130_fd_pr__nfet_01v8 L=0.5u W=1u
M13391 o7 ibias vss vss sky130_fd_pr__nfet_01v8 L=0.5u W=1u
M13392 o7 ibias vss vss sky130_fd_pr__nfet_01v8 L=0.5u W=1u
M13393 o7 ibias vss vss sky130_fd_pr__nfet_01v8 L=0.5u W=1u
M13394 o7 ibias vss vss sky130_fd_pr__nfet_01v8 L=0.5u W=1u
M13395 o7 ibias vss vss sky130_fd_pr__nfet_01v8 L=0.5u W=1u
M13396 o7 ibias vss vss sky130_fd_pr__nfet_01v8 L=0.5u W=1u
M13397 o7 ibias vss vss sky130_fd_pr__nfet_01v8 L=0.5u W=1u
M13398 o7 ibias vss vss sky130_fd_pr__nfet_01v8 L=0.5u W=1u
M13399 o7 ibias vss vss sky130_fd_pr__nfet_01v8 L=0.5u W=1u
M13400 o7 ibias vss vss sky130_fd_pr__nfet_01v8 L=0.5u W=1u
M13401 o7 ibias vss vss sky130_fd_pr__nfet_01v8 L=0.5u W=1u
M13402 o7 ibias vss vss sky130_fd_pr__nfet_01v8 L=0.5u W=1u
M13403 o7 ibias vss vss sky130_fd_pr__nfet_01v8 L=0.5u W=1u
M13404 o7 ibias vss vss sky130_fd_pr__nfet_01v8 L=0.5u W=1u
M13405 o7 ibias vss vss sky130_fd_pr__nfet_01v8 L=0.5u W=1u
M13406 o7 ibias vss vss sky130_fd_pr__nfet_01v8 L=0.5u W=1u
M13407 o7 ibias vss vss sky130_fd_pr__nfet_01v8 L=0.5u W=1u
M13408 o7 ibias vss vss sky130_fd_pr__nfet_01v8 L=0.5u W=1u
M13409 o7 ibias vss vss sky130_fd_pr__nfet_01v8 L=0.5u W=1u
M13410 o7 ibias vss vss sky130_fd_pr__nfet_01v8 L=0.5u W=1u
M13411 o7 ibias vss vss sky130_fd_pr__nfet_01v8 L=0.5u W=1u
M13412 o7 ibias vss vss sky130_fd_pr__nfet_01v8 L=0.5u W=1u
M13413 o7 ibias vss vss sky130_fd_pr__nfet_01v8 L=0.5u W=1u
M13414 o7 ibias vss vss sky130_fd_pr__nfet_01v8 L=0.5u W=1u
M13415 o7 ibias vss vss sky130_fd_pr__nfet_01v8 L=0.5u W=1u
M13416 o7 ibias vss vss sky130_fd_pr__nfet_01v8 L=0.5u W=1u
M13417 o7 ibias vss vss sky130_fd_pr__nfet_01v8 L=0.5u W=1u
M13418 o7 ibias vss vss sky130_fd_pr__nfet_01v8 L=0.5u W=1u
M13419 o7 ibias vss vss sky130_fd_pr__nfet_01v8 L=0.5u W=1u
M13420 o7 ibias vss vss sky130_fd_pr__nfet_01v8 L=0.5u W=1u
M13421 o7 ibias vss vss sky130_fd_pr__nfet_01v8 L=0.5u W=1u
M13422 o7 ibias vss vss sky130_fd_pr__nfet_01v8 L=0.5u W=1u
M13423 o7 ibias vss vss sky130_fd_pr__nfet_01v8 L=0.5u W=1u
M13424 o7 ibias vss vss sky130_fd_pr__nfet_01v8 L=0.5u W=1u
M13425 o7 ibias vss vss sky130_fd_pr__nfet_01v8 L=0.5u W=1u
M13426 o7 ibias vss vss sky130_fd_pr__nfet_01v8 L=0.5u W=1u
M13427 o7 ibias vss vss sky130_fd_pr__nfet_01v8 L=0.5u W=1u
M13428 o7 ibias vss vss sky130_fd_pr__nfet_01v8 L=0.5u W=1u
M13429 o7 ibias vss vss sky130_fd_pr__nfet_01v8 L=0.5u W=1u
M13430 o7 ibias vss vss sky130_fd_pr__nfet_01v8 L=0.5u W=1u
M13431 o7 ibias vss vss sky130_fd_pr__nfet_01v8 L=0.5u W=1u
M13432 o7 ibias vss vss sky130_fd_pr__nfet_01v8 L=0.5u W=1u
M13433 o7 ibias vss vss sky130_fd_pr__nfet_01v8 L=0.5u W=1u
M13434 o7 ibias vss vss sky130_fd_pr__nfet_01v8 L=0.5u W=1u
M13435 o7 ibias vss vss sky130_fd_pr__nfet_01v8 L=0.5u W=1u
M13436 o7 ibias vss vss sky130_fd_pr__nfet_01v8 L=0.5u W=1u
M13437 o7 ibias vss vss sky130_fd_pr__nfet_01v8 L=0.5u W=1u
M13438 o7 ibias vss vss sky130_fd_pr__nfet_01v8 L=0.5u W=1u
M13439 o7 ibias vss vss sky130_fd_pr__nfet_01v8 L=0.5u W=1u
M13440 o7 ibias vss vss sky130_fd_pr__nfet_01v8 L=0.5u W=1u
M13441 o7 ibias vss vss sky130_fd_pr__nfet_01v8 L=0.5u W=1u
M13442 o7 ibias vss vss sky130_fd_pr__nfet_01v8 L=0.5u W=1u
M13443 o7 ibias vss vss sky130_fd_pr__nfet_01v8 L=0.5u W=1u
M13444 o7 ibias vss vss sky130_fd_pr__nfet_01v8 L=0.5u W=1u
M13445 o7 ibias vss vss sky130_fd_pr__nfet_01v8 L=0.5u W=1u
M13446 o7 ibias vss vss sky130_fd_pr__nfet_01v8 L=0.5u W=1u
M13447 o7 ibias vss vss sky130_fd_pr__nfet_01v8 L=0.5u W=1u
M13448 o7 ibias vss vss sky130_fd_pr__nfet_01v8 L=0.5u W=1u
M13449 o7 ibias vss vss sky130_fd_pr__nfet_01v8 L=0.5u W=1u
M13450 o7 ibias vss vss sky130_fd_pr__nfet_01v8 L=0.5u W=1u
M13451 o7 ibias vss vss sky130_fd_pr__nfet_01v8 L=0.5u W=1u
M13452 o7 ibias vss vss sky130_fd_pr__nfet_01v8 L=0.5u W=1u
M13453 o7 ibias vss vss sky130_fd_pr__nfet_01v8 L=0.5u W=1u
M13454 o7 ibias vss vss sky130_fd_pr__nfet_01v8 L=0.5u W=1u
M13455 o7 ibias vss vss sky130_fd_pr__nfet_01v8 L=0.5u W=1u
M13456 o7 ibias vss vss sky130_fd_pr__nfet_01v8 L=0.5u W=1u
M13457 o7 ibias vss vss sky130_fd_pr__nfet_01v8 L=0.5u W=1u
M13458 o7 ibias vss vss sky130_fd_pr__nfet_01v8 L=0.5u W=1u
M13459 o7 ibias vss vss sky130_fd_pr__nfet_01v8 L=0.5u W=1u
M13460 o7 ibias vss vss sky130_fd_pr__nfet_01v8 L=0.5u W=1u
M13461 o7 ibias vss vss sky130_fd_pr__nfet_01v8 L=0.5u W=1u
M13462 o7 ibias vss vss sky130_fd_pr__nfet_01v8 L=0.5u W=1u
M13463 o7 ibias vss vss sky130_fd_pr__nfet_01v8 L=0.5u W=1u
M13464 o7 ibias vss vss sky130_fd_pr__nfet_01v8 L=0.5u W=1u
M13465 o7 ibias vss vss sky130_fd_pr__nfet_01v8 L=0.5u W=1u
M13466 o7 ibias vss vss sky130_fd_pr__nfet_01v8 L=0.5u W=1u
M13467 o7 ibias vss vss sky130_fd_pr__nfet_01v8 L=0.5u W=1u
M13468 o7 ibias vss vss sky130_fd_pr__nfet_01v8 L=0.5u W=1u
M13469 o7 ibias vss vss sky130_fd_pr__nfet_01v8 L=0.5u W=1u
M13470 o7 ibias vss vss sky130_fd_pr__nfet_01v8 L=0.5u W=1u
M13471 o7 ibias vss vss sky130_fd_pr__nfet_01v8 L=0.5u W=1u
M13472 o7 ibias vss vss sky130_fd_pr__nfet_01v8 L=0.5u W=1u
M13473 o7 ibias vss vss sky130_fd_pr__nfet_01v8 L=0.5u W=1u
M13474 o7 ibias vss vss sky130_fd_pr__nfet_01v8 L=0.5u W=1u
M13475 o7 ibias vss vss sky130_fd_pr__nfet_01v8 L=0.5u W=1u
M13476 o7 ibias vss vss sky130_fd_pr__nfet_01v8 L=0.5u W=1u
M13477 o7 ibias vss vss sky130_fd_pr__nfet_01v8 L=0.5u W=1u
M13478 o7 ibias vss vss sky130_fd_pr__nfet_01v8 L=0.5u W=1u
M13479 o7 ibias vss vss sky130_fd_pr__nfet_01v8 L=0.5u W=1u
M13480 o7 ibias vss vss sky130_fd_pr__nfet_01v8 L=0.5u W=1u
M13481 o7 ibias vss vss sky130_fd_pr__nfet_01v8 L=0.5u W=1u
M13482 o7 ibias vss vss sky130_fd_pr__nfet_01v8 L=0.5u W=1u
M13483 o7 ibias vss vss sky130_fd_pr__nfet_01v8 L=0.5u W=1u
M13484 o7 ibias vss vss sky130_fd_pr__nfet_01v8 L=0.5u W=1u
M13485 o7 ibias vss vss sky130_fd_pr__nfet_01v8 L=0.5u W=1u
M13486 o7 ibias vss vss sky130_fd_pr__nfet_01v8 L=0.5u W=1u
M13487 o7 ibias vss vss sky130_fd_pr__nfet_01v8 L=0.5u W=1u
M13488 o7 ibias vss vss sky130_fd_pr__nfet_01v8 L=0.5u W=1u
M13489 o7 ibias vss vss sky130_fd_pr__nfet_01v8 L=0.5u W=1u
M13490 o7 ibias vss vss sky130_fd_pr__nfet_01v8 L=0.5u W=1u
M13491 o7 ibias vss vss sky130_fd_pr__nfet_01v8 L=0.5u W=1u
M13492 o7 ibias vss vss sky130_fd_pr__nfet_01v8 L=0.5u W=1u
M13493 o7 ibias vss vss sky130_fd_pr__nfet_01v8 L=0.5u W=1u
M13494 o7 ibias vss vss sky130_fd_pr__nfet_01v8 L=0.5u W=1u
M13495 o7 ibias vss vss sky130_fd_pr__nfet_01v8 L=0.5u W=1u
M13496 o7 ibias vss vss sky130_fd_pr__nfet_01v8 L=0.5u W=1u
M13497 o7 ibias vss vss sky130_fd_pr__nfet_01v8 L=0.5u W=1u
M13498 o7 ibias vss vss sky130_fd_pr__nfet_01v8 L=0.5u W=1u
M13499 o7 ibias vss vss sky130_fd_pr__nfet_01v8 L=0.5u W=1u
M13500 o7 ibias vss vss sky130_fd_pr__nfet_01v8 L=0.5u W=1u
M13501 o7 ibias vss vss sky130_fd_pr__nfet_01v8 L=0.5u W=1u
M13502 o7 ibias vss vss sky130_fd_pr__nfet_01v8 L=0.5u W=1u
M13503 o7 ibias vss vss sky130_fd_pr__nfet_01v8 L=0.5u W=1u
M13504 o7 ibias vss vss sky130_fd_pr__nfet_01v8 L=0.5u W=1u
M13505 o7 ibias vss vss sky130_fd_pr__nfet_01v8 L=0.5u W=1u
M13506 o7 ibias vss vss sky130_fd_pr__nfet_01v8 L=0.5u W=1u
M13507 o7 ibias vss vss sky130_fd_pr__nfet_01v8 L=0.5u W=1u
M13508 o7 ibias vss vss sky130_fd_pr__nfet_01v8 L=0.5u W=1u
M13509 o7 ibias vss vss sky130_fd_pr__nfet_01v8 L=0.5u W=1u
M13510 o7 ibias vss vss sky130_fd_pr__nfet_01v8 L=0.5u W=1u
M13511 o7 ibias vss vss sky130_fd_pr__nfet_01v8 L=0.5u W=1u
M13512 o7 ibias vss vss sky130_fd_pr__nfet_01v8 L=0.5u W=1u
M13513 o7 ibias vss vss sky130_fd_pr__nfet_01v8 L=0.5u W=1u
M13514 o7 ibias vss vss sky130_fd_pr__nfet_01v8 L=0.5u W=1u
M13515 o7 ibias vss vss sky130_fd_pr__nfet_01v8 L=0.5u W=1u
M13516 o7 ibias vss vss sky130_fd_pr__nfet_01v8 L=0.5u W=1u
M13517 o7 ibias vss vss sky130_fd_pr__nfet_01v8 L=0.5u W=1u
M13518 o7 ibias vss vss sky130_fd_pr__nfet_01v8 L=0.5u W=1u
M13519 o7 ibias vss vss sky130_fd_pr__nfet_01v8 L=0.5u W=1u
M13520 o7 ibias vss vss sky130_fd_pr__nfet_01v8 L=0.5u W=1u
M13521 o7 ibias vss vss sky130_fd_pr__nfet_01v8 L=0.5u W=1u
M13522 o7 ibias vss vss sky130_fd_pr__nfet_01v8 L=0.5u W=1u
M13523 o7 ibias vss vss sky130_fd_pr__nfet_01v8 L=0.5u W=1u
M13524 o7 ibias vss vss sky130_fd_pr__nfet_01v8 L=0.5u W=1u
M13525 o7 ibias vss vss sky130_fd_pr__nfet_01v8 L=0.5u W=1u
M13526 o7 ibias vss vss sky130_fd_pr__nfet_01v8 L=0.5u W=1u
M13527 o7 ibias vss vss sky130_fd_pr__nfet_01v8 L=0.5u W=1u
M13528 o7 ibias vss vss sky130_fd_pr__nfet_01v8 L=0.5u W=1u
M13529 o7 ibias vss vss sky130_fd_pr__nfet_01v8 L=0.5u W=1u
M13530 o7 ibias vss vss sky130_fd_pr__nfet_01v8 L=0.5u W=1u
M13531 o7 ibias vss vss sky130_fd_pr__nfet_01v8 L=0.5u W=1u
M13532 o7 ibias vss vss sky130_fd_pr__nfet_01v8 L=0.5u W=1u
M13533 o7 ibias vss vss sky130_fd_pr__nfet_01v8 L=0.5u W=1u
M13534 o7 ibias vss vss sky130_fd_pr__nfet_01v8 L=0.5u W=1u
M13535 o7 ibias vss vss sky130_fd_pr__nfet_01v8 L=0.5u W=1u
M13536 o7 ibias vss vss sky130_fd_pr__nfet_01v8 L=0.5u W=1u
M13537 o7 ibias vss vss sky130_fd_pr__nfet_01v8 L=0.5u W=1u
M13538 o7 ibias vss vss sky130_fd_pr__nfet_01v8 L=0.5u W=1u
M13539 o7 ibias vss vss sky130_fd_pr__nfet_01v8 L=0.5u W=1u
M13540 o7 ibias vss vss sky130_fd_pr__nfet_01v8 L=0.5u W=1u
M13541 o7 ibias vss vss sky130_fd_pr__nfet_01v8 L=0.5u W=1u
M13542 o7 ibias vss vss sky130_fd_pr__nfet_01v8 L=0.5u W=1u
M13543 o7 ibias vss vss sky130_fd_pr__nfet_01v8 L=0.5u W=1u
M13544 o7 ibias vss vss sky130_fd_pr__nfet_01v8 L=0.5u W=1u
M13545 o7 ibias vss vss sky130_fd_pr__nfet_01v8 L=0.5u W=1u
M13546 o7 ibias vss vss sky130_fd_pr__nfet_01v8 L=0.5u W=1u
M13547 o7 ibias vss vss sky130_fd_pr__nfet_01v8 L=0.5u W=1u
M13548 o7 ibias vss vss sky130_fd_pr__nfet_01v8 L=0.5u W=1u
M13549 o7 ibias vss vss sky130_fd_pr__nfet_01v8 L=0.5u W=1u
M13550 o7 ibias vss vss sky130_fd_pr__nfet_01v8 L=0.5u W=1u
M13551 o7 ibias vss vss sky130_fd_pr__nfet_01v8 L=0.5u W=1u
M13552 o7 ibias vss vss sky130_fd_pr__nfet_01v8 L=0.5u W=1u
M13553 o7 ibias vss vss sky130_fd_pr__nfet_01v8 L=0.5u W=1u
M13554 o7 ibias vss vss sky130_fd_pr__nfet_01v8 L=0.5u W=1u
M13555 o7 ibias vss vss sky130_fd_pr__nfet_01v8 L=0.5u W=1u
M13556 o7 ibias vss vss sky130_fd_pr__nfet_01v8 L=0.5u W=1u
M13557 o7 ibias vss vss sky130_fd_pr__nfet_01v8 L=0.5u W=1u
M13558 o7 ibias vss vss sky130_fd_pr__nfet_01v8 L=0.5u W=1u
M13559 o7 ibias vss vss sky130_fd_pr__nfet_01v8 L=0.5u W=1u
M13560 o7 ibias vss vss sky130_fd_pr__nfet_01v8 L=0.5u W=1u
M13561 o7 ibias vss vss sky130_fd_pr__nfet_01v8 L=0.5u W=1u
M13562 o7 ibias vss vss sky130_fd_pr__nfet_01v8 L=0.5u W=1u
M13563 o7 ibias vss vss sky130_fd_pr__nfet_01v8 L=0.5u W=1u
M13564 o7 ibias vss vss sky130_fd_pr__nfet_01v8 L=0.5u W=1u
M13565 o7 ibias vss vss sky130_fd_pr__nfet_01v8 L=0.5u W=1u
M13566 o7 ibias vss vss sky130_fd_pr__nfet_01v8 L=0.5u W=1u
M13567 o7 ibias vss vss sky130_fd_pr__nfet_01v8 L=0.5u W=1u
M13568 o7 ibias vss vss sky130_fd_pr__nfet_01v8 L=0.5u W=1u
M13569 o7 ibias vss vss sky130_fd_pr__nfet_01v8 L=0.5u W=1u
M13570 o7 ibias vss vss sky130_fd_pr__nfet_01v8 L=0.5u W=1u
M13571 o7 ibias vss vss sky130_fd_pr__nfet_01v8 L=0.5u W=1u
M13572 o7 ibias vss vss sky130_fd_pr__nfet_01v8 L=0.5u W=1u
M13573 o7 ibias vss vss sky130_fd_pr__nfet_01v8 L=0.5u W=1u
M13574 o7 ibias vss vss sky130_fd_pr__nfet_01v8 L=0.5u W=1u
M13575 o7 ibias vss vss sky130_fd_pr__nfet_01v8 L=0.5u W=1u
M13576 o7 ibias vss vss sky130_fd_pr__nfet_01v8 L=0.5u W=1u
M13577 o7 ibias vss vss sky130_fd_pr__nfet_01v8 L=0.5u W=1u
M13578 o7 ibias vss vss sky130_fd_pr__nfet_01v8 L=0.5u W=1u
M13579 o7 ibias vss vss sky130_fd_pr__nfet_01v8 L=0.5u W=1u
M13580 o7 ibias vss vss sky130_fd_pr__nfet_01v8 L=0.5u W=1u
M13581 o7 ibias vss vss sky130_fd_pr__nfet_01v8 L=0.5u W=1u
M13582 o7 ibias vss vss sky130_fd_pr__nfet_01v8 L=0.5u W=1u
M13583 o7 ibias vss vss sky130_fd_pr__nfet_01v8 L=0.5u W=1u
M13584 o7 ibias vss vss sky130_fd_pr__nfet_01v8 L=0.5u W=1u
M13585 o7 ibias vss vss sky130_fd_pr__nfet_01v8 L=0.5u W=1u
M13586 o7 ibias vss vss sky130_fd_pr__nfet_01v8 L=0.5u W=1u
M13587 o7 ibias vss vss sky130_fd_pr__nfet_01v8 L=0.5u W=1u
M13588 o7 ibias vss vss sky130_fd_pr__nfet_01v8 L=0.5u W=1u
M13589 o7 ibias vss vss sky130_fd_pr__nfet_01v8 L=0.5u W=1u
M13590 o7 ibias vss vss sky130_fd_pr__nfet_01v8 L=0.5u W=1u
M13591 o7 ibias vss vss sky130_fd_pr__nfet_01v8 L=0.5u W=1u
M13592 o7 ibias vss vss sky130_fd_pr__nfet_01v8 L=0.5u W=1u
M13593 o7 ibias vss vss sky130_fd_pr__nfet_01v8 L=0.5u W=1u
M13594 o7 ibias vss vss sky130_fd_pr__nfet_01v8 L=0.5u W=1u
M13595 o7 ibias vss vss sky130_fd_pr__nfet_01v8 L=0.5u W=1u
M13596 o7 ibias vss vss sky130_fd_pr__nfet_01v8 L=0.5u W=1u
M13597 o7 ibias vss vss sky130_fd_pr__nfet_01v8 L=0.5u W=1u
M13598 o7 ibias vss vss sky130_fd_pr__nfet_01v8 L=0.5u W=1u
M13599 o7 ibias vss vss sky130_fd_pr__nfet_01v8 L=0.5u W=1u
M13600 o7 ibias vss vss sky130_fd_pr__nfet_01v8 L=0.5u W=1u
M13601 o7 ibias vss vss sky130_fd_pr__nfet_01v8 L=0.5u W=1u
M13602 o7 ibias vss vss sky130_fd_pr__nfet_01v8 L=0.5u W=1u
M13603 o7 ibias vss vss sky130_fd_pr__nfet_01v8 L=0.5u W=1u
M13604 o7 ibias vss vss sky130_fd_pr__nfet_01v8 L=0.5u W=1u
M13605 o7 ibias vss vss sky130_fd_pr__nfet_01v8 L=0.5u W=1u
M13606 o7 ibias vss vss sky130_fd_pr__nfet_01v8 L=0.5u W=1u
M13607 o7 ibias vss vss sky130_fd_pr__nfet_01v8 L=0.5u W=1u
M13608 o7 ibias vss vss sky130_fd_pr__nfet_01v8 L=0.5u W=1u
M13609 o7 ibias vss vss sky130_fd_pr__nfet_01v8 L=0.5u W=1u
M13610 o7 ibias vss vss sky130_fd_pr__nfet_01v8 L=0.5u W=1u
M13611 o7 ibias vss vss sky130_fd_pr__nfet_01v8 L=0.5u W=1u
M13612 o7 ibias vss vss sky130_fd_pr__nfet_01v8 L=0.5u W=1u
M13613 o7 ibias vss vss sky130_fd_pr__nfet_01v8 L=0.5u W=1u
M13614 o7 ibias vss vss sky130_fd_pr__nfet_01v8 L=0.5u W=1u
M13615 o7 ibias vss vss sky130_fd_pr__nfet_01v8 L=0.5u W=1u
M13616 o7 ibias vss vss sky130_fd_pr__nfet_01v8 L=0.5u W=1u
M13617 o7 ibias vss vss sky130_fd_pr__nfet_01v8 L=0.5u W=1u
M13618 o7 ibias vss vss sky130_fd_pr__nfet_01v8 L=0.5u W=1u
M13619 o7 ibias vss vss sky130_fd_pr__nfet_01v8 L=0.5u W=1u
M13620 o7 ibias vss vss sky130_fd_pr__nfet_01v8 L=0.5u W=1u
M13621 o7 ibias vss vss sky130_fd_pr__nfet_01v8 L=0.5u W=1u
M13622 o7 ibias vss vss sky130_fd_pr__nfet_01v8 L=0.5u W=1u
M13623 o7 ibias vss vss sky130_fd_pr__nfet_01v8 L=0.5u W=1u
M13624 o7 ibias vss vss sky130_fd_pr__nfet_01v8 L=0.5u W=1u
M13625 o7 ibias vss vss sky130_fd_pr__nfet_01v8 L=0.5u W=1u
M13626 o7 ibias vss vss sky130_fd_pr__nfet_01v8 L=0.5u W=1u
M13627 o7 ibias vss vss sky130_fd_pr__nfet_01v8 L=0.5u W=1u
M13628 o7 ibias vss vss sky130_fd_pr__nfet_01v8 L=0.5u W=1u
M13629 o7 ibias vss vss sky130_fd_pr__nfet_01v8 L=0.5u W=1u
M13630 o7 ibias vss vss sky130_fd_pr__nfet_01v8 L=0.5u W=1u
M13631 o7 ibias vss vss sky130_fd_pr__nfet_01v8 L=0.5u W=1u
M13632 o7 ibias vss vss sky130_fd_pr__nfet_01v8 L=0.5u W=1u
M13633 o7 ibias vss vss sky130_fd_pr__nfet_01v8 L=0.5u W=1u
M13634 o7 ibias vss vss sky130_fd_pr__nfet_01v8 L=0.5u W=1u
M13635 o7 ibias vss vss sky130_fd_pr__nfet_01v8 L=0.5u W=1u
M13636 o7 ibias vss vss sky130_fd_pr__nfet_01v8 L=0.5u W=1u
M13637 o7 ibias vss vss sky130_fd_pr__nfet_01v8 L=0.5u W=1u
M13638 o7 ibias vss vss sky130_fd_pr__nfet_01v8 L=0.5u W=1u
M13639 o7 ibias vss vss sky130_fd_pr__nfet_01v8 L=0.5u W=1u
M13640 o7 ibias vss vss sky130_fd_pr__nfet_01v8 L=0.5u W=1u
M13641 o7 ibias vss vss sky130_fd_pr__nfet_01v8 L=0.5u W=1u
M13642 o7 ibias vss vss sky130_fd_pr__nfet_01v8 L=0.5u W=1u
M13643 o7 ibias vss vss sky130_fd_pr__nfet_01v8 L=0.5u W=1u
M13644 o7 ibias vss vss sky130_fd_pr__nfet_01v8 L=0.5u W=1u
M13645 o7 ibias vss vss sky130_fd_pr__nfet_01v8 L=0.5u W=1u
M13646 o7 ibias vss vss sky130_fd_pr__nfet_01v8 L=0.5u W=1u
M13647 o7 ibias vss vss sky130_fd_pr__nfet_01v8 L=0.5u W=1u
M13648 o7 ibias vss vss sky130_fd_pr__nfet_01v8 L=0.5u W=1u
M13649 o7 ibias vss vss sky130_fd_pr__nfet_01v8 L=0.5u W=1u
M13650 o7 ibias vss vss sky130_fd_pr__nfet_01v8 L=0.5u W=1u
M13651 o7 ibias vss vss sky130_fd_pr__nfet_01v8 L=0.5u W=1u
M13652 o7 ibias vss vss sky130_fd_pr__nfet_01v8 L=0.5u W=1u
M13653 o7 ibias vss vss sky130_fd_pr__nfet_01v8 L=0.5u W=1u
M13654 o7 ibias vss vss sky130_fd_pr__nfet_01v8 L=0.5u W=1u
M13655 o7 ibias vss vss sky130_fd_pr__nfet_01v8 L=0.5u W=1u
M13656 o7 ibias vss vss sky130_fd_pr__nfet_01v8 L=0.5u W=1u
M13657 o7 ibias vss vss sky130_fd_pr__nfet_01v8 L=0.5u W=1u
M13658 o7 ibias vss vss sky130_fd_pr__nfet_01v8 L=0.5u W=1u
M13659 o7 ibias vss vss sky130_fd_pr__nfet_01v8 L=0.5u W=1u
M13660 o7 ibias vss vss sky130_fd_pr__nfet_01v8 L=0.5u W=1u
M13661 o7 ibias vss vss sky130_fd_pr__nfet_01v8 L=0.5u W=1u
M13662 o7 ibias vss vss sky130_fd_pr__nfet_01v8 L=0.5u W=1u
M13663 o7 ibias vss vss sky130_fd_pr__nfet_01v8 L=0.5u W=1u
M13664 o7 ibias vss vss sky130_fd_pr__nfet_01v8 L=0.5u W=1u
M13665 o7 ibias vss vss sky130_fd_pr__nfet_01v8 L=0.5u W=1u
M13666 o7 ibias vss vss sky130_fd_pr__nfet_01v8 L=0.5u W=1u
M13667 o7 ibias vss vss sky130_fd_pr__nfet_01v8 L=0.5u W=1u
M13668 o7 ibias vss vss sky130_fd_pr__nfet_01v8 L=0.5u W=1u
M13669 o7 ibias vss vss sky130_fd_pr__nfet_01v8 L=0.5u W=1u
M13670 o7 ibias vss vss sky130_fd_pr__nfet_01v8 L=0.5u W=1u
M13671 o7 ibias vss vss sky130_fd_pr__nfet_01v8 L=0.5u W=1u
M13672 o7 ibias vss vss sky130_fd_pr__nfet_01v8 L=0.5u W=1u
M13673 o7 ibias vss vss sky130_fd_pr__nfet_01v8 L=0.5u W=1u
M13674 o7 ibias vss vss sky130_fd_pr__nfet_01v8 L=0.5u W=1u
M13675 o7 ibias vss vss sky130_fd_pr__nfet_01v8 L=0.5u W=1u
M13676 o7 ibias vss vss sky130_fd_pr__nfet_01v8 L=0.5u W=1u
M13677 o7 ibias vss vss sky130_fd_pr__nfet_01v8 L=0.5u W=1u
M13678 o7 ibias vss vss sky130_fd_pr__nfet_01v8 L=0.5u W=1u
M13679 o7 ibias vss vss sky130_fd_pr__nfet_01v8 L=0.5u W=1u
M13680 o7 ibias vss vss sky130_fd_pr__nfet_01v8 L=0.5u W=1u
M13681 o7 ibias vss vss sky130_fd_pr__nfet_01v8 L=0.5u W=1u
M13682 o7 ibias vss vss sky130_fd_pr__nfet_01v8 L=0.5u W=1u
M13683 o7 ibias vss vss sky130_fd_pr__nfet_01v8 L=0.5u W=1u
M13684 o7 ibias vss vss sky130_fd_pr__nfet_01v8 L=0.5u W=1u
M13685 o7 ibias vss vss sky130_fd_pr__nfet_01v8 L=0.5u W=1u
M13686 o7 ibias vss vss sky130_fd_pr__nfet_01v8 L=0.5u W=1u
M13687 o7 ibias vss vss sky130_fd_pr__nfet_01v8 L=0.5u W=1u
M13688 o7 ibias vss vss sky130_fd_pr__nfet_01v8 L=0.5u W=1u
M13689 o7 ibias vss vss sky130_fd_pr__nfet_01v8 L=0.5u W=1u
M13690 o7 ibias vss vss sky130_fd_pr__nfet_01v8 L=0.5u W=1u
M13691 o7 ibias vss vss sky130_fd_pr__nfet_01v8 L=0.5u W=1u
M13692 o7 ibias vss vss sky130_fd_pr__nfet_01v8 L=0.5u W=1u
M13693 o7 ibias vss vss sky130_fd_pr__nfet_01v8 L=0.5u W=1u
M13694 o7 ibias vss vss sky130_fd_pr__nfet_01v8 L=0.5u W=1u
M13695 o7 ibias vss vss sky130_fd_pr__nfet_01v8 L=0.5u W=1u
M13696 o7 ibias vss vss sky130_fd_pr__nfet_01v8 L=0.5u W=1u
M13697 o7 ibias vss vss sky130_fd_pr__nfet_01v8 L=0.5u W=1u
M13698 o7 ibias vss vss sky130_fd_pr__nfet_01v8 L=0.5u W=1u
M13699 o7 ibias vss vss sky130_fd_pr__nfet_01v8 L=0.5u W=1u
M13700 o7 ibias vss vss sky130_fd_pr__nfet_01v8 L=0.5u W=1u
M13701 o7 ibias vss vss sky130_fd_pr__nfet_01v8 L=0.5u W=1u
M13702 o7 ibias vss vss sky130_fd_pr__nfet_01v8 L=0.5u W=1u
M13703 o7 ibias vss vss sky130_fd_pr__nfet_01v8 L=0.5u W=1u
M13704 o7 ibias vss vss sky130_fd_pr__nfet_01v8 L=0.5u W=1u
M13705 o7 ibias vss vss sky130_fd_pr__nfet_01v8 L=0.5u W=1u
M13706 o7 ibias vss vss sky130_fd_pr__nfet_01v8 L=0.5u W=1u
M13707 o7 ibias vss vss sky130_fd_pr__nfet_01v8 L=0.5u W=1u
M13708 o7 ibias vss vss sky130_fd_pr__nfet_01v8 L=0.5u W=1u
M13709 o7 ibias vss vss sky130_fd_pr__nfet_01v8 L=0.5u W=1u
M13710 o7 ibias vss vss sky130_fd_pr__nfet_01v8 L=0.5u W=1u
M13711 o7 ibias vss vss sky130_fd_pr__nfet_01v8 L=0.5u W=1u
M13712 o7 ibias vss vss sky130_fd_pr__nfet_01v8 L=0.5u W=1u
M13713 o7 ibias vss vss sky130_fd_pr__nfet_01v8 L=0.5u W=1u
M13714 o7 ibias vss vss sky130_fd_pr__nfet_01v8 L=0.5u W=1u
M13715 o7 ibias vss vss sky130_fd_pr__nfet_01v8 L=0.5u W=1u
M13716 o7 ibias vss vss sky130_fd_pr__nfet_01v8 L=0.5u W=1u
M13717 o7 ibias vss vss sky130_fd_pr__nfet_01v8 L=0.5u W=1u
M13718 o7 ibias vss vss sky130_fd_pr__nfet_01v8 L=0.5u W=1u
M13719 o7 ibias vss vss sky130_fd_pr__nfet_01v8 L=0.5u W=1u
M13720 o7 ibias vss vss sky130_fd_pr__nfet_01v8 L=0.5u W=1u
M13721 o7 ibias vss vss sky130_fd_pr__nfet_01v8 L=0.5u W=1u
M13722 o7 ibias vss vss sky130_fd_pr__nfet_01v8 L=0.5u W=1u
M13723 o7 ibias vss vss sky130_fd_pr__nfet_01v8 L=0.5u W=1u
M13724 o7 ibias vss vss sky130_fd_pr__nfet_01v8 L=0.5u W=1u
M13725 o7 ibias vss vss sky130_fd_pr__nfet_01v8 L=0.5u W=1u
M13726 o7 ibias vss vss sky130_fd_pr__nfet_01v8 L=0.5u W=1u
M13727 o7 ibias vss vss sky130_fd_pr__nfet_01v8 L=0.5u W=1u
M13728 o7 ibias vss vss sky130_fd_pr__nfet_01v8 L=0.5u W=1u
M13729 o7 ibias vss vss sky130_fd_pr__nfet_01v8 L=0.5u W=1u
M13730 o7 ibias vss vss sky130_fd_pr__nfet_01v8 L=0.5u W=1u
M13731 o7 ibias vss vss sky130_fd_pr__nfet_01v8 L=0.5u W=1u
M13732 o7 ibias vss vss sky130_fd_pr__nfet_01v8 L=0.5u W=1u
M13733 o7 ibias vss vss sky130_fd_pr__nfet_01v8 L=0.5u W=1u
M13734 o7 ibias vss vss sky130_fd_pr__nfet_01v8 L=0.5u W=1u
M13735 o7 ibias vss vss sky130_fd_pr__nfet_01v8 L=0.5u W=1u
M13736 o7 ibias vss vss sky130_fd_pr__nfet_01v8 L=0.5u W=1u
M13737 o7 ibias vss vss sky130_fd_pr__nfet_01v8 L=0.5u W=1u
M13738 o7 ibias vss vss sky130_fd_pr__nfet_01v8 L=0.5u W=1u
M13739 o7 ibias vss vss sky130_fd_pr__nfet_01v8 L=0.5u W=1u
M13740 o7 ibias vss vss sky130_fd_pr__nfet_01v8 L=0.5u W=1u
M13741 o7 ibias vss vss sky130_fd_pr__nfet_01v8 L=0.5u W=1u
M13742 o7 ibias vss vss sky130_fd_pr__nfet_01v8 L=0.5u W=1u
M13743 o7 ibias vss vss sky130_fd_pr__nfet_01v8 L=0.5u W=1u
M13744 o7 ibias vss vss sky130_fd_pr__nfet_01v8 L=0.5u W=1u
M13745 o7 ibias vss vss sky130_fd_pr__nfet_01v8 L=0.5u W=1u
M13746 o7 ibias vss vss sky130_fd_pr__nfet_01v8 L=0.5u W=1u
M13747 o7 ibias vss vss sky130_fd_pr__nfet_01v8 L=0.5u W=1u
M13748 o7 ibias vss vss sky130_fd_pr__nfet_01v8 L=0.5u W=1u
M13749 o7 ibias vss vss sky130_fd_pr__nfet_01v8 L=0.5u W=1u
M13750 o7 ibias vss vss sky130_fd_pr__nfet_01v8 L=0.5u W=1u
M13751 o7 ibias vss vss sky130_fd_pr__nfet_01v8 L=0.5u W=1u
M13752 o7 ibias vss vss sky130_fd_pr__nfet_01v8 L=0.5u W=1u
M13753 o7 ibias vss vss sky130_fd_pr__nfet_01v8 L=0.5u W=1u
M13754 o7 ibias vss vss sky130_fd_pr__nfet_01v8 L=0.5u W=1u
M13755 o7 ibias vss vss sky130_fd_pr__nfet_01v8 L=0.5u W=1u
M13756 o7 ibias vss vss sky130_fd_pr__nfet_01v8 L=0.5u W=1u
M13757 o7 ibias vss vss sky130_fd_pr__nfet_01v8 L=0.5u W=1u
M13758 o7 ibias vss vss sky130_fd_pr__nfet_01v8 L=0.5u W=1u
M13759 o7 ibias vss vss sky130_fd_pr__nfet_01v8 L=0.5u W=1u
M13760 o7 ibias vss vss sky130_fd_pr__nfet_01v8 L=0.5u W=1u
M13761 o7 ibias vss vss sky130_fd_pr__nfet_01v8 L=0.5u W=1u
M13762 o7 ibias vss vss sky130_fd_pr__nfet_01v8 L=0.5u W=1u
M13763 o7 ibias vss vss sky130_fd_pr__nfet_01v8 L=0.5u W=1u
M13764 o7 ibias vss vss sky130_fd_pr__nfet_01v8 L=0.5u W=1u
M13765 o7 ibias vss vss sky130_fd_pr__nfet_01v8 L=0.5u W=1u
M13766 o7 ibias vss vss sky130_fd_pr__nfet_01v8 L=0.5u W=1u
M13767 o7 ibias vss vss sky130_fd_pr__nfet_01v8 L=0.5u W=1u
M13768 o7 ibias vss vss sky130_fd_pr__nfet_01v8 L=0.5u W=1u
M13769 o7 ibias vss vss sky130_fd_pr__nfet_01v8 L=0.5u W=1u
M13770 o7 ibias vss vss sky130_fd_pr__nfet_01v8 L=0.5u W=1u
M13771 o7 ibias vss vss sky130_fd_pr__nfet_01v8 L=0.5u W=1u
M13772 o7 ibias vss vss sky130_fd_pr__nfet_01v8 L=0.5u W=1u
M13773 o7 ibias vss vss sky130_fd_pr__nfet_01v8 L=0.5u W=1u
M13774 o7 ibias vss vss sky130_fd_pr__nfet_01v8 L=0.5u W=1u
M13775 o7 ibias vss vss sky130_fd_pr__nfet_01v8 L=0.5u W=1u
M13776 o7 ibias vss vss sky130_fd_pr__nfet_01v8 L=0.5u W=1u
M13777 o7 ibias vss vss sky130_fd_pr__nfet_01v8 L=0.5u W=1u
M13778 o7 ibias vss vss sky130_fd_pr__nfet_01v8 L=0.5u W=1u
M13779 o7 ibias vss vss sky130_fd_pr__nfet_01v8 L=0.5u W=1u
M13780 o7 ibias vss vss sky130_fd_pr__nfet_01v8 L=0.5u W=1u
M13781 o7 ibias vss vss sky130_fd_pr__nfet_01v8 L=0.5u W=1u
M13782 o7 ibias vss vss sky130_fd_pr__nfet_01v8 L=0.5u W=1u
M13783 o7 ibias vss vss sky130_fd_pr__nfet_01v8 L=0.5u W=1u
M13784 o7 ibias vss vss sky130_fd_pr__nfet_01v8 L=0.5u W=1u
M13785 o7 ibias vss vss sky130_fd_pr__nfet_01v8 L=0.5u W=1u
M13786 o7 ibias vss vss sky130_fd_pr__nfet_01v8 L=0.5u W=1u
M13787 o7 ibias vss vss sky130_fd_pr__nfet_01v8 L=0.5u W=1u
M13788 o7 ibias vss vss sky130_fd_pr__nfet_01v8 L=0.5u W=1u
M13789 o7 ibias vss vss sky130_fd_pr__nfet_01v8 L=0.5u W=1u
M13790 o7 ibias vss vss sky130_fd_pr__nfet_01v8 L=0.5u W=1u
M13791 o7 ibias vss vss sky130_fd_pr__nfet_01v8 L=0.5u W=1u
M13792 o7 ibias vss vss sky130_fd_pr__nfet_01v8 L=0.5u W=1u
M13793 o7 ibias vss vss sky130_fd_pr__nfet_01v8 L=0.5u W=1u
M13794 o7 ibias vss vss sky130_fd_pr__nfet_01v8 L=0.5u W=1u
M13795 o7 ibias vss vss sky130_fd_pr__nfet_01v8 L=0.5u W=1u
M13796 o7 ibias vss vss sky130_fd_pr__nfet_01v8 L=0.5u W=1u
M13797 o7 ibias vss vss sky130_fd_pr__nfet_01v8 L=0.5u W=1u
M13798 o7 ibias vss vss sky130_fd_pr__nfet_01v8 L=0.5u W=1u
M13799 o7 ibias vss vss sky130_fd_pr__nfet_01v8 L=0.5u W=1u
M13800 o7 ibias vss vss sky130_fd_pr__nfet_01v8 L=0.5u W=1u
M13801 o7 ibias vss vss sky130_fd_pr__nfet_01v8 L=0.5u W=1u
M13802 o7 ibias vss vss sky130_fd_pr__nfet_01v8 L=0.5u W=1u
M13803 o7 ibias vss vss sky130_fd_pr__nfet_01v8 L=0.5u W=1u
M13804 o7 ibias vss vss sky130_fd_pr__nfet_01v8 L=0.5u W=1u
M13805 o7 ibias vss vss sky130_fd_pr__nfet_01v8 L=0.5u W=1u
M13806 o7 ibias vss vss sky130_fd_pr__nfet_01v8 L=0.5u W=1u
M13807 o7 ibias vss vss sky130_fd_pr__nfet_01v8 L=0.5u W=1u
M13808 o7 ibias vss vss sky130_fd_pr__nfet_01v8 L=0.5u W=1u
M13809 o7 ibias vss vss sky130_fd_pr__nfet_01v8 L=0.5u W=1u
M13810 o7 ibias vss vss sky130_fd_pr__nfet_01v8 L=0.5u W=1u
M13811 o7 ibias vss vss sky130_fd_pr__nfet_01v8 L=0.5u W=1u
M13812 o7 ibias vss vss sky130_fd_pr__nfet_01v8 L=0.5u W=1u
M13813 o7 ibias vss vss sky130_fd_pr__nfet_01v8 L=0.5u W=1u
M13814 o7 ibias vss vss sky130_fd_pr__nfet_01v8 L=0.5u W=1u
M13815 o7 ibias vss vss sky130_fd_pr__nfet_01v8 L=0.5u W=1u
M13816 o7 ibias vss vss sky130_fd_pr__nfet_01v8 L=0.5u W=1u
M13817 o7 ibias vss vss sky130_fd_pr__nfet_01v8 L=0.5u W=1u
M13818 o7 ibias vss vss sky130_fd_pr__nfet_01v8 L=0.5u W=1u
M13819 o7 ibias vss vss sky130_fd_pr__nfet_01v8 L=0.5u W=1u
M13820 o7 ibias vss vss sky130_fd_pr__nfet_01v8 L=0.5u W=1u
M13821 o7 ibias vss vss sky130_fd_pr__nfet_01v8 L=0.5u W=1u
M13822 o7 ibias vss vss sky130_fd_pr__nfet_01v8 L=0.5u W=1u
M13823 o7 ibias vss vss sky130_fd_pr__nfet_01v8 L=0.5u W=1u
M13824 o7 ibias vss vss sky130_fd_pr__nfet_01v8 L=0.5u W=1u
M13825 o7 ibias vss vss sky130_fd_pr__nfet_01v8 L=0.5u W=1u
M13826 o7 ibias vss vss sky130_fd_pr__nfet_01v8 L=0.5u W=1u
M13827 o7 ibias vss vss sky130_fd_pr__nfet_01v8 L=0.5u W=1u
M13828 o7 ibias vss vss sky130_fd_pr__nfet_01v8 L=0.5u W=1u
M13829 o7 ibias vss vss sky130_fd_pr__nfet_01v8 L=0.5u W=1u
M13830 o7 ibias vss vss sky130_fd_pr__nfet_01v8 L=0.5u W=1u
M13831 o7 ibias vss vss sky130_fd_pr__nfet_01v8 L=0.5u W=1u
M13832 o7 ibias vss vss sky130_fd_pr__nfet_01v8 L=0.5u W=1u
M13833 o7 ibias vss vss sky130_fd_pr__nfet_01v8 L=0.5u W=1u
M13834 o7 ibias vss vss sky130_fd_pr__nfet_01v8 L=0.5u W=1u
M13835 o7 ibias vss vss sky130_fd_pr__nfet_01v8 L=0.5u W=1u
M13836 o7 ibias vss vss sky130_fd_pr__nfet_01v8 L=0.5u W=1u
M13837 o7 ibias vss vss sky130_fd_pr__nfet_01v8 L=0.5u W=1u
M13838 o7 ibias vss vss sky130_fd_pr__nfet_01v8 L=0.5u W=1u
M13839 o7 ibias vss vss sky130_fd_pr__nfet_01v8 L=0.5u W=1u
M13840 o7 ibias vss vss sky130_fd_pr__nfet_01v8 L=0.5u W=1u
M13841 o7 ibias vss vss sky130_fd_pr__nfet_01v8 L=0.5u W=1u
M13842 o7 ibias vss vss sky130_fd_pr__nfet_01v8 L=0.5u W=1u
M13843 o7 ibias vss vss sky130_fd_pr__nfet_01v8 L=0.5u W=1u
M13844 o7 ibias vss vss sky130_fd_pr__nfet_01v8 L=0.5u W=1u
M13845 o7 ibias vss vss sky130_fd_pr__nfet_01v8 L=0.5u W=1u
M13846 o7 ibias vss vss sky130_fd_pr__nfet_01v8 L=0.5u W=1u
M13847 o7 ibias vss vss sky130_fd_pr__nfet_01v8 L=0.5u W=1u
M13848 o7 ibias vss vss sky130_fd_pr__nfet_01v8 L=0.5u W=1u
M13849 o7 ibias vss vss sky130_fd_pr__nfet_01v8 L=0.5u W=1u
M13850 o7 ibias vss vss sky130_fd_pr__nfet_01v8 L=0.5u W=1u
M13851 o7 ibias vss vss sky130_fd_pr__nfet_01v8 L=0.5u W=1u
M13852 o7 ibias vss vss sky130_fd_pr__nfet_01v8 L=0.5u W=1u
M13853 o7 ibias vss vss sky130_fd_pr__nfet_01v8 L=0.5u W=1u
M13854 o7 ibias vss vss sky130_fd_pr__nfet_01v8 L=0.5u W=1u
M13855 o7 ibias vss vss sky130_fd_pr__nfet_01v8 L=0.5u W=1u
M13856 o7 ibias vss vss sky130_fd_pr__nfet_01v8 L=0.5u W=1u
M13857 o7 ibias vss vss sky130_fd_pr__nfet_01v8 L=0.5u W=1u
M13858 o7 ibias vss vss sky130_fd_pr__nfet_01v8 L=0.5u W=1u
M13859 o7 ibias vss vss sky130_fd_pr__nfet_01v8 L=0.5u W=1u
M13860 o7 ibias vss vss sky130_fd_pr__nfet_01v8 L=0.5u W=1u
M13861 o7 ibias vss vss sky130_fd_pr__nfet_01v8 L=0.5u W=1u
M13862 o7 ibias vss vss sky130_fd_pr__nfet_01v8 L=0.5u W=1u
M13863 o7 ibias vss vss sky130_fd_pr__nfet_01v8 L=0.5u W=1u
M13864 o7 ibias vss vss sky130_fd_pr__nfet_01v8 L=0.5u W=1u
M13865 o7 ibias vss vss sky130_fd_pr__nfet_01v8 L=0.5u W=1u
M13866 o7 ibias vss vss sky130_fd_pr__nfet_01v8 L=0.5u W=1u
M13867 o7 ibias vss vss sky130_fd_pr__nfet_01v8 L=0.5u W=1u
M13868 o7 ibias vss vss sky130_fd_pr__nfet_01v8 L=0.5u W=1u
M13869 o7 ibias vss vss sky130_fd_pr__nfet_01v8 L=0.5u W=1u
M13870 o7 ibias vss vss sky130_fd_pr__nfet_01v8 L=0.5u W=1u
M13871 o7 ibias vss vss sky130_fd_pr__nfet_01v8 L=0.5u W=1u
M13872 o7 ibias vss vss sky130_fd_pr__nfet_01v8 L=0.5u W=1u
M13873 o7 ibias vss vss sky130_fd_pr__nfet_01v8 L=0.5u W=1u
M13874 o7 ibias vss vss sky130_fd_pr__nfet_01v8 L=0.5u W=1u
M13875 o7 ibias vss vss sky130_fd_pr__nfet_01v8 L=0.5u W=1u
M13876 o7 ibias vss vss sky130_fd_pr__nfet_01v8 L=0.5u W=1u
M13877 o7 ibias vss vss sky130_fd_pr__nfet_01v8 L=0.5u W=1u
M13878 o7 ibias vss vss sky130_fd_pr__nfet_01v8 L=0.5u W=1u
M13879 o7 ibias vss vss sky130_fd_pr__nfet_01v8 L=0.5u W=1u
M13880 o7 ibias vss vss sky130_fd_pr__nfet_01v8 L=0.5u W=1u
M13881 o7 ibias vss vss sky130_fd_pr__nfet_01v8 L=0.5u W=1u
M13882 o7 ibias vss vss sky130_fd_pr__nfet_01v8 L=0.5u W=1u
M13883 o7 ibias vss vss sky130_fd_pr__nfet_01v8 L=0.5u W=1u
M13884 o7 ibias vss vss sky130_fd_pr__nfet_01v8 L=0.5u W=1u
M13885 o7 ibias vss vss sky130_fd_pr__nfet_01v8 L=0.5u W=1u
M13886 o7 ibias vss vss sky130_fd_pr__nfet_01v8 L=0.5u W=1u
M13887 o7 ibias vss vss sky130_fd_pr__nfet_01v8 L=0.5u W=1u
M13888 o7 ibias vss vss sky130_fd_pr__nfet_01v8 L=0.5u W=1u
M13889 o7 ibias vss vss sky130_fd_pr__nfet_01v8 L=0.5u W=1u
M13890 o7 ibias vss vss sky130_fd_pr__nfet_01v8 L=0.5u W=1u
M13891 o7 ibias vss vss sky130_fd_pr__nfet_01v8 L=0.5u W=1u
M13892 o7 ibias vss vss sky130_fd_pr__nfet_01v8 L=0.5u W=1u
M13893 o7 ibias vss vss sky130_fd_pr__nfet_01v8 L=0.5u W=1u
M13894 o7 ibias vss vss sky130_fd_pr__nfet_01v8 L=0.5u W=1u
M13895 o7 ibias vss vss sky130_fd_pr__nfet_01v8 L=0.5u W=1u
M13896 o7 ibias vss vss sky130_fd_pr__nfet_01v8 L=0.5u W=1u
M13897 o7 ibias vss vss sky130_fd_pr__nfet_01v8 L=0.5u W=1u
M13898 o7 ibias vss vss sky130_fd_pr__nfet_01v8 L=0.5u W=1u
M13899 o7 ibias vss vss sky130_fd_pr__nfet_01v8 L=0.5u W=1u
M13900 o7 ibias vss vss sky130_fd_pr__nfet_01v8 L=0.5u W=1u
M13901 o7 ibias vss vss sky130_fd_pr__nfet_01v8 L=0.5u W=1u
M13902 o7 ibias vss vss sky130_fd_pr__nfet_01v8 L=0.5u W=1u
M13903 o7 ibias vss vss sky130_fd_pr__nfet_01v8 L=0.5u W=1u
M13904 o7 ibias vss vss sky130_fd_pr__nfet_01v8 L=0.5u W=1u
M13905 o7 ibias vss vss sky130_fd_pr__nfet_01v8 L=0.5u W=1u
M13906 o7 ibias vss vss sky130_fd_pr__nfet_01v8 L=0.5u W=1u
M13907 o7 ibias vss vss sky130_fd_pr__nfet_01v8 L=0.5u W=1u
M13908 o7 ibias vss vss sky130_fd_pr__nfet_01v8 L=0.5u W=1u
M13909 o7 ibias vss vss sky130_fd_pr__nfet_01v8 L=0.5u W=1u
M13910 o7 ibias vss vss sky130_fd_pr__nfet_01v8 L=0.5u W=1u
M13911 o7 ibias vss vss sky130_fd_pr__nfet_01v8 L=0.5u W=1u
M13912 o7 ibias vss vss sky130_fd_pr__nfet_01v8 L=0.5u W=1u
M13913 o7 ibias vss vss sky130_fd_pr__nfet_01v8 L=0.5u W=1u
M13914 o7 ibias vss vss sky130_fd_pr__nfet_01v8 L=0.5u W=1u
M13915 o7 ibias vss vss sky130_fd_pr__nfet_01v8 L=0.5u W=1u
M13916 o7 ibias vss vss sky130_fd_pr__nfet_01v8 L=0.5u W=1u
M13917 o7 ibias vss vss sky130_fd_pr__nfet_01v8 L=0.5u W=1u
M13918 o7 ibias vss vss sky130_fd_pr__nfet_01v8 L=0.5u W=1u
M13919 o7 ibias vss vss sky130_fd_pr__nfet_01v8 L=0.5u W=1u
M13920 o7 ibias vss vss sky130_fd_pr__nfet_01v8 L=0.5u W=1u
M13921 o7 ibias vss vss sky130_fd_pr__nfet_01v8 L=0.5u W=1u
M13922 o7 ibias vss vss sky130_fd_pr__nfet_01v8 L=0.5u W=1u
M13923 o7 ibias vss vss sky130_fd_pr__nfet_01v8 L=0.5u W=1u
M13924 o7 ibias vss vss sky130_fd_pr__nfet_01v8 L=0.5u W=1u
M13925 o7 ibias vss vss sky130_fd_pr__nfet_01v8 L=0.5u W=1u
M13926 o7 ibias vss vss sky130_fd_pr__nfet_01v8 L=0.5u W=1u
M13927 o7 ibias vss vss sky130_fd_pr__nfet_01v8 L=0.5u W=1u
M13928 o7 ibias vss vss sky130_fd_pr__nfet_01v8 L=0.5u W=1u
M13929 o7 ibias vss vss sky130_fd_pr__nfet_01v8 L=0.5u W=1u
M13930 o7 ibias vss vss sky130_fd_pr__nfet_01v8 L=0.5u W=1u
M13931 o7 ibias vss vss sky130_fd_pr__nfet_01v8 L=0.5u W=1u
M13932 o7 ibias vss vss sky130_fd_pr__nfet_01v8 L=0.5u W=1u
M13933 o7 ibias vss vss sky130_fd_pr__nfet_01v8 L=0.5u W=1u
M13934 o7 ibias vss vss sky130_fd_pr__nfet_01v8 L=0.5u W=1u
M13935 o7 ibias vss vss sky130_fd_pr__nfet_01v8 L=0.5u W=1u
M13936 o7 ibias vss vss sky130_fd_pr__nfet_01v8 L=0.5u W=1u
M13937 o7 ibias vss vss sky130_fd_pr__nfet_01v8 L=0.5u W=1u
M13938 o7 ibias vss vss sky130_fd_pr__nfet_01v8 L=0.5u W=1u
M13939 o7 ibias vss vss sky130_fd_pr__nfet_01v8 L=0.5u W=1u
M13940 o7 ibias vss vss sky130_fd_pr__nfet_01v8 L=0.5u W=1u
M13941 o7 ibias vss vss sky130_fd_pr__nfet_01v8 L=0.5u W=1u
M13942 o7 ibias vss vss sky130_fd_pr__nfet_01v8 L=0.5u W=1u
M13943 o7 ibias vss vss sky130_fd_pr__nfet_01v8 L=0.5u W=1u
M13944 o7 ibias vss vss sky130_fd_pr__nfet_01v8 L=0.5u W=1u
M13945 o7 ibias vss vss sky130_fd_pr__nfet_01v8 L=0.5u W=1u
M13946 o7 ibias vss vss sky130_fd_pr__nfet_01v8 L=0.5u W=1u
M13947 o7 ibias vss vss sky130_fd_pr__nfet_01v8 L=0.5u W=1u
M13948 o7 ibias vss vss sky130_fd_pr__nfet_01v8 L=0.5u W=1u
M13949 o7 ibias vss vss sky130_fd_pr__nfet_01v8 L=0.5u W=1u
M13950 o7 ibias vss vss sky130_fd_pr__nfet_01v8 L=0.5u W=1u
M13951 o7 ibias vss vss sky130_fd_pr__nfet_01v8 L=0.5u W=1u
M13952 o7 ibias vss vss sky130_fd_pr__nfet_01v8 L=0.5u W=1u
M13953 o7 ibias vss vss sky130_fd_pr__nfet_01v8 L=0.5u W=1u
M13954 o7 ibias vss vss sky130_fd_pr__nfet_01v8 L=0.5u W=1u
M13955 o7 ibias vss vss sky130_fd_pr__nfet_01v8 L=0.5u W=1u
M13956 o7 ibias vss vss sky130_fd_pr__nfet_01v8 L=0.5u W=1u
M13957 o7 ibias vss vss sky130_fd_pr__nfet_01v8 L=0.5u W=1u
M13958 o7 ibias vss vss sky130_fd_pr__nfet_01v8 L=0.5u W=1u
M13959 o7 ibias vss vss sky130_fd_pr__nfet_01v8 L=0.5u W=1u
M13960 o7 ibias vss vss sky130_fd_pr__nfet_01v8 L=0.5u W=1u
M13961 o7 ibias vss vss sky130_fd_pr__nfet_01v8 L=0.5u W=1u
M13962 o7 ibias vss vss sky130_fd_pr__nfet_01v8 L=0.5u W=1u
M13963 o7 ibias vss vss sky130_fd_pr__nfet_01v8 L=0.5u W=1u
M13964 o7 ibias vss vss sky130_fd_pr__nfet_01v8 L=0.5u W=1u
M13965 o7 ibias vss vss sky130_fd_pr__nfet_01v8 L=0.5u W=1u
M13966 o7 ibias vss vss sky130_fd_pr__nfet_01v8 L=0.5u W=1u
M13967 o7 ibias vss vss sky130_fd_pr__nfet_01v8 L=0.5u W=1u
M13968 o7 ibias vss vss sky130_fd_pr__nfet_01v8 L=0.5u W=1u
M13969 o7 ibias vss vss sky130_fd_pr__nfet_01v8 L=0.5u W=1u
M13970 o7 ibias vss vss sky130_fd_pr__nfet_01v8 L=0.5u W=1u
M13971 o7 ibias vss vss sky130_fd_pr__nfet_01v8 L=0.5u W=1u
M13972 o7 ibias vss vss sky130_fd_pr__nfet_01v8 L=0.5u W=1u
M13973 o7 ibias vss vss sky130_fd_pr__nfet_01v8 L=0.5u W=1u
M13974 o7 ibias vss vss sky130_fd_pr__nfet_01v8 L=0.5u W=1u
M13975 o7 ibias vss vss sky130_fd_pr__nfet_01v8 L=0.5u W=1u
M13976 o7 ibias vss vss sky130_fd_pr__nfet_01v8 L=0.5u W=1u
M13977 o7 ibias vss vss sky130_fd_pr__nfet_01v8 L=0.5u W=1u
M13978 o7 ibias vss vss sky130_fd_pr__nfet_01v8 L=0.5u W=1u
M13979 o7 ibias vss vss sky130_fd_pr__nfet_01v8 L=0.5u W=1u
M13980 o7 ibias vss vss sky130_fd_pr__nfet_01v8 L=0.5u W=1u
M13981 o7 ibias vss vss sky130_fd_pr__nfet_01v8 L=0.5u W=1u
M13982 o7 ibias vss vss sky130_fd_pr__nfet_01v8 L=0.5u W=1u
M13983 o7 ibias vss vss sky130_fd_pr__nfet_01v8 L=0.5u W=1u
M13984 o7 ibias vss vss sky130_fd_pr__nfet_01v8 L=0.5u W=1u
M13985 o7 ibias vss vss sky130_fd_pr__nfet_01v8 L=0.5u W=1u
M13986 o7 ibias vss vss sky130_fd_pr__nfet_01v8 L=0.5u W=1u
M13987 o7 ibias vss vss sky130_fd_pr__nfet_01v8 L=0.5u W=1u
M13988 o7 ibias vss vss sky130_fd_pr__nfet_01v8 L=0.5u W=1u
M13989 o7 ibias vss vss sky130_fd_pr__nfet_01v8 L=0.5u W=1u
M13990 o7 ibias vss vss sky130_fd_pr__nfet_01v8 L=0.5u W=1u
M13991 o7 ibias vss vss sky130_fd_pr__nfet_01v8 L=0.5u W=1u
M13992 o7 ibias vss vss sky130_fd_pr__nfet_01v8 L=0.5u W=1u
M13993 o7 ibias vss vss sky130_fd_pr__nfet_01v8 L=0.5u W=1u
M13994 o7 ibias vss vss sky130_fd_pr__nfet_01v8 L=0.5u W=1u
M13995 o7 ibias vss vss sky130_fd_pr__nfet_01v8 L=0.5u W=1u
M13996 o7 ibias vss vss sky130_fd_pr__nfet_01v8 L=0.5u W=1u
M13997 o7 ibias vss vss sky130_fd_pr__nfet_01v8 L=0.5u W=1u
M13998 o7 ibias vss vss sky130_fd_pr__nfet_01v8 L=0.5u W=1u
M13999 o7 ibias vss vss sky130_fd_pr__nfet_01v8 L=0.5u W=1u
M14000 o7 ibias vss vss sky130_fd_pr__nfet_01v8 L=0.5u W=1u
M14001 o7 ibias vss vss sky130_fd_pr__nfet_01v8 L=0.5u W=1u
M14002 o7 ibias vss vss sky130_fd_pr__nfet_01v8 L=0.5u W=1u
M14003 o7 ibias vss vss sky130_fd_pr__nfet_01v8 L=0.5u W=1u
M14004 o7 ibias vss vss sky130_fd_pr__nfet_01v8 L=0.5u W=1u
M14005 o7 ibias vss vss sky130_fd_pr__nfet_01v8 L=0.5u W=1u
M14006 o7 ibias vss vss sky130_fd_pr__nfet_01v8 L=0.5u W=1u
M14007 o7 ibias vss vss sky130_fd_pr__nfet_01v8 L=0.5u W=1u
M14008 o7 ibias vss vss sky130_fd_pr__nfet_01v8 L=0.5u W=1u
M14009 o7 ibias vss vss sky130_fd_pr__nfet_01v8 L=0.5u W=1u
M14010 o7 ibias vss vss sky130_fd_pr__nfet_01v8 L=0.5u W=1u
M14011 o7 ibias vss vss sky130_fd_pr__nfet_01v8 L=0.5u W=1u
M14012 o7 ibias vss vss sky130_fd_pr__nfet_01v8 L=0.5u W=1u
M14013 o7 ibias vss vss sky130_fd_pr__nfet_01v8 L=0.5u W=1u
M14014 o7 ibias vss vss sky130_fd_pr__nfet_01v8 L=0.5u W=1u
M14015 o7 ibias vss vss sky130_fd_pr__nfet_01v8 L=0.5u W=1u
M14016 o7 ibias vss vss sky130_fd_pr__nfet_01v8 L=0.5u W=1u
M14017 o7 ibias vss vss sky130_fd_pr__nfet_01v8 L=0.5u W=1u
M14018 o7 ibias vss vss sky130_fd_pr__nfet_01v8 L=0.5u W=1u
M14019 o7 ibias vss vss sky130_fd_pr__nfet_01v8 L=0.5u W=1u
M14020 o7 ibias vss vss sky130_fd_pr__nfet_01v8 L=0.5u W=1u
M14021 o7 ibias vss vss sky130_fd_pr__nfet_01v8 L=0.5u W=1u
M14022 o7 ibias vss vss sky130_fd_pr__nfet_01v8 L=0.5u W=1u
M14023 o7 ibias vss vss sky130_fd_pr__nfet_01v8 L=0.5u W=1u
M14024 o7 ibias vss vss sky130_fd_pr__nfet_01v8 L=0.5u W=1u
M14025 o7 ibias vss vss sky130_fd_pr__nfet_01v8 L=0.5u W=1u
M14026 o7 ibias vss vss sky130_fd_pr__nfet_01v8 L=0.5u W=1u
M14027 o7 ibias vss vss sky130_fd_pr__nfet_01v8 L=0.5u W=1u
M14028 o7 ibias vss vss sky130_fd_pr__nfet_01v8 L=0.5u W=1u
M14029 o7 ibias vss vss sky130_fd_pr__nfet_01v8 L=0.5u W=1u
M14030 o7 ibias vss vss sky130_fd_pr__nfet_01v8 L=0.5u W=1u
M14031 o7 ibias vss vss sky130_fd_pr__nfet_01v8 L=0.5u W=1u
M14032 o7 ibias vss vss sky130_fd_pr__nfet_01v8 L=0.5u W=1u
M14033 o7 ibias vss vss sky130_fd_pr__nfet_01v8 L=0.5u W=1u
M14034 o7 ibias vss vss sky130_fd_pr__nfet_01v8 L=0.5u W=1u
M14035 o7 ibias vss vss sky130_fd_pr__nfet_01v8 L=0.5u W=1u
M14036 o7 ibias vss vss sky130_fd_pr__nfet_01v8 L=0.5u W=1u
M14037 o7 ibias vss vss sky130_fd_pr__nfet_01v8 L=0.5u W=1u
M14038 o7 ibias vss vss sky130_fd_pr__nfet_01v8 L=0.5u W=1u
M14039 o7 ibias vss vss sky130_fd_pr__nfet_01v8 L=0.5u W=1u
M14040 o7 ibias vss vss sky130_fd_pr__nfet_01v8 L=0.5u W=1u
M14041 o7 ibias vss vss sky130_fd_pr__nfet_01v8 L=0.5u W=1u
M14042 o7 ibias vss vss sky130_fd_pr__nfet_01v8 L=0.5u W=1u
M14043 o7 ibias vss vss sky130_fd_pr__nfet_01v8 L=0.5u W=1u
M14044 o7 ibias vss vss sky130_fd_pr__nfet_01v8 L=0.5u W=1u
M14045 o7 ibias vss vss sky130_fd_pr__nfet_01v8 L=0.5u W=1u
M14046 o7 ibias vss vss sky130_fd_pr__nfet_01v8 L=0.5u W=1u
M14047 o7 ibias vss vss sky130_fd_pr__nfet_01v8 L=0.5u W=1u
M14048 o7 ibias vss vss sky130_fd_pr__nfet_01v8 L=0.5u W=1u
M14049 o7 ibias vss vss sky130_fd_pr__nfet_01v8 L=0.5u W=1u
M14050 o7 ibias vss vss sky130_fd_pr__nfet_01v8 L=0.5u W=1u
M14051 o7 ibias vss vss sky130_fd_pr__nfet_01v8 L=0.5u W=1u
M14052 o7 ibias vss vss sky130_fd_pr__nfet_01v8 L=0.5u W=1u
M14053 o7 ibias vss vss sky130_fd_pr__nfet_01v8 L=0.5u W=1u
M14054 o7 ibias vss vss sky130_fd_pr__nfet_01v8 L=0.5u W=1u
M14055 o7 ibias vss vss sky130_fd_pr__nfet_01v8 L=0.5u W=1u
M14056 o7 ibias vss vss sky130_fd_pr__nfet_01v8 L=0.5u W=1u
M14057 o7 ibias vss vss sky130_fd_pr__nfet_01v8 L=0.5u W=1u
M14058 o7 ibias vss vss sky130_fd_pr__nfet_01v8 L=0.5u W=1u
M14059 o7 ibias vss vss sky130_fd_pr__nfet_01v8 L=0.5u W=1u
M14060 o7 ibias vss vss sky130_fd_pr__nfet_01v8 L=0.5u W=1u
M14061 o7 ibias vss vss sky130_fd_pr__nfet_01v8 L=0.5u W=1u
M14062 o7 ibias vss vss sky130_fd_pr__nfet_01v8 L=0.5u W=1u
M14063 o7 ibias vss vss sky130_fd_pr__nfet_01v8 L=0.5u W=1u
M14064 o7 ibias vss vss sky130_fd_pr__nfet_01v8 L=0.5u W=1u
M14065 o7 ibias vss vss sky130_fd_pr__nfet_01v8 L=0.5u W=1u
M14066 o7 ibias vss vss sky130_fd_pr__nfet_01v8 L=0.5u W=1u
M14067 o7 ibias vss vss sky130_fd_pr__nfet_01v8 L=0.5u W=1u
M14068 o7 ibias vss vss sky130_fd_pr__nfet_01v8 L=0.5u W=1u
M14069 o7 ibias vss vss sky130_fd_pr__nfet_01v8 L=0.5u W=1u
M14070 o7 ibias vss vss sky130_fd_pr__nfet_01v8 L=0.5u W=1u
M14071 o7 ibias vss vss sky130_fd_pr__nfet_01v8 L=0.5u W=1u
M14072 o7 ibias vss vss sky130_fd_pr__nfet_01v8 L=0.5u W=1u
M14073 o7 ibias vss vss sky130_fd_pr__nfet_01v8 L=0.5u W=1u
M14074 o7 ibias vss vss sky130_fd_pr__nfet_01v8 L=0.5u W=1u
M14075 o7 ibias vss vss sky130_fd_pr__nfet_01v8 L=0.5u W=1u
M14076 o7 ibias vss vss sky130_fd_pr__nfet_01v8 L=0.5u W=1u
M14077 o7 ibias vss vss sky130_fd_pr__nfet_01v8 L=0.5u W=1u
M14078 o7 ibias vss vss sky130_fd_pr__nfet_01v8 L=0.5u W=1u
M14079 o7 ibias vss vss sky130_fd_pr__nfet_01v8 L=0.5u W=1u
M14080 o7 ibias vss vss sky130_fd_pr__nfet_01v8 L=0.5u W=1u
M14081 o7 ibias vss vss sky130_fd_pr__nfet_01v8 L=0.5u W=1u
M14082 o7 ibias vss vss sky130_fd_pr__nfet_01v8 L=0.5u W=1u
M14083 o7 ibias vss vss sky130_fd_pr__nfet_01v8 L=0.5u W=1u
M14084 o7 ibias vss vss sky130_fd_pr__nfet_01v8 L=0.5u W=1u
M14085 o7 ibias vss vss sky130_fd_pr__nfet_01v8 L=0.5u W=1u
M14086 o7 ibias vss vss sky130_fd_pr__nfet_01v8 L=0.5u W=1u
M14087 o7 ibias vss vss sky130_fd_pr__nfet_01v8 L=0.5u W=1u
M14088 o7 ibias vss vss sky130_fd_pr__nfet_01v8 L=0.5u W=1u
M14089 o7 ibias vss vss sky130_fd_pr__nfet_01v8 L=0.5u W=1u
M14090 o7 ibias vss vss sky130_fd_pr__nfet_01v8 L=0.5u W=1u
M14091 o7 ibias vss vss sky130_fd_pr__nfet_01v8 L=0.5u W=1u
M14092 o7 ibias vss vss sky130_fd_pr__nfet_01v8 L=0.5u W=1u
M14093 o7 ibias vss vss sky130_fd_pr__nfet_01v8 L=0.5u W=1u
M14094 o7 ibias vss vss sky130_fd_pr__nfet_01v8 L=0.5u W=1u
M14095 o7 ibias vss vss sky130_fd_pr__nfet_01v8 L=0.5u W=1u
M14096 o7 ibias vss vss sky130_fd_pr__nfet_01v8 L=0.5u W=1u
M14097 o7 ibias vss vss sky130_fd_pr__nfet_01v8 L=0.5u W=1u
M14098 o7 ibias vss vss sky130_fd_pr__nfet_01v8 L=0.5u W=1u
M14099 o7 ibias vss vss sky130_fd_pr__nfet_01v8 L=0.5u W=1u
M14100 o7 ibias vss vss sky130_fd_pr__nfet_01v8 L=0.5u W=1u
M14101 o7 ibias vss vss sky130_fd_pr__nfet_01v8 L=0.5u W=1u
M14102 o7 ibias vss vss sky130_fd_pr__nfet_01v8 L=0.5u W=1u
M14103 o7 ibias vss vss sky130_fd_pr__nfet_01v8 L=0.5u W=1u
M14104 o7 ibias vss vss sky130_fd_pr__nfet_01v8 L=0.5u W=1u
M14105 o7 ibias vss vss sky130_fd_pr__nfet_01v8 L=0.5u W=1u
M14106 o7 ibias vss vss sky130_fd_pr__nfet_01v8 L=0.5u W=1u
M14107 o7 ibias vss vss sky130_fd_pr__nfet_01v8 L=0.5u W=1u
M14108 o7 ibias vss vss sky130_fd_pr__nfet_01v8 L=0.5u W=1u
M14109 o7 ibias vss vss sky130_fd_pr__nfet_01v8 L=0.5u W=1u
M14110 o7 ibias vss vss sky130_fd_pr__nfet_01v8 L=0.5u W=1u
M14111 o7 ibias vss vss sky130_fd_pr__nfet_01v8 L=0.5u W=1u
M14112 o7 ibias vss vss sky130_fd_pr__nfet_01v8 L=0.5u W=1u
M14113 o7 ibias vss vss sky130_fd_pr__nfet_01v8 L=0.5u W=1u
M14114 o7 ibias vss vss sky130_fd_pr__nfet_01v8 L=0.5u W=1u
M14115 o7 ibias vss vss sky130_fd_pr__nfet_01v8 L=0.5u W=1u
M14116 o7 ibias vss vss sky130_fd_pr__nfet_01v8 L=0.5u W=1u
M14117 o7 ibias vss vss sky130_fd_pr__nfet_01v8 L=0.5u W=1u
M14118 o7 ibias vss vss sky130_fd_pr__nfet_01v8 L=0.5u W=1u
M14119 o7 ibias vss vss sky130_fd_pr__nfet_01v8 L=0.5u W=1u
M14120 o7 ibias vss vss sky130_fd_pr__nfet_01v8 L=0.5u W=1u
M14121 o7 ibias vss vss sky130_fd_pr__nfet_01v8 L=0.5u W=1u
M14122 o7 ibias vss vss sky130_fd_pr__nfet_01v8 L=0.5u W=1u
M14123 o7 ibias vss vss sky130_fd_pr__nfet_01v8 L=0.5u W=1u
M14124 o7 ibias vss vss sky130_fd_pr__nfet_01v8 L=0.5u W=1u
M14125 o7 ibias vss vss sky130_fd_pr__nfet_01v8 L=0.5u W=1u
M14126 o7 ibias vss vss sky130_fd_pr__nfet_01v8 L=0.5u W=1u
M14127 o7 ibias vss vss sky130_fd_pr__nfet_01v8 L=0.5u W=1u
M14128 o7 ibias vss vss sky130_fd_pr__nfet_01v8 L=0.5u W=1u
M14129 o7 ibias vss vss sky130_fd_pr__nfet_01v8 L=0.5u W=1u
M14130 o7 ibias vss vss sky130_fd_pr__nfet_01v8 L=0.5u W=1u
M14131 o7 ibias vss vss sky130_fd_pr__nfet_01v8 L=0.5u W=1u
M14132 o7 ibias vss vss sky130_fd_pr__nfet_01v8 L=0.5u W=1u
M14133 o7 ibias vss vss sky130_fd_pr__nfet_01v8 L=0.5u W=1u
M14134 o7 ibias vss vss sky130_fd_pr__nfet_01v8 L=0.5u W=1u
M14135 o7 ibias vss vss sky130_fd_pr__nfet_01v8 L=0.5u W=1u
M14136 o7 ibias vss vss sky130_fd_pr__nfet_01v8 L=0.5u W=1u
M14137 o7 ibias vss vss sky130_fd_pr__nfet_01v8 L=0.5u W=1u
M14138 o7 ibias vss vss sky130_fd_pr__nfet_01v8 L=0.5u W=1u
M14139 o7 ibias vss vss sky130_fd_pr__nfet_01v8 L=0.5u W=1u
M14140 o7 ibias vss vss sky130_fd_pr__nfet_01v8 L=0.5u W=1u
M14141 o7 ibias vss vss sky130_fd_pr__nfet_01v8 L=0.5u W=1u
M14142 o7 ibias vss vss sky130_fd_pr__nfet_01v8 L=0.5u W=1u
M14143 o7 ibias vss vss sky130_fd_pr__nfet_01v8 L=0.5u W=1u
M14144 o7 ibias vss vss sky130_fd_pr__nfet_01v8 L=0.5u W=1u
M14145 o7 ibias vss vss sky130_fd_pr__nfet_01v8 L=0.5u W=1u
M14146 o7 ibias vss vss sky130_fd_pr__nfet_01v8 L=0.5u W=1u
M14147 o7 ibias vss vss sky130_fd_pr__nfet_01v8 L=0.5u W=1u
M14148 o7 ibias vss vss sky130_fd_pr__nfet_01v8 L=0.5u W=1u
M14149 o7 ibias vss vss sky130_fd_pr__nfet_01v8 L=0.5u W=1u
M14150 o7 ibias vss vss sky130_fd_pr__nfet_01v8 L=0.5u W=1u
M14151 o7 ibias vss vss sky130_fd_pr__nfet_01v8 L=0.5u W=1u
M14152 o7 ibias vss vss sky130_fd_pr__nfet_01v8 L=0.5u W=1u
M14153 o7 ibias vss vss sky130_fd_pr__nfet_01v8 L=0.5u W=1u
M14154 o7 ibias vss vss sky130_fd_pr__nfet_01v8 L=0.5u W=1u
M14155 o7 ibias vss vss sky130_fd_pr__nfet_01v8 L=0.5u W=1u
M14156 o7 ibias vss vss sky130_fd_pr__nfet_01v8 L=0.5u W=1u
M14157 o7 ibias vss vss sky130_fd_pr__nfet_01v8 L=0.5u W=1u
M14158 o7 ibias vss vss sky130_fd_pr__nfet_01v8 L=0.5u W=1u
M14159 o7 ibias vss vss sky130_fd_pr__nfet_01v8 L=0.5u W=1u
M14160 o7 ibias vss vss sky130_fd_pr__nfet_01v8 L=0.5u W=1u
M14161 o7 ibias vss vss sky130_fd_pr__nfet_01v8 L=0.5u W=1u
M14162 o7 ibias vss vss sky130_fd_pr__nfet_01v8 L=0.5u W=1u
M14163 o7 ibias vss vss sky130_fd_pr__nfet_01v8 L=0.5u W=1u
M14164 o7 ibias vss vss sky130_fd_pr__nfet_01v8 L=0.5u W=1u
M14165 o7 ibias vss vss sky130_fd_pr__nfet_01v8 L=0.5u W=1u
M14166 o7 ibias vss vss sky130_fd_pr__nfet_01v8 L=0.5u W=1u
M14167 o7 ibias vss vss sky130_fd_pr__nfet_01v8 L=0.5u W=1u
M14168 o7 ibias vss vss sky130_fd_pr__nfet_01v8 L=0.5u W=1u
M14169 o7 ibias vss vss sky130_fd_pr__nfet_01v8 L=0.5u W=1u
M14170 o7 ibias vss vss sky130_fd_pr__nfet_01v8 L=0.5u W=1u
M14171 o7 ibias vss vss sky130_fd_pr__nfet_01v8 L=0.5u W=1u
M14172 o7 ibias vss vss sky130_fd_pr__nfet_01v8 L=0.5u W=1u
M14173 o7 ibias vss vss sky130_fd_pr__nfet_01v8 L=0.5u W=1u
M14174 o7 ibias vss vss sky130_fd_pr__nfet_01v8 L=0.5u W=1u
M14175 o7 ibias vss vss sky130_fd_pr__nfet_01v8 L=0.5u W=1u
M14176 o7 ibias vss vss sky130_fd_pr__nfet_01v8 L=0.5u W=1u
M14177 o7 ibias vss vss sky130_fd_pr__nfet_01v8 L=0.5u W=1u
M14178 o7 ibias vss vss sky130_fd_pr__nfet_01v8 L=0.5u W=1u
M14179 o7 ibias vss vss sky130_fd_pr__nfet_01v8 L=0.5u W=1u
M14180 o7 ibias vss vss sky130_fd_pr__nfet_01v8 L=0.5u W=1u
M14181 o7 ibias vss vss sky130_fd_pr__nfet_01v8 L=0.5u W=1u
M14182 o7 ibias vss vss sky130_fd_pr__nfet_01v8 L=0.5u W=1u
M14183 o7 ibias vss vss sky130_fd_pr__nfet_01v8 L=0.5u W=1u
M14184 o7 ibias vss vss sky130_fd_pr__nfet_01v8 L=0.5u W=1u
M14185 o7 ibias vss vss sky130_fd_pr__nfet_01v8 L=0.5u W=1u
M14186 o7 ibias vss vss sky130_fd_pr__nfet_01v8 L=0.5u W=1u
M14187 o7 ibias vss vss sky130_fd_pr__nfet_01v8 L=0.5u W=1u
M14188 o7 ibias vss vss sky130_fd_pr__nfet_01v8 L=0.5u W=1u
M14189 o7 ibias vss vss sky130_fd_pr__nfet_01v8 L=0.5u W=1u
M14190 o7 ibias vss vss sky130_fd_pr__nfet_01v8 L=0.5u W=1u
M14191 o7 ibias vss vss sky130_fd_pr__nfet_01v8 L=0.5u W=1u
M14192 o7 ibias vss vss sky130_fd_pr__nfet_01v8 L=0.5u W=1u
M14193 o7 ibias vss vss sky130_fd_pr__nfet_01v8 L=0.5u W=1u
M14194 o7 ibias vss vss sky130_fd_pr__nfet_01v8 L=0.5u W=1u
M14195 o7 ibias vss vss sky130_fd_pr__nfet_01v8 L=0.5u W=1u
M14196 o7 ibias vss vss sky130_fd_pr__nfet_01v8 L=0.5u W=1u
M14197 o7 ibias vss vss sky130_fd_pr__nfet_01v8 L=0.5u W=1u
M14198 o7 ibias vss vss sky130_fd_pr__nfet_01v8 L=0.5u W=1u
M14199 o7 ibias vss vss sky130_fd_pr__nfet_01v8 L=0.5u W=1u
M14200 o7 ibias vss vss sky130_fd_pr__nfet_01v8 L=0.5u W=1u
M14201 o7 ibias vss vss sky130_fd_pr__nfet_01v8 L=0.5u W=1u
M14202 o7 ibias vss vss sky130_fd_pr__nfet_01v8 L=0.5u W=1u
M14203 o7 ibias vss vss sky130_fd_pr__nfet_01v8 L=0.5u W=1u
M14204 o7 ibias vss vss sky130_fd_pr__nfet_01v8 L=0.5u W=1u
M14205 o7 ibias vss vss sky130_fd_pr__nfet_01v8 L=0.5u W=1u
M14206 o7 ibias vss vss sky130_fd_pr__nfet_01v8 L=0.5u W=1u
M14207 o7 ibias vss vss sky130_fd_pr__nfet_01v8 L=0.5u W=1u
M14208 o7 ibias vss vss sky130_fd_pr__nfet_01v8 L=0.5u W=1u
M14209 o7 ibias vss vss sky130_fd_pr__nfet_01v8 L=0.5u W=1u
M14210 o7 ibias vss vss sky130_fd_pr__nfet_01v8 L=0.5u W=1u
M14211 o7 ibias vss vss sky130_fd_pr__nfet_01v8 L=0.5u W=1u
M14212 o7 ibias vss vss sky130_fd_pr__nfet_01v8 L=0.5u W=1u
M14213 o7 ibias vss vss sky130_fd_pr__nfet_01v8 L=0.5u W=1u
M14214 o7 ibias vss vss sky130_fd_pr__nfet_01v8 L=0.5u W=1u
M14215 o7 ibias vss vss sky130_fd_pr__nfet_01v8 L=0.5u W=1u
M14216 o7 ibias vss vss sky130_fd_pr__nfet_01v8 L=0.5u W=1u
M14217 o7 ibias vss vss sky130_fd_pr__nfet_01v8 L=0.5u W=1u
M14218 o7 ibias vss vss sky130_fd_pr__nfet_01v8 L=0.5u W=1u
M14219 o7 ibias vss vss sky130_fd_pr__nfet_01v8 L=0.5u W=1u
M14220 o7 ibias vss vss sky130_fd_pr__nfet_01v8 L=0.5u W=1u
M14221 o7 ibias vss vss sky130_fd_pr__nfet_01v8 L=0.5u W=1u
M14222 o7 ibias vss vss sky130_fd_pr__nfet_01v8 L=0.5u W=1u
M14223 o7 ibias vss vss sky130_fd_pr__nfet_01v8 L=0.5u W=1u
M14224 o7 ibias vss vss sky130_fd_pr__nfet_01v8 L=0.5u W=1u
M14225 o7 ibias vss vss sky130_fd_pr__nfet_01v8 L=0.5u W=1u
M14226 o7 ibias vss vss sky130_fd_pr__nfet_01v8 L=0.5u W=1u
M14227 o7 ibias vss vss sky130_fd_pr__nfet_01v8 L=0.5u W=1u
M14228 o7 ibias vss vss sky130_fd_pr__nfet_01v8 L=0.5u W=1u
M14229 o7 ibias vss vss sky130_fd_pr__nfet_01v8 L=0.5u W=1u
M14230 o7 ibias vss vss sky130_fd_pr__nfet_01v8 L=0.5u W=1u
M14231 o7 ibias vss vss sky130_fd_pr__nfet_01v8 L=0.5u W=1u
M14232 o7 ibias vss vss sky130_fd_pr__nfet_01v8 L=0.5u W=1u
M14233 o7 ibias vss vss sky130_fd_pr__nfet_01v8 L=0.5u W=1u
M14234 o7 ibias vss vss sky130_fd_pr__nfet_01v8 L=0.5u W=1u
M14235 o7 ibias vss vss sky130_fd_pr__nfet_01v8 L=0.5u W=1u
M14236 o7 ibias vss vss sky130_fd_pr__nfet_01v8 L=0.5u W=1u
M14237 o7 ibias vss vss sky130_fd_pr__nfet_01v8 L=0.5u W=1u
M14238 o7 ibias vss vss sky130_fd_pr__nfet_01v8 L=0.5u W=1u
M14239 o7 ibias vss vss sky130_fd_pr__nfet_01v8 L=0.5u W=1u
M14240 o7 ibias vss vss sky130_fd_pr__nfet_01v8 L=0.5u W=1u
M14241 o7 ibias vss vss sky130_fd_pr__nfet_01v8 L=0.5u W=1u
M14242 o7 ibias vss vss sky130_fd_pr__nfet_01v8 L=0.5u W=1u
M14243 o7 ibias vss vss sky130_fd_pr__nfet_01v8 L=0.5u W=1u
M14244 o7 ibias vss vss sky130_fd_pr__nfet_01v8 L=0.5u W=1u
M14245 o7 ibias vss vss sky130_fd_pr__nfet_01v8 L=0.5u W=1u
M14246 o7 ibias vss vss sky130_fd_pr__nfet_01v8 L=0.5u W=1u
M14247 o7 ibias vss vss sky130_fd_pr__nfet_01v8 L=0.5u W=1u
M14248 o7 ibias vss vss sky130_fd_pr__nfet_01v8 L=0.5u W=1u
M14249 o7 ibias vss vss sky130_fd_pr__nfet_01v8 L=0.5u W=1u
M14250 o7 ibias vss vss sky130_fd_pr__nfet_01v8 L=0.5u W=1u
M14251 o7 ibias vss vss sky130_fd_pr__nfet_01v8 L=0.5u W=1u
M14252 o7 ibias vss vss sky130_fd_pr__nfet_01v8 L=0.5u W=1u
M14253 o7 ibias vss vss sky130_fd_pr__nfet_01v8 L=0.5u W=1u
M14254 o7 ibias vss vss sky130_fd_pr__nfet_01v8 L=0.5u W=1u
M14255 o7 ibias vss vss sky130_fd_pr__nfet_01v8 L=0.5u W=1u
M14256 o7 ibias vss vss sky130_fd_pr__nfet_01v8 L=0.5u W=1u
M14257 o7 ibias vss vss sky130_fd_pr__nfet_01v8 L=0.5u W=1u
M14258 o7 ibias vss vss sky130_fd_pr__nfet_01v8 L=0.5u W=1u
M14259 o7 ibias vss vss sky130_fd_pr__nfet_01v8 L=0.5u W=1u
M14260 o7 ibias vss vss sky130_fd_pr__nfet_01v8 L=0.5u W=1u
M14261 o7 ibias vss vss sky130_fd_pr__nfet_01v8 L=0.5u W=1u
M14262 o7 ibias vss vss sky130_fd_pr__nfet_01v8 L=0.5u W=1u
M14263 o7 ibias vss vss sky130_fd_pr__nfet_01v8 L=0.5u W=1u
M14264 o7 ibias vss vss sky130_fd_pr__nfet_01v8 L=0.5u W=1u
M14265 o7 ibias vss vss sky130_fd_pr__nfet_01v8 L=0.5u W=1u
M14266 o7 ibias vss vss sky130_fd_pr__nfet_01v8 L=0.5u W=1u
M14267 o7 ibias vss vss sky130_fd_pr__nfet_01v8 L=0.5u W=1u
M14268 o7 ibias vss vss sky130_fd_pr__nfet_01v8 L=0.5u W=1u
M14269 o7 ibias vss vss sky130_fd_pr__nfet_01v8 L=0.5u W=1u
M14270 o7 ibias vss vss sky130_fd_pr__nfet_01v8 L=0.5u W=1u
M14271 o7 ibias vss vss sky130_fd_pr__nfet_01v8 L=0.5u W=1u
M14272 o7 ibias vss vss sky130_fd_pr__nfet_01v8 L=0.5u W=1u
M14273 o7 ibias vss vss sky130_fd_pr__nfet_01v8 L=0.5u W=1u
M14274 o7 ibias vss vss sky130_fd_pr__nfet_01v8 L=0.5u W=1u
M14275 o7 ibias vss vss sky130_fd_pr__nfet_01v8 L=0.5u W=1u
M14276 o7 ibias vss vss sky130_fd_pr__nfet_01v8 L=0.5u W=1u
M14277 o7 ibias vss vss sky130_fd_pr__nfet_01v8 L=0.5u W=1u
M14278 o7 ibias vss vss sky130_fd_pr__nfet_01v8 L=0.5u W=1u
M14279 o7 ibias vss vss sky130_fd_pr__nfet_01v8 L=0.5u W=1u
M14280 o7 ibias vss vss sky130_fd_pr__nfet_01v8 L=0.5u W=1u
M14281 o7 ibias vss vss sky130_fd_pr__nfet_01v8 L=0.5u W=1u
M14282 o7 ibias vss vss sky130_fd_pr__nfet_01v8 L=0.5u W=1u
M14283 o7 ibias vss vss sky130_fd_pr__nfet_01v8 L=0.5u W=1u
M14284 o7 ibias vss vss sky130_fd_pr__nfet_01v8 L=0.5u W=1u
M14285 o7 ibias vss vss sky130_fd_pr__nfet_01v8 L=0.5u W=1u
M14286 o7 ibias vss vss sky130_fd_pr__nfet_01v8 L=0.5u W=1u
M14287 o7 ibias vss vss sky130_fd_pr__nfet_01v8 L=0.5u W=1u
M14288 o7 ibias vss vss sky130_fd_pr__nfet_01v8 L=0.5u W=1u
M14289 o7 ibias vss vss sky130_fd_pr__nfet_01v8 L=0.5u W=1u
M14290 o7 ibias vss vss sky130_fd_pr__nfet_01v8 L=0.5u W=1u
M14291 o7 ibias vss vss sky130_fd_pr__nfet_01v8 L=0.5u W=1u
M14292 o7 ibias vss vss sky130_fd_pr__nfet_01v8 L=0.5u W=1u
M14293 o7 ibias vss vss sky130_fd_pr__nfet_01v8 L=0.5u W=1u
M14294 o7 ibias vss vss sky130_fd_pr__nfet_01v8 L=0.5u W=1u
M14295 o7 ibias vss vss sky130_fd_pr__nfet_01v8 L=0.5u W=1u
M14296 o7 ibias vss vss sky130_fd_pr__nfet_01v8 L=0.5u W=1u
M14297 o7 ibias vss vss sky130_fd_pr__nfet_01v8 L=0.5u W=1u
M14298 o7 ibias vss vss sky130_fd_pr__nfet_01v8 L=0.5u W=1u
M14299 o7 ibias vss vss sky130_fd_pr__nfet_01v8 L=0.5u W=1u
M14300 o7 ibias vss vss sky130_fd_pr__nfet_01v8 L=0.5u W=1u
M14301 o7 ibias vss vss sky130_fd_pr__nfet_01v8 L=0.5u W=1u
M14302 o7 ibias vss vss sky130_fd_pr__nfet_01v8 L=0.5u W=1u
M14303 o7 ibias vss vss sky130_fd_pr__nfet_01v8 L=0.5u W=1u
M14304 o7 ibias vss vss sky130_fd_pr__nfet_01v8 L=0.5u W=1u
M14305 o7 ibias vss vss sky130_fd_pr__nfet_01v8 L=0.5u W=1u
M14306 o7 ibias vss vss sky130_fd_pr__nfet_01v8 L=0.5u W=1u
M14307 o7 ibias vss vss sky130_fd_pr__nfet_01v8 L=0.5u W=1u
M14308 o7 ibias vss vss sky130_fd_pr__nfet_01v8 L=0.5u W=1u
M14309 o7 ibias vss vss sky130_fd_pr__nfet_01v8 L=0.5u W=1u
M14310 o7 ibias vss vss sky130_fd_pr__nfet_01v8 L=0.5u W=1u
M14311 o7 ibias vss vss sky130_fd_pr__nfet_01v8 L=0.5u W=1u
M14312 o7 ibias vss vss sky130_fd_pr__nfet_01v8 L=0.5u W=1u
M14313 o7 ibias vss vss sky130_fd_pr__nfet_01v8 L=0.5u W=1u
M14314 o7 ibias vss vss sky130_fd_pr__nfet_01v8 L=0.5u W=1u
M14315 o7 ibias vss vss sky130_fd_pr__nfet_01v8 L=0.5u W=1u
M14316 o7 ibias vss vss sky130_fd_pr__nfet_01v8 L=0.5u W=1u
M14317 o7 ibias vss vss sky130_fd_pr__nfet_01v8 L=0.5u W=1u
M14318 o7 ibias vss vss sky130_fd_pr__nfet_01v8 L=0.5u W=1u
M14319 o7 ibias vss vss sky130_fd_pr__nfet_01v8 L=0.5u W=1u
M14320 o7 ibias vss vss sky130_fd_pr__nfet_01v8 L=0.5u W=1u
M14321 o7 ibias vss vss sky130_fd_pr__nfet_01v8 L=0.5u W=1u
M14322 o7 ibias vss vss sky130_fd_pr__nfet_01v8 L=0.5u W=1u
M14323 o7 ibias vss vss sky130_fd_pr__nfet_01v8 L=0.5u W=1u
M14324 o7 ibias vss vss sky130_fd_pr__nfet_01v8 L=0.5u W=1u
M14325 o7 ibias vss vss sky130_fd_pr__nfet_01v8 L=0.5u W=1u
M14326 o7 ibias vss vss sky130_fd_pr__nfet_01v8 L=0.5u W=1u
M14327 o7 ibias vss vss sky130_fd_pr__nfet_01v8 L=0.5u W=1u
M14328 o7 ibias vss vss sky130_fd_pr__nfet_01v8 L=0.5u W=1u
M14329 o7 ibias vss vss sky130_fd_pr__nfet_01v8 L=0.5u W=1u
M14330 o7 ibias vss vss sky130_fd_pr__nfet_01v8 L=0.5u W=1u
M14331 o7 ibias vss vss sky130_fd_pr__nfet_01v8 L=0.5u W=1u
M14332 o7 ibias vss vss sky130_fd_pr__nfet_01v8 L=0.5u W=1u
M14333 o7 ibias vss vss sky130_fd_pr__nfet_01v8 L=0.5u W=1u
M14334 o7 ibias vss vss sky130_fd_pr__nfet_01v8 L=0.5u W=1u
M14335 o7 ibias vss vss sky130_fd_pr__nfet_01v8 L=0.5u W=1u
M14336 o7 ibias vss vss sky130_fd_pr__nfet_01v8 L=0.5u W=1u
M14337 o7 ibias vss vss sky130_fd_pr__nfet_01v8 L=0.5u W=1u
M14338 o7 ibias vss vss sky130_fd_pr__nfet_01v8 L=0.5u W=1u
M14339 o7 ibias vss vss sky130_fd_pr__nfet_01v8 L=0.5u W=1u
M14340 o7 ibias vss vss sky130_fd_pr__nfet_01v8 L=0.5u W=1u
M14341 o7 ibias vss vss sky130_fd_pr__nfet_01v8 L=0.5u W=1u
M14342 o7 ibias vss vss sky130_fd_pr__nfet_01v8 L=0.5u W=1u
M14343 o7 ibias vss vss sky130_fd_pr__nfet_01v8 L=0.5u W=1u
M14344 o7 ibias vss vss sky130_fd_pr__nfet_01v8 L=0.5u W=1u
M14345 o7 ibias vss vss sky130_fd_pr__nfet_01v8 L=0.5u W=1u
M14346 o7 ibias vss vss sky130_fd_pr__nfet_01v8 L=0.5u W=1u
M14347 o7 ibias vss vss sky130_fd_pr__nfet_01v8 L=0.5u W=1u
M14348 o7 ibias vss vss sky130_fd_pr__nfet_01v8 L=0.5u W=1u
M14349 o7 ibias vss vss sky130_fd_pr__nfet_01v8 L=0.5u W=1u
M14350 o7 ibias vss vss sky130_fd_pr__nfet_01v8 L=0.5u W=1u
M14351 o7 ibias vss vss sky130_fd_pr__nfet_01v8 L=0.5u W=1u
M14352 o7 ibias vss vss sky130_fd_pr__nfet_01v8 L=0.5u W=1u
M14353 o7 ibias vss vss sky130_fd_pr__nfet_01v8 L=0.5u W=1u
M14354 o7 ibias vss vss sky130_fd_pr__nfet_01v8 L=0.5u W=1u
M14355 o7 ibias vss vss sky130_fd_pr__nfet_01v8 L=0.5u W=1u
M14356 o7 ibias vss vss sky130_fd_pr__nfet_01v8 L=0.5u W=1u
M14357 o7 ibias vss vss sky130_fd_pr__nfet_01v8 L=0.5u W=1u
M14358 o7 ibias vss vss sky130_fd_pr__nfet_01v8 L=0.5u W=1u
M14359 o7 ibias vss vss sky130_fd_pr__nfet_01v8 L=0.5u W=1u
M14360 o7 ibias vss vss sky130_fd_pr__nfet_01v8 L=0.5u W=1u
M14361 o7 ibias vss vss sky130_fd_pr__nfet_01v8 L=0.5u W=1u
M14362 o7 ibias vss vss sky130_fd_pr__nfet_01v8 L=0.5u W=1u
M14363 o7 ibias vss vss sky130_fd_pr__nfet_01v8 L=0.5u W=1u
M14364 o7 ibias vss vss sky130_fd_pr__nfet_01v8 L=0.5u W=1u
M14365 o7 ibias vss vss sky130_fd_pr__nfet_01v8 L=0.5u W=1u
M14366 o7 ibias vss vss sky130_fd_pr__nfet_01v8 L=0.5u W=1u
M14367 o7 ibias vss vss sky130_fd_pr__nfet_01v8 L=0.5u W=1u
M14368 o7 ibias vss vss sky130_fd_pr__nfet_01v8 L=0.5u W=1u
M14369 o7 ibias vss vss sky130_fd_pr__nfet_01v8 L=0.5u W=1u
M14370 o7 ibias vss vss sky130_fd_pr__nfet_01v8 L=0.5u W=1u
M14371 o7 ibias vss vss sky130_fd_pr__nfet_01v8 L=0.5u W=1u
M14372 o7 ibias vss vss sky130_fd_pr__nfet_01v8 L=0.5u W=1u
M14373 o7 ibias vss vss sky130_fd_pr__nfet_01v8 L=0.5u W=1u
M14374 o7 ibias vss vss sky130_fd_pr__nfet_01v8 L=0.5u W=1u
M14375 o7 ibias vss vss sky130_fd_pr__nfet_01v8 L=0.5u W=1u
M14376 o7 ibias vss vss sky130_fd_pr__nfet_01v8 L=0.5u W=1u
M14377 o7 ibias vss vss sky130_fd_pr__nfet_01v8 L=0.5u W=1u
M14378 o7 ibias vss vss sky130_fd_pr__nfet_01v8 L=0.5u W=1u
M14379 o7 ibias vss vss sky130_fd_pr__nfet_01v8 L=0.5u W=1u
M14380 o7 ibias vss vss sky130_fd_pr__nfet_01v8 L=0.5u W=1u
M14381 o7 ibias vss vss sky130_fd_pr__nfet_01v8 L=0.5u W=1u
M14382 o7 ibias vss vss sky130_fd_pr__nfet_01v8 L=0.5u W=1u
M14383 o7 ibias vss vss sky130_fd_pr__nfet_01v8 L=0.5u W=1u
M14384 o7 ibias vss vss sky130_fd_pr__nfet_01v8 L=0.5u W=1u
M14385 o7 ibias vss vss sky130_fd_pr__nfet_01v8 L=0.5u W=1u
M14386 o7 ibias vss vss sky130_fd_pr__nfet_01v8 L=0.5u W=1u
M14387 o7 ibias vss vss sky130_fd_pr__nfet_01v8 L=0.5u W=1u
M14388 o7 ibias vss vss sky130_fd_pr__nfet_01v8 L=0.5u W=1u
M14389 o7 ibias vss vss sky130_fd_pr__nfet_01v8 L=0.5u W=1u
M14390 o7 ibias vss vss sky130_fd_pr__nfet_01v8 L=0.5u W=1u
M14391 o7 ibias vss vss sky130_fd_pr__nfet_01v8 L=0.5u W=1u
M14392 o7 ibias vss vss sky130_fd_pr__nfet_01v8 L=0.5u W=1u
M14393 o7 ibias vss vss sky130_fd_pr__nfet_01v8 L=0.5u W=1u
M14394 o7 ibias vss vss sky130_fd_pr__nfet_01v8 L=0.5u W=1u
M14395 o7 ibias vss vss sky130_fd_pr__nfet_01v8 L=0.5u W=1u
M14396 o7 ibias vss vss sky130_fd_pr__nfet_01v8 L=0.5u W=1u
M14397 o7 ibias vss vss sky130_fd_pr__nfet_01v8 L=0.5u W=1u
M14398 o7 ibias vss vss sky130_fd_pr__nfet_01v8 L=0.5u W=1u
M14399 o7 ibias vss vss sky130_fd_pr__nfet_01v8 L=0.5u W=1u
M14400 o7 ibias vss vss sky130_fd_pr__nfet_01v8 L=0.5u W=1u
M14401 o7 ibias vss vss sky130_fd_pr__nfet_01v8 L=0.5u W=1u
M14402 o7 ibias vss vss sky130_fd_pr__nfet_01v8 L=0.5u W=1u
M14403 o7 ibias vss vss sky130_fd_pr__nfet_01v8 L=0.5u W=1u
M14404 o7 ibias vss vss sky130_fd_pr__nfet_01v8 L=0.5u W=1u
M14405 o7 ibias vss vss sky130_fd_pr__nfet_01v8 L=0.5u W=1u
M14406 o7 ibias vss vss sky130_fd_pr__nfet_01v8 L=0.5u W=1u
M14407 o7 ibias vss vss sky130_fd_pr__nfet_01v8 L=0.5u W=1u
M14408 o7 ibias vss vss sky130_fd_pr__nfet_01v8 L=0.5u W=1u
M14409 o7 ibias vss vss sky130_fd_pr__nfet_01v8 L=0.5u W=1u
M14410 o7 ibias vss vss sky130_fd_pr__nfet_01v8 L=0.5u W=1u
M14411 o7 ibias vss vss sky130_fd_pr__nfet_01v8 L=0.5u W=1u
M14412 o7 ibias vss vss sky130_fd_pr__nfet_01v8 L=0.5u W=1u
M14413 o7 ibias vss vss sky130_fd_pr__nfet_01v8 L=0.5u W=1u
M14414 o7 ibias vss vss sky130_fd_pr__nfet_01v8 L=0.5u W=1u
M14415 o7 ibias vss vss sky130_fd_pr__nfet_01v8 L=0.5u W=1u
M14416 o7 ibias vss vss sky130_fd_pr__nfet_01v8 L=0.5u W=1u
M14417 o7 ibias vss vss sky130_fd_pr__nfet_01v8 L=0.5u W=1u
M14418 o7 ibias vss vss sky130_fd_pr__nfet_01v8 L=0.5u W=1u
M14419 o7 ibias vss vss sky130_fd_pr__nfet_01v8 L=0.5u W=1u
M14420 o7 ibias vss vss sky130_fd_pr__nfet_01v8 L=0.5u W=1u
M14421 o7 ibias vss vss sky130_fd_pr__nfet_01v8 L=0.5u W=1u
M14422 o7 ibias vss vss sky130_fd_pr__nfet_01v8 L=0.5u W=1u
M14423 o7 ibias vss vss sky130_fd_pr__nfet_01v8 L=0.5u W=1u
M14424 o7 ibias vss vss sky130_fd_pr__nfet_01v8 L=0.5u W=1u
M14425 o7 ibias vss vss sky130_fd_pr__nfet_01v8 L=0.5u W=1u
M14426 o7 ibias vss vss sky130_fd_pr__nfet_01v8 L=0.5u W=1u
M14427 o7 ibias vss vss sky130_fd_pr__nfet_01v8 L=0.5u W=1u
M14428 o7 ibias vss vss sky130_fd_pr__nfet_01v8 L=0.5u W=1u
M14429 o7 ibias vss vss sky130_fd_pr__nfet_01v8 L=0.5u W=1u
M14430 o7 ibias vss vss sky130_fd_pr__nfet_01v8 L=0.5u W=1u
M14431 o7 ibias vss vss sky130_fd_pr__nfet_01v8 L=0.5u W=1u
M14432 o7 ibias vss vss sky130_fd_pr__nfet_01v8 L=0.5u W=1u
M14433 o7 ibias vss vss sky130_fd_pr__nfet_01v8 L=0.5u W=1u
M14434 o7 ibias vss vss sky130_fd_pr__nfet_01v8 L=0.5u W=1u
M14435 o7 ibias vss vss sky130_fd_pr__nfet_01v8 L=0.5u W=1u
M14436 o7 ibias vss vss sky130_fd_pr__nfet_01v8 L=0.5u W=1u
M14437 o7 ibias vss vss sky130_fd_pr__nfet_01v8 L=0.5u W=1u
M14438 o7 ibias vss vss sky130_fd_pr__nfet_01v8 L=0.5u W=1u
M14439 o7 ibias vss vss sky130_fd_pr__nfet_01v8 L=0.5u W=1u
M14440 o7 ibias vss vss sky130_fd_pr__nfet_01v8 L=0.5u W=1u
M14441 o7 ibias vss vss sky130_fd_pr__nfet_01v8 L=0.5u W=1u
M14442 o7 ibias vss vss sky130_fd_pr__nfet_01v8 L=0.5u W=1u
M14443 o7 ibias vss vss sky130_fd_pr__nfet_01v8 L=0.5u W=1u
M14444 o7 ibias vss vss sky130_fd_pr__nfet_01v8 L=0.5u W=1u
M14445 o7 ibias vss vss sky130_fd_pr__nfet_01v8 L=0.5u W=1u
M14446 o7 ibias vss vss sky130_fd_pr__nfet_01v8 L=0.5u W=1u
M14447 o7 ibias vss vss sky130_fd_pr__nfet_01v8 L=0.5u W=1u
M14448 o7 ibias vss vss sky130_fd_pr__nfet_01v8 L=0.5u W=1u
M14449 o7 ibias vss vss sky130_fd_pr__nfet_01v8 L=0.5u W=1u
M14450 o7 ibias vss vss sky130_fd_pr__nfet_01v8 L=0.5u W=1u
M14451 o7 ibias vss vss sky130_fd_pr__nfet_01v8 L=0.5u W=1u
M14452 o7 ibias vss vss sky130_fd_pr__nfet_01v8 L=0.5u W=1u
M14453 o7 ibias vss vss sky130_fd_pr__nfet_01v8 L=0.5u W=1u
M14454 o7 ibias vss vss sky130_fd_pr__nfet_01v8 L=0.5u W=1u
M14455 o7 ibias vss vss sky130_fd_pr__nfet_01v8 L=0.5u W=1u
M14456 o7 ibias vss vss sky130_fd_pr__nfet_01v8 L=0.5u W=1u
M14457 o7 ibias vss vss sky130_fd_pr__nfet_01v8 L=0.5u W=1u
M14458 o7 ibias vss vss sky130_fd_pr__nfet_01v8 L=0.5u W=1u
M14459 o7 ibias vss vss sky130_fd_pr__nfet_01v8 L=0.5u W=1u
M14460 o7 ibias vss vss sky130_fd_pr__nfet_01v8 L=0.5u W=1u
M14461 o7 ibias vss vss sky130_fd_pr__nfet_01v8 L=0.5u W=1u
M14462 o7 ibias vss vss sky130_fd_pr__nfet_01v8 L=0.5u W=1u
M14463 o7 ibias vss vss sky130_fd_pr__nfet_01v8 L=0.5u W=1u
M14464 o7 ibias vss vss sky130_fd_pr__nfet_01v8 L=0.5u W=1u
M14465 o7 ibias vss vss sky130_fd_pr__nfet_01v8 L=0.5u W=1u
M14466 o7 ibias vss vss sky130_fd_pr__nfet_01v8 L=0.5u W=1u
M14467 o7 ibias vss vss sky130_fd_pr__nfet_01v8 L=0.5u W=1u
M14468 o7 ibias vss vss sky130_fd_pr__nfet_01v8 L=0.5u W=1u
M14469 o7 ibias vss vss sky130_fd_pr__nfet_01v8 L=0.5u W=1u
M14470 o7 ibias vss vss sky130_fd_pr__nfet_01v8 L=0.5u W=1u
M14471 o7 ibias vss vss sky130_fd_pr__nfet_01v8 L=0.5u W=1u
M14472 o7 ibias vss vss sky130_fd_pr__nfet_01v8 L=0.5u W=1u
M14473 o7 ibias vss vss sky130_fd_pr__nfet_01v8 L=0.5u W=1u
M14474 o7 ibias vss vss sky130_fd_pr__nfet_01v8 L=0.5u W=1u
M14475 o7 ibias vss vss sky130_fd_pr__nfet_01v8 L=0.5u W=1u
M14476 o7 ibias vss vss sky130_fd_pr__nfet_01v8 L=0.5u W=1u
M14477 o7 ibias vss vss sky130_fd_pr__nfet_01v8 L=0.5u W=1u
M14478 o7 ibias vss vss sky130_fd_pr__nfet_01v8 L=0.5u W=1u
M14479 o7 ibias vss vss sky130_fd_pr__nfet_01v8 L=0.5u W=1u
M14480 o7 ibias vss vss sky130_fd_pr__nfet_01v8 L=0.5u W=1u
M14481 o7 ibias vss vss sky130_fd_pr__nfet_01v8 L=0.5u W=1u
M14482 o7 ibias vss vss sky130_fd_pr__nfet_01v8 L=0.5u W=1u
M14483 o7 ibias vss vss sky130_fd_pr__nfet_01v8 L=0.5u W=1u
M14484 o7 ibias vss vss sky130_fd_pr__nfet_01v8 L=0.5u W=1u
M14485 o7 ibias vss vss sky130_fd_pr__nfet_01v8 L=0.5u W=1u
M14486 o7 ibias vss vss sky130_fd_pr__nfet_01v8 L=0.5u W=1u
M14487 o7 ibias vss vss sky130_fd_pr__nfet_01v8 L=0.5u W=1u
M14488 o7 ibias vss vss sky130_fd_pr__nfet_01v8 L=0.5u W=1u
M14489 o7 ibias vss vss sky130_fd_pr__nfet_01v8 L=0.5u W=1u
M14490 o7 ibias vss vss sky130_fd_pr__nfet_01v8 L=0.5u W=1u
M14491 o7 ibias vss vss sky130_fd_pr__nfet_01v8 L=0.5u W=1u
M14492 o7 ibias vss vss sky130_fd_pr__nfet_01v8 L=0.5u W=1u
M14493 o7 ibias vss vss sky130_fd_pr__nfet_01v8 L=0.5u W=1u
M14494 o7 ibias vss vss sky130_fd_pr__nfet_01v8 L=0.5u W=1u
M14495 o7 ibias vss vss sky130_fd_pr__nfet_01v8 L=0.5u W=1u
M14496 o7 ibias vss vss sky130_fd_pr__nfet_01v8 L=0.5u W=1u
M14497 o7 ibias vss vss sky130_fd_pr__nfet_01v8 L=0.5u W=1u
M14498 o7 ibias vss vss sky130_fd_pr__nfet_01v8 L=0.5u W=1u
M14499 o7 ibias vss vss sky130_fd_pr__nfet_01v8 L=0.5u W=1u
M14500 o7 ibias vss vss sky130_fd_pr__nfet_01v8 L=0.5u W=1u
M14501 o7 ibias vss vss sky130_fd_pr__nfet_01v8 L=0.5u W=1u
M14502 o7 ibias vss vss sky130_fd_pr__nfet_01v8 L=0.5u W=1u
M14503 o7 ibias vss vss sky130_fd_pr__nfet_01v8 L=0.5u W=1u
M14504 o7 ibias vss vss sky130_fd_pr__nfet_01v8 L=0.5u W=1u
M14505 o7 ibias vss vss sky130_fd_pr__nfet_01v8 L=0.5u W=1u
M14506 o7 ibias vss vss sky130_fd_pr__nfet_01v8 L=0.5u W=1u
M14507 o7 ibias vss vss sky130_fd_pr__nfet_01v8 L=0.5u W=1u
M14508 o7 ibias vss vss sky130_fd_pr__nfet_01v8 L=0.5u W=1u
M14509 o7 ibias vss vss sky130_fd_pr__nfet_01v8 L=0.5u W=1u
M14510 o7 ibias vss vss sky130_fd_pr__nfet_01v8 L=0.5u W=1u
M14511 o7 ibias vss vss sky130_fd_pr__nfet_01v8 L=0.5u W=1u
M14512 o7 ibias vss vss sky130_fd_pr__nfet_01v8 L=0.5u W=1u
M14513 o7 ibias vss vss sky130_fd_pr__nfet_01v8 L=0.5u W=1u
M14514 o7 ibias vss vss sky130_fd_pr__nfet_01v8 L=0.5u W=1u
M14515 o7 ibias vss vss sky130_fd_pr__nfet_01v8 L=0.5u W=1u
M14516 o7 ibias vss vss sky130_fd_pr__nfet_01v8 L=0.5u W=1u
M14517 o7 ibias vss vss sky130_fd_pr__nfet_01v8 L=0.5u W=1u
M14518 o7 ibias vss vss sky130_fd_pr__nfet_01v8 L=0.5u W=1u
M14519 o7 ibias vss vss sky130_fd_pr__nfet_01v8 L=0.5u W=1u
M14520 o7 ibias vss vss sky130_fd_pr__nfet_01v8 L=0.5u W=1u
M14521 o7 ibias vss vss sky130_fd_pr__nfet_01v8 L=0.5u W=1u
M14522 o7 ibias vss vss sky130_fd_pr__nfet_01v8 L=0.5u W=1u
M14523 o7 ibias vss vss sky130_fd_pr__nfet_01v8 L=0.5u W=1u
M14524 o7 ibias vss vss sky130_fd_pr__nfet_01v8 L=0.5u W=1u
M14525 o7 ibias vss vss sky130_fd_pr__nfet_01v8 L=0.5u W=1u
M14526 o7 ibias vss vss sky130_fd_pr__nfet_01v8 L=0.5u W=1u
M14527 o7 ibias vss vss sky130_fd_pr__nfet_01v8 L=0.5u W=1u
M14528 o7 ibias vss vss sky130_fd_pr__nfet_01v8 L=0.5u W=1u
M14529 o7 ibias vss vss sky130_fd_pr__nfet_01v8 L=0.5u W=1u
M14530 o7 ibias vss vss sky130_fd_pr__nfet_01v8 L=0.5u W=1u
M14531 o7 ibias vss vss sky130_fd_pr__nfet_01v8 L=0.5u W=1u
M14532 o7 ibias vss vss sky130_fd_pr__nfet_01v8 L=0.5u W=1u
M14533 o7 ibias vss vss sky130_fd_pr__nfet_01v8 L=0.5u W=1u
M14534 o7 ibias vss vss sky130_fd_pr__nfet_01v8 L=0.5u W=1u
M14535 o7 ibias vss vss sky130_fd_pr__nfet_01v8 L=0.5u W=1u
M14536 o7 ibias vss vss sky130_fd_pr__nfet_01v8 L=0.5u W=1u
M14537 o7 ibias vss vss sky130_fd_pr__nfet_01v8 L=0.5u W=1u
M14538 o7 ibias vss vss sky130_fd_pr__nfet_01v8 L=0.5u W=1u
M14539 o7 ibias vss vss sky130_fd_pr__nfet_01v8 L=0.5u W=1u
M14540 o7 ibias vss vss sky130_fd_pr__nfet_01v8 L=0.5u W=1u
M14541 o7 ibias vss vss sky130_fd_pr__nfet_01v8 L=0.5u W=1u
M14542 o7 ibias vss vss sky130_fd_pr__nfet_01v8 L=0.5u W=1u
M14543 o7 ibias vss vss sky130_fd_pr__nfet_01v8 L=0.5u W=1u
M14544 o7 ibias vss vss sky130_fd_pr__nfet_01v8 L=0.5u W=1u
M14545 o7 ibias vss vss sky130_fd_pr__nfet_01v8 L=0.5u W=1u
M14546 o7 ibias vss vss sky130_fd_pr__nfet_01v8 L=0.5u W=1u
M14547 o7 ibias vss vss sky130_fd_pr__nfet_01v8 L=0.5u W=1u
M14548 o7 ibias vss vss sky130_fd_pr__nfet_01v8 L=0.5u W=1u
M14549 o7 ibias vss vss sky130_fd_pr__nfet_01v8 L=0.5u W=1u
M14550 o7 ibias vss vss sky130_fd_pr__nfet_01v8 L=0.5u W=1u
M14551 o7 ibias vss vss sky130_fd_pr__nfet_01v8 L=0.5u W=1u
M14552 o7 ibias vss vss sky130_fd_pr__nfet_01v8 L=0.5u W=1u
M14553 o7 ibias vss vss sky130_fd_pr__nfet_01v8 L=0.5u W=1u
M14554 o7 ibias vss vss sky130_fd_pr__nfet_01v8 L=0.5u W=1u
M14555 o7 ibias vss vss sky130_fd_pr__nfet_01v8 L=0.5u W=1u
M14556 o7 ibias vss vss sky130_fd_pr__nfet_01v8 L=0.5u W=1u
M14557 o7 ibias vss vss sky130_fd_pr__nfet_01v8 L=0.5u W=1u
M14558 o7 ibias vss vss sky130_fd_pr__nfet_01v8 L=0.5u W=1u
M14559 o7 ibias vss vss sky130_fd_pr__nfet_01v8 L=0.5u W=1u
M14560 o7 ibias vss vss sky130_fd_pr__nfet_01v8 L=0.5u W=1u
M14561 o7 ibias vss vss sky130_fd_pr__nfet_01v8 L=0.5u W=1u
M14562 o7 ibias vss vss sky130_fd_pr__nfet_01v8 L=0.5u W=1u
M14563 o7 ibias vss vss sky130_fd_pr__nfet_01v8 L=0.5u W=1u
M14564 o7 ibias vss vss sky130_fd_pr__nfet_01v8 L=0.5u W=1u
M14565 o7 ibias vss vss sky130_fd_pr__nfet_01v8 L=0.5u W=1u
M14566 o7 ibias vss vss sky130_fd_pr__nfet_01v8 L=0.5u W=1u
M14567 o7 ibias vss vss sky130_fd_pr__nfet_01v8 L=0.5u W=1u
M14568 o7 ibias vss vss sky130_fd_pr__nfet_01v8 L=0.5u W=1u
M14569 o7 ibias vss vss sky130_fd_pr__nfet_01v8 L=0.5u W=1u
M14570 o7 ibias vss vss sky130_fd_pr__nfet_01v8 L=0.5u W=1u
M14571 o7 ibias vss vss sky130_fd_pr__nfet_01v8 L=0.5u W=1u
M14572 o7 ibias vss vss sky130_fd_pr__nfet_01v8 L=0.5u W=1u
M14573 o7 ibias vss vss sky130_fd_pr__nfet_01v8 L=0.5u W=1u
M14574 o7 ibias vss vss sky130_fd_pr__nfet_01v8 L=0.5u W=1u
M14575 o7 ibias vss vss sky130_fd_pr__nfet_01v8 L=0.5u W=1u
M14576 o7 ibias vss vss sky130_fd_pr__nfet_01v8 L=0.5u W=1u
M14577 o7 ibias vss vss sky130_fd_pr__nfet_01v8 L=0.5u W=1u
M14578 o7 ibias vss vss sky130_fd_pr__nfet_01v8 L=0.5u W=1u
M14579 o7 ibias vss vss sky130_fd_pr__nfet_01v8 L=0.5u W=1u
M14580 o7 ibias vss vss sky130_fd_pr__nfet_01v8 L=0.5u W=1u
M14581 o7 ibias vss vss sky130_fd_pr__nfet_01v8 L=0.5u W=1u
M14582 o7 ibias vss vss sky130_fd_pr__nfet_01v8 L=0.5u W=1u
M14583 o7 ibias vss vss sky130_fd_pr__nfet_01v8 L=0.5u W=1u
M14584 o7 ibias vss vss sky130_fd_pr__nfet_01v8 L=0.5u W=1u
M14585 o7 ibias vss vss sky130_fd_pr__nfet_01v8 L=0.5u W=1u
M14586 o7 ibias vss vss sky130_fd_pr__nfet_01v8 L=0.5u W=1u
M14587 o7 ibias vss vss sky130_fd_pr__nfet_01v8 L=0.5u W=1u
M14588 o7 ibias vss vss sky130_fd_pr__nfet_01v8 L=0.5u W=1u
M14589 o7 ibias vss vss sky130_fd_pr__nfet_01v8 L=0.5u W=1u
M14590 o7 ibias vss vss sky130_fd_pr__nfet_01v8 L=0.5u W=1u
M14591 o7 ibias vss vss sky130_fd_pr__nfet_01v8 L=0.5u W=1u
M14592 o7 ibias vss vss sky130_fd_pr__nfet_01v8 L=0.5u W=1u
M14593 o7 ibias vss vss sky130_fd_pr__nfet_01v8 L=0.5u W=1u
M14594 o7 ibias vss vss sky130_fd_pr__nfet_01v8 L=0.5u W=1u
M14595 o7 ibias vss vss sky130_fd_pr__nfet_01v8 L=0.5u W=1u
M14596 o7 ibias vss vss sky130_fd_pr__nfet_01v8 L=0.5u W=1u
M14597 o7 ibias vss vss sky130_fd_pr__nfet_01v8 L=0.5u W=1u
M14598 o7 ibias vss vss sky130_fd_pr__nfet_01v8 L=0.5u W=1u
M14599 o7 ibias vss vss sky130_fd_pr__nfet_01v8 L=0.5u W=1u
M14600 o7 ibias vss vss sky130_fd_pr__nfet_01v8 L=0.5u W=1u
M14601 o7 ibias vss vss sky130_fd_pr__nfet_01v8 L=0.5u W=1u
M14602 o7 ibias vss vss sky130_fd_pr__nfet_01v8 L=0.5u W=1u
M14603 o7 ibias vss vss sky130_fd_pr__nfet_01v8 L=0.5u W=1u
M14604 o7 ibias vss vss sky130_fd_pr__nfet_01v8 L=0.5u W=1u
M14605 o7 ibias vss vss sky130_fd_pr__nfet_01v8 L=0.5u W=1u
M14606 o7 ibias vss vss sky130_fd_pr__nfet_01v8 L=0.5u W=1u
M14607 o7 ibias vss vss sky130_fd_pr__nfet_01v8 L=0.5u W=1u
M14608 o7 ibias vss vss sky130_fd_pr__nfet_01v8 L=0.5u W=1u
M14609 o7 ibias vss vss sky130_fd_pr__nfet_01v8 L=0.5u W=1u
M14610 o7 ibias vss vss sky130_fd_pr__nfet_01v8 L=0.5u W=1u
M14611 o7 ibias vss vss sky130_fd_pr__nfet_01v8 L=0.5u W=1u
M14612 o7 ibias vss vss sky130_fd_pr__nfet_01v8 L=0.5u W=1u
M14613 o7 ibias vss vss sky130_fd_pr__nfet_01v8 L=0.5u W=1u
M14614 o7 ibias vss vss sky130_fd_pr__nfet_01v8 L=0.5u W=1u
M14615 o7 ibias vss vss sky130_fd_pr__nfet_01v8 L=0.5u W=1u
M14616 o7 ibias vss vss sky130_fd_pr__nfet_01v8 L=0.5u W=1u
M14617 o7 ibias vss vss sky130_fd_pr__nfet_01v8 L=0.5u W=1u
M14618 o7 ibias vss vss sky130_fd_pr__nfet_01v8 L=0.5u W=1u
M14619 o7 ibias vss vss sky130_fd_pr__nfet_01v8 L=0.5u W=1u
M14620 o7 ibias vss vss sky130_fd_pr__nfet_01v8 L=0.5u W=1u
M14621 o7 ibias vss vss sky130_fd_pr__nfet_01v8 L=0.5u W=1u
M14622 o7 ibias vss vss sky130_fd_pr__nfet_01v8 L=0.5u W=1u
M14623 o7 ibias vss vss sky130_fd_pr__nfet_01v8 L=0.5u W=1u
M14624 o7 ibias vss vss sky130_fd_pr__nfet_01v8 L=0.5u W=1u
M14625 o7 ibias vss vss sky130_fd_pr__nfet_01v8 L=0.5u W=1u
M14626 o7 ibias vss vss sky130_fd_pr__nfet_01v8 L=0.5u W=1u
M14627 o7 ibias vss vss sky130_fd_pr__nfet_01v8 L=0.5u W=1u
M14628 o7 ibias vss vss sky130_fd_pr__nfet_01v8 L=0.5u W=1u
M14629 o7 ibias vss vss sky130_fd_pr__nfet_01v8 L=0.5u W=1u
M14630 o7 ibias vss vss sky130_fd_pr__nfet_01v8 L=0.5u W=1u
M14631 o7 ibias vss vss sky130_fd_pr__nfet_01v8 L=0.5u W=1u
M14632 o7 ibias vss vss sky130_fd_pr__nfet_01v8 L=0.5u W=1u
M14633 o7 ibias vss vss sky130_fd_pr__nfet_01v8 L=0.5u W=1u
M14634 o7 ibias vss vss sky130_fd_pr__nfet_01v8 L=0.5u W=1u
M14635 o7 ibias vss vss sky130_fd_pr__nfet_01v8 L=0.5u W=1u
M14636 o7 ibias vss vss sky130_fd_pr__nfet_01v8 L=0.5u W=1u
M14637 o7 ibias vss vss sky130_fd_pr__nfet_01v8 L=0.5u W=1u
M14638 o7 ibias vss vss sky130_fd_pr__nfet_01v8 L=0.5u W=1u
M14639 o7 ibias vss vss sky130_fd_pr__nfet_01v8 L=0.5u W=1u
M14640 o7 ibias vss vss sky130_fd_pr__nfet_01v8 L=0.5u W=1u
M14641 o7 ibias vss vss sky130_fd_pr__nfet_01v8 L=0.5u W=1u
M14642 o7 ibias vss vss sky130_fd_pr__nfet_01v8 L=0.5u W=1u
M14643 o7 ibias vss vss sky130_fd_pr__nfet_01v8 L=0.5u W=1u
M14644 o7 ibias vss vss sky130_fd_pr__nfet_01v8 L=0.5u W=1u
M14645 o7 ibias vss vss sky130_fd_pr__nfet_01v8 L=0.5u W=1u
M14646 o7 ibias vss vss sky130_fd_pr__nfet_01v8 L=0.5u W=1u
M14647 o7 ibias vss vss sky130_fd_pr__nfet_01v8 L=0.5u W=1u
M14648 o7 ibias vss vss sky130_fd_pr__nfet_01v8 L=0.5u W=1u
M14649 o7 ibias vss vss sky130_fd_pr__nfet_01v8 L=0.5u W=1u
M14650 o7 ibias vss vss sky130_fd_pr__nfet_01v8 L=0.5u W=1u
M14651 o7 ibias vss vss sky130_fd_pr__nfet_01v8 L=0.5u W=1u
M14652 o7 ibias vss vss sky130_fd_pr__nfet_01v8 L=0.5u W=1u
M14653 o7 ibias vss vss sky130_fd_pr__nfet_01v8 L=0.5u W=1u
M14654 o7 ibias vss vss sky130_fd_pr__nfet_01v8 L=0.5u W=1u
M14655 o7 ibias vss vss sky130_fd_pr__nfet_01v8 L=0.5u W=1u
M14656 o7 ibias vss vss sky130_fd_pr__nfet_01v8 L=0.5u W=1u
M14657 o7 ibias vss vss sky130_fd_pr__nfet_01v8 L=0.5u W=1u
M14658 o7 ibias vss vss sky130_fd_pr__nfet_01v8 L=0.5u W=1u
M14659 o7 ibias vss vss sky130_fd_pr__nfet_01v8 L=0.5u W=1u
M14660 o7 ibias vss vss sky130_fd_pr__nfet_01v8 L=0.5u W=1u
M14661 o7 ibias vss vss sky130_fd_pr__nfet_01v8 L=0.5u W=1u
M14662 o7 ibias vss vss sky130_fd_pr__nfet_01v8 L=0.5u W=1u
M14663 o7 ibias vss vss sky130_fd_pr__nfet_01v8 L=0.5u W=1u
M14664 o7 ibias vss vss sky130_fd_pr__nfet_01v8 L=0.5u W=1u
M14665 o7 ibias vss vss sky130_fd_pr__nfet_01v8 L=0.5u W=1u
M14666 o7 ibias vss vss sky130_fd_pr__nfet_01v8 L=0.5u W=1u
M14667 o7 ibias vss vss sky130_fd_pr__nfet_01v8 L=0.5u W=1u
M14668 o7 ibias vss vss sky130_fd_pr__nfet_01v8 L=0.5u W=1u
M14669 o7 ibias vss vss sky130_fd_pr__nfet_01v8 L=0.5u W=1u
M14670 o7 ibias vss vss sky130_fd_pr__nfet_01v8 L=0.5u W=1u
M14671 o7 ibias vss vss sky130_fd_pr__nfet_01v8 L=0.5u W=1u
M14672 o7 ibias vss vss sky130_fd_pr__nfet_01v8 L=0.5u W=1u
M14673 o7 ibias vss vss sky130_fd_pr__nfet_01v8 L=0.5u W=1u
M14674 o7 ibias vss vss sky130_fd_pr__nfet_01v8 L=0.5u W=1u
M14675 o7 ibias vss vss sky130_fd_pr__nfet_01v8 L=0.5u W=1u
M14676 o7 ibias vss vss sky130_fd_pr__nfet_01v8 L=0.5u W=1u
M14677 o7 ibias vss vss sky130_fd_pr__nfet_01v8 L=0.5u W=1u
M14678 o7 ibias vss vss sky130_fd_pr__nfet_01v8 L=0.5u W=1u
M14679 o7 ibias vss vss sky130_fd_pr__nfet_01v8 L=0.5u W=1u
M14680 o7 ibias vss vss sky130_fd_pr__nfet_01v8 L=0.5u W=1u
M14681 o7 ibias vss vss sky130_fd_pr__nfet_01v8 L=0.5u W=1u
M14682 o7 ibias vss vss sky130_fd_pr__nfet_01v8 L=0.5u W=1u
M14683 o7 ibias vss vss sky130_fd_pr__nfet_01v8 L=0.5u W=1u
M14684 o7 ibias vss vss sky130_fd_pr__nfet_01v8 L=0.5u W=1u
M14685 o7 ibias vss vss sky130_fd_pr__nfet_01v8 L=0.5u W=1u
M14686 o7 ibias vss vss sky130_fd_pr__nfet_01v8 L=0.5u W=1u
M14687 o7 ibias vss vss sky130_fd_pr__nfet_01v8 L=0.5u W=1u
M14688 o7 ibias vss vss sky130_fd_pr__nfet_01v8 L=0.5u W=1u
M14689 o7 ibias vss vss sky130_fd_pr__nfet_01v8 L=0.5u W=1u
M14690 o7 ibias vss vss sky130_fd_pr__nfet_01v8 L=0.5u W=1u
M14691 o7 ibias vss vss sky130_fd_pr__nfet_01v8 L=0.5u W=1u
M14692 o7 ibias vss vss sky130_fd_pr__nfet_01v8 L=0.5u W=1u
M14693 o7 ibias vss vss sky130_fd_pr__nfet_01v8 L=0.5u W=1u
M14694 o7 ibias vss vss sky130_fd_pr__nfet_01v8 L=0.5u W=1u
M14695 o7 ibias vss vss sky130_fd_pr__nfet_01v8 L=0.5u W=1u
M14696 o7 ibias vss vss sky130_fd_pr__nfet_01v8 L=0.5u W=1u
M14697 o7 ibias vss vss sky130_fd_pr__nfet_01v8 L=0.5u W=1u
M14698 o7 ibias vss vss sky130_fd_pr__nfet_01v8 L=0.5u W=1u
M14699 o7 ibias vss vss sky130_fd_pr__nfet_01v8 L=0.5u W=1u
M14700 o7 ibias vss vss sky130_fd_pr__nfet_01v8 L=0.5u W=1u
M14701 o7 ibias vss vss sky130_fd_pr__nfet_01v8 L=0.5u W=1u
M14702 o7 ibias vss vss sky130_fd_pr__nfet_01v8 L=0.5u W=1u
M14703 o7 ibias vss vss sky130_fd_pr__nfet_01v8 L=0.5u W=1u
M14704 o7 ibias vss vss sky130_fd_pr__nfet_01v8 L=0.5u W=1u
M14705 o7 ibias vss vss sky130_fd_pr__nfet_01v8 L=0.5u W=1u
M14706 o7 ibias vss vss sky130_fd_pr__nfet_01v8 L=0.5u W=1u
M14707 o7 ibias vss vss sky130_fd_pr__nfet_01v8 L=0.5u W=1u
M14708 o7 ibias vss vss sky130_fd_pr__nfet_01v8 L=0.5u W=1u
M14709 o7 ibias vss vss sky130_fd_pr__nfet_01v8 L=0.5u W=1u
M14710 o7 ibias vss vss sky130_fd_pr__nfet_01v8 L=0.5u W=1u
M14711 o7 ibias vss vss sky130_fd_pr__nfet_01v8 L=0.5u W=1u
M14712 o7 ibias vss vss sky130_fd_pr__nfet_01v8 L=0.5u W=1u
M14713 o7 ibias vss vss sky130_fd_pr__nfet_01v8 L=0.5u W=1u
M14714 o7 ibias vss vss sky130_fd_pr__nfet_01v8 L=0.5u W=1u
M14715 o7 ibias vss vss sky130_fd_pr__nfet_01v8 L=0.5u W=1u
M14716 o7 ibias vss vss sky130_fd_pr__nfet_01v8 L=0.5u W=1u
M14717 o7 ibias vss vss sky130_fd_pr__nfet_01v8 L=0.5u W=1u
M14718 o7 ibias vss vss sky130_fd_pr__nfet_01v8 L=0.5u W=1u
M14719 o7 ibias vss vss sky130_fd_pr__nfet_01v8 L=0.5u W=1u
M14720 o7 ibias vss vss sky130_fd_pr__nfet_01v8 L=0.5u W=1u
M14721 o7 ibias vss vss sky130_fd_pr__nfet_01v8 L=0.5u W=1u
M14722 o7 ibias vss vss sky130_fd_pr__nfet_01v8 L=0.5u W=1u
M14723 o7 ibias vss vss sky130_fd_pr__nfet_01v8 L=0.5u W=1u
M14724 o7 ibias vss vss sky130_fd_pr__nfet_01v8 L=0.5u W=1u
M14725 o7 ibias vss vss sky130_fd_pr__nfet_01v8 L=0.5u W=1u
M14726 o7 ibias vss vss sky130_fd_pr__nfet_01v8 L=0.5u W=1u
M14727 o7 ibias vss vss sky130_fd_pr__nfet_01v8 L=0.5u W=1u
M14728 o7 ibias vss vss sky130_fd_pr__nfet_01v8 L=0.5u W=1u
M14729 o7 ibias vss vss sky130_fd_pr__nfet_01v8 L=0.5u W=1u
M14730 o7 ibias vss vss sky130_fd_pr__nfet_01v8 L=0.5u W=1u
M14731 o7 ibias vss vss sky130_fd_pr__nfet_01v8 L=0.5u W=1u
M14732 o7 ibias vss vss sky130_fd_pr__nfet_01v8 L=0.5u W=1u
M14733 o7 ibias vss vss sky130_fd_pr__nfet_01v8 L=0.5u W=1u
M14734 o7 ibias vss vss sky130_fd_pr__nfet_01v8 L=0.5u W=1u
M14735 o7 ibias vss vss sky130_fd_pr__nfet_01v8 L=0.5u W=1u
M14736 o7 ibias vss vss sky130_fd_pr__nfet_01v8 L=0.5u W=1u
M14737 o7 ibias vss vss sky130_fd_pr__nfet_01v8 L=0.5u W=1u
M14738 o7 ibias vss vss sky130_fd_pr__nfet_01v8 L=0.5u W=1u
M14739 o7 ibias vss vss sky130_fd_pr__nfet_01v8 L=0.5u W=1u
M14740 o7 ibias vss vss sky130_fd_pr__nfet_01v8 L=0.5u W=1u
M14741 o7 ibias vss vss sky130_fd_pr__nfet_01v8 L=0.5u W=1u
M14742 o7 ibias vss vss sky130_fd_pr__nfet_01v8 L=0.5u W=1u
M14743 o7 ibias vss vss sky130_fd_pr__nfet_01v8 L=0.5u W=1u
M14744 o7 ibias vss vss sky130_fd_pr__nfet_01v8 L=0.5u W=1u
M14745 o7 ibias vss vss sky130_fd_pr__nfet_01v8 L=0.5u W=1u
M14746 o7 ibias vss vss sky130_fd_pr__nfet_01v8 L=0.5u W=1u
M14747 o7 ibias vss vss sky130_fd_pr__nfet_01v8 L=0.5u W=1u
M14748 o7 ibias vss vss sky130_fd_pr__nfet_01v8 L=0.5u W=1u
M14749 o7 ibias vss vss sky130_fd_pr__nfet_01v8 L=0.5u W=1u
M14750 o7 ibias vss vss sky130_fd_pr__nfet_01v8 L=0.5u W=1u
M14751 o7 ibias vss vss sky130_fd_pr__nfet_01v8 L=0.5u W=1u
M14752 o7 ibias vss vss sky130_fd_pr__nfet_01v8 L=0.5u W=1u
M14753 o7 ibias vss vss sky130_fd_pr__nfet_01v8 L=0.5u W=1u
M14754 o7 ibias vss vss sky130_fd_pr__nfet_01v8 L=0.5u W=1u
M14755 o7 ibias vss vss sky130_fd_pr__nfet_01v8 L=0.5u W=1u
M14756 o7 ibias vss vss sky130_fd_pr__nfet_01v8 L=0.5u W=1u
M14757 o7 ibias vss vss sky130_fd_pr__nfet_01v8 L=0.5u W=1u
M14758 o7 ibias vss vss sky130_fd_pr__nfet_01v8 L=0.5u W=1u
M14759 o7 ibias vss vss sky130_fd_pr__nfet_01v8 L=0.5u W=1u
M14760 o7 ibias vss vss sky130_fd_pr__nfet_01v8 L=0.5u W=1u
M14761 o7 ibias vss vss sky130_fd_pr__nfet_01v8 L=0.5u W=1u
M14762 o7 ibias vss vss sky130_fd_pr__nfet_01v8 L=0.5u W=1u
M14763 o7 ibias vss vss sky130_fd_pr__nfet_01v8 L=0.5u W=1u
M14764 o7 ibias vss vss sky130_fd_pr__nfet_01v8 L=0.5u W=1u
M14765 o7 ibias vss vss sky130_fd_pr__nfet_01v8 L=0.5u W=1u
M14766 o7 ibias vss vss sky130_fd_pr__nfet_01v8 L=0.5u W=1u
M14767 o7 ibias vss vss sky130_fd_pr__nfet_01v8 L=0.5u W=1u
M14768 o7 ibias vss vss sky130_fd_pr__nfet_01v8 L=0.5u W=1u
M14769 o7 ibias vss vss sky130_fd_pr__nfet_01v8 L=0.5u W=1u
M14770 o7 ibias vss vss sky130_fd_pr__nfet_01v8 L=0.5u W=1u
M14771 o7 ibias vss vss sky130_fd_pr__nfet_01v8 L=0.5u W=1u
M14772 o7 ibias vss vss sky130_fd_pr__nfet_01v8 L=0.5u W=1u
M14773 o7 ibias vss vss sky130_fd_pr__nfet_01v8 L=0.5u W=1u
M14774 o7 ibias vss vss sky130_fd_pr__nfet_01v8 L=0.5u W=1u
M14775 o7 ibias vss vss sky130_fd_pr__nfet_01v8 L=0.5u W=1u
M14776 o7 ibias vss vss sky130_fd_pr__nfet_01v8 L=0.5u W=1u
M14777 o7 ibias vss vss sky130_fd_pr__nfet_01v8 L=0.5u W=1u
M14778 o7 ibias vss vss sky130_fd_pr__nfet_01v8 L=0.5u W=1u
M14779 o7 ibias vss vss sky130_fd_pr__nfet_01v8 L=0.5u W=1u
M14780 o7 ibias vss vss sky130_fd_pr__nfet_01v8 L=0.5u W=1u
M14781 o7 ibias vss vss sky130_fd_pr__nfet_01v8 L=0.5u W=1u
M14782 o7 ibias vss vss sky130_fd_pr__nfet_01v8 L=0.5u W=1u
M14783 o7 ibias vss vss sky130_fd_pr__nfet_01v8 L=0.5u W=1u
M14784 o7 ibias vss vss sky130_fd_pr__nfet_01v8 L=0.5u W=1u
M14785 o7 ibias vss vss sky130_fd_pr__nfet_01v8 L=0.5u W=1u
M14786 o7 ibias vss vss sky130_fd_pr__nfet_01v8 L=0.5u W=1u
M14787 o7 ibias vss vss sky130_fd_pr__nfet_01v8 L=0.5u W=1u
M14788 o7 ibias vss vss sky130_fd_pr__nfet_01v8 L=0.5u W=1u
M14789 o7 ibias vss vss sky130_fd_pr__nfet_01v8 L=0.5u W=1u
M14790 o7 ibias vss vss sky130_fd_pr__nfet_01v8 L=0.5u W=1u
M14791 o7 ibias vss vss sky130_fd_pr__nfet_01v8 L=0.5u W=1u
M14792 o7 ibias vss vss sky130_fd_pr__nfet_01v8 L=0.5u W=1u
M14793 o7 ibias vss vss sky130_fd_pr__nfet_01v8 L=0.5u W=1u
M14794 o7 ibias vss vss sky130_fd_pr__nfet_01v8 L=0.5u W=1u
M14795 o7 ibias vss vss sky130_fd_pr__nfet_01v8 L=0.5u W=1u
M14796 o7 ibias vss vss sky130_fd_pr__nfet_01v8 L=0.5u W=1u
M14797 o7 ibias vss vss sky130_fd_pr__nfet_01v8 L=0.5u W=1u
M14798 o7 ibias vss vss sky130_fd_pr__nfet_01v8 L=0.5u W=1u
M14799 o7 ibias vss vss sky130_fd_pr__nfet_01v8 L=0.5u W=1u
M14800 o7 ibias vss vss sky130_fd_pr__nfet_01v8 L=0.5u W=1u
M14801 o7 ibias vss vss sky130_fd_pr__nfet_01v8 L=0.5u W=1u
M14802 o7 ibias vss vss sky130_fd_pr__nfet_01v8 L=0.5u W=1u
M14803 o7 ibias vss vss sky130_fd_pr__nfet_01v8 L=0.5u W=1u
M14804 o7 ibias vss vss sky130_fd_pr__nfet_01v8 L=0.5u W=1u
M14805 o7 ibias vss vss sky130_fd_pr__nfet_01v8 L=0.5u W=1u
M14806 o7 ibias vss vss sky130_fd_pr__nfet_01v8 L=0.5u W=1u
M14807 o7 ibias vss vss sky130_fd_pr__nfet_01v8 L=0.5u W=1u
M14808 o7 ibias vss vss sky130_fd_pr__nfet_01v8 L=0.5u W=1u
M14809 o7 ibias vss vss sky130_fd_pr__nfet_01v8 L=0.5u W=1u
M14810 o7 ibias vss vss sky130_fd_pr__nfet_01v8 L=0.5u W=1u
M14811 o7 ibias vss vss sky130_fd_pr__nfet_01v8 L=0.5u W=1u
M14812 o7 ibias vss vss sky130_fd_pr__nfet_01v8 L=0.5u W=1u
M14813 o7 ibias vss vss sky130_fd_pr__nfet_01v8 L=0.5u W=1u
M14814 o7 ibias vss vss sky130_fd_pr__nfet_01v8 L=0.5u W=1u
M14815 o7 ibias vss vss sky130_fd_pr__nfet_01v8 L=0.5u W=1u
M14816 o7 ibias vss vss sky130_fd_pr__nfet_01v8 L=0.5u W=1u
M14817 o7 ibias vss vss sky130_fd_pr__nfet_01v8 L=0.5u W=1u
M14818 o7 ibias vss vss sky130_fd_pr__nfet_01v8 L=0.5u W=1u
M14819 o7 ibias vss vss sky130_fd_pr__nfet_01v8 L=0.5u W=1u
M14820 o7 ibias vss vss sky130_fd_pr__nfet_01v8 L=0.5u W=1u
M14821 o7 ibias vss vss sky130_fd_pr__nfet_01v8 L=0.5u W=1u
M14822 o7 ibias vss vss sky130_fd_pr__nfet_01v8 L=0.5u W=1u
M14823 o7 ibias vss vss sky130_fd_pr__nfet_01v8 L=0.5u W=1u
M14824 o7 ibias vss vss sky130_fd_pr__nfet_01v8 L=0.5u W=1u
M14825 o7 ibias vss vss sky130_fd_pr__nfet_01v8 L=0.5u W=1u
M14826 o7 ibias vss vss sky130_fd_pr__nfet_01v8 L=0.5u W=1u
M14827 o7 ibias vss vss sky130_fd_pr__nfet_01v8 L=0.5u W=1u
M14828 o7 ibias vss vss sky130_fd_pr__nfet_01v8 L=0.5u W=1u
M14829 o7 ibias vss vss sky130_fd_pr__nfet_01v8 L=0.5u W=1u
M14830 o7 ibias vss vss sky130_fd_pr__nfet_01v8 L=0.5u W=1u
M14831 o7 ibias vss vss sky130_fd_pr__nfet_01v8 L=0.5u W=1u
M14832 o7 ibias vss vss sky130_fd_pr__nfet_01v8 L=0.5u W=1u
M14833 o7 ibias vss vss sky130_fd_pr__nfet_01v8 L=0.5u W=1u
M14834 o7 ibias vss vss sky130_fd_pr__nfet_01v8 L=0.5u W=1u
M14835 o7 ibias vss vss sky130_fd_pr__nfet_01v8 L=0.5u W=1u
M14836 o7 ibias vss vss sky130_fd_pr__nfet_01v8 L=0.5u W=1u
M14837 o7 ibias vss vss sky130_fd_pr__nfet_01v8 L=0.5u W=1u
M14838 o7 ibias vss vss sky130_fd_pr__nfet_01v8 L=0.5u W=1u
M14839 o7 ibias vss vss sky130_fd_pr__nfet_01v8 L=0.5u W=1u
M14840 o7 ibias vss vss sky130_fd_pr__nfet_01v8 L=0.5u W=1u
M14841 o7 ibias vss vss sky130_fd_pr__nfet_01v8 L=0.5u W=1u
M14842 o7 ibias vss vss sky130_fd_pr__nfet_01v8 L=0.5u W=1u
M14843 o7 ibias vss vss sky130_fd_pr__nfet_01v8 L=0.5u W=1u
M14844 o7 ibias vss vss sky130_fd_pr__nfet_01v8 L=0.5u W=1u
M14845 o7 ibias vss vss sky130_fd_pr__nfet_01v8 L=0.5u W=1u
M14846 o7 ibias vss vss sky130_fd_pr__nfet_01v8 L=0.5u W=1u
M14847 o7 ibias vss vss sky130_fd_pr__nfet_01v8 L=0.5u W=1u
M14848 o7 ibias vss vss sky130_fd_pr__nfet_01v8 L=0.5u W=1u
M14849 o7 ibias vss vss sky130_fd_pr__nfet_01v8 L=0.5u W=1u
M14850 o7 ibias vss vss sky130_fd_pr__nfet_01v8 L=0.5u W=1u
M14851 o7 ibias vss vss sky130_fd_pr__nfet_01v8 L=0.5u W=1u
M14852 o7 ibias vss vss sky130_fd_pr__nfet_01v8 L=0.5u W=1u
M14853 o7 ibias vss vss sky130_fd_pr__nfet_01v8 L=0.5u W=1u
M14854 o7 ibias vss vss sky130_fd_pr__nfet_01v8 L=0.5u W=1u
M14855 o7 ibias vss vss sky130_fd_pr__nfet_01v8 L=0.5u W=1u
M14856 o7 ibias vss vss sky130_fd_pr__nfet_01v8 L=0.5u W=1u
M14857 o7 ibias vss vss sky130_fd_pr__nfet_01v8 L=0.5u W=1u
M14858 o7 ibias vss vss sky130_fd_pr__nfet_01v8 L=0.5u W=1u
M14859 o7 ibias vss vss sky130_fd_pr__nfet_01v8 L=0.5u W=1u
M14860 o7 ibias vss vss sky130_fd_pr__nfet_01v8 L=0.5u W=1u
M14861 o7 ibias vss vss sky130_fd_pr__nfet_01v8 L=0.5u W=1u
M14862 o7 ibias vss vss sky130_fd_pr__nfet_01v8 L=0.5u W=1u
M14863 o7 ibias vss vss sky130_fd_pr__nfet_01v8 L=0.5u W=1u
M14864 o7 ibias vss vss sky130_fd_pr__nfet_01v8 L=0.5u W=1u
M14865 o7 ibias vss vss sky130_fd_pr__nfet_01v8 L=0.5u W=1u
M14866 o7 ibias vss vss sky130_fd_pr__nfet_01v8 L=0.5u W=1u
M14867 o7 ibias vss vss sky130_fd_pr__nfet_01v8 L=0.5u W=1u
M14868 o7 ibias vss vss sky130_fd_pr__nfet_01v8 L=0.5u W=1u
M14869 o7 ibias vss vss sky130_fd_pr__nfet_01v8 L=0.5u W=1u
M14870 o7 ibias vss vss sky130_fd_pr__nfet_01v8 L=0.5u W=1u
M14871 o7 ibias vss vss sky130_fd_pr__nfet_01v8 L=0.5u W=1u
M14872 o7 ibias vss vss sky130_fd_pr__nfet_01v8 L=0.5u W=1u
M14873 o7 ibias vss vss sky130_fd_pr__nfet_01v8 L=0.5u W=1u
M14874 o7 ibias vss vss sky130_fd_pr__nfet_01v8 L=0.5u W=1u
M14875 o7 ibias vss vss sky130_fd_pr__nfet_01v8 L=0.5u W=1u
M14876 o7 ibias vss vss sky130_fd_pr__nfet_01v8 L=0.5u W=1u
M14877 o7 ibias vss vss sky130_fd_pr__nfet_01v8 L=0.5u W=1u
M14878 o7 ibias vss vss sky130_fd_pr__nfet_01v8 L=0.5u W=1u
M14879 o7 ibias vss vss sky130_fd_pr__nfet_01v8 L=0.5u W=1u
M14880 o7 ibias vss vss sky130_fd_pr__nfet_01v8 L=0.5u W=1u
M14881 o7 ibias vss vss sky130_fd_pr__nfet_01v8 L=0.5u W=1u
M14882 o7 ibias vss vss sky130_fd_pr__nfet_01v8 L=0.5u W=1u
M14883 o7 ibias vss vss sky130_fd_pr__nfet_01v8 L=0.5u W=1u
M14884 o7 ibias vss vss sky130_fd_pr__nfet_01v8 L=0.5u W=1u
M14885 o7 ibias vss vss sky130_fd_pr__nfet_01v8 L=0.5u W=1u
M14886 o7 ibias vss vss sky130_fd_pr__nfet_01v8 L=0.5u W=1u
M14887 o7 ibias vss vss sky130_fd_pr__nfet_01v8 L=0.5u W=1u
M14888 o7 ibias vss vss sky130_fd_pr__nfet_01v8 L=0.5u W=1u
M14889 o7 ibias vss vss sky130_fd_pr__nfet_01v8 L=0.5u W=1u
M14890 o7 ibias vss vss sky130_fd_pr__nfet_01v8 L=0.5u W=1u
M14891 o7 ibias vss vss sky130_fd_pr__nfet_01v8 L=0.5u W=1u
M14892 o7 ibias vss vss sky130_fd_pr__nfet_01v8 L=0.5u W=1u
M14893 o7 ibias vss vss sky130_fd_pr__nfet_01v8 L=0.5u W=1u
M14894 o7 ibias vss vss sky130_fd_pr__nfet_01v8 L=0.5u W=1u
M14895 o7 ibias vss vss sky130_fd_pr__nfet_01v8 L=0.5u W=1u
M14896 o7 ibias vss vss sky130_fd_pr__nfet_01v8 L=0.5u W=1u
M14897 o7 ibias vss vss sky130_fd_pr__nfet_01v8 L=0.5u W=1u
M14898 o7 ibias vss vss sky130_fd_pr__nfet_01v8 L=0.5u W=1u
M14899 o7 ibias vss vss sky130_fd_pr__nfet_01v8 L=0.5u W=1u
M14900 o7 ibias vss vss sky130_fd_pr__nfet_01v8 L=0.5u W=1u
M14901 o7 ibias vss vss sky130_fd_pr__nfet_01v8 L=0.5u W=1u
M14902 o7 ibias vss vss sky130_fd_pr__nfet_01v8 L=0.5u W=1u
M14903 o7 ibias vss vss sky130_fd_pr__nfet_01v8 L=0.5u W=1u
M14904 o7 ibias vss vss sky130_fd_pr__nfet_01v8 L=0.5u W=1u
M14905 o7 ibias vss vss sky130_fd_pr__nfet_01v8 L=0.5u W=1u
M14906 o7 ibias vss vss sky130_fd_pr__nfet_01v8 L=0.5u W=1u
M14907 o7 ibias vss vss sky130_fd_pr__nfet_01v8 L=0.5u W=1u
M14908 o7 ibias vss vss sky130_fd_pr__nfet_01v8 L=0.5u W=1u
M14909 o7 ibias vss vss sky130_fd_pr__nfet_01v8 L=0.5u W=1u
M14910 o7 ibias vss vss sky130_fd_pr__nfet_01v8 L=0.5u W=1u
M14911 o7 ibias vss vss sky130_fd_pr__nfet_01v8 L=0.5u W=1u
M14912 o7 ibias vss vss sky130_fd_pr__nfet_01v8 L=0.5u W=1u
M14913 o7 ibias vss vss sky130_fd_pr__nfet_01v8 L=0.5u W=1u
M14914 o7 ibias vss vss sky130_fd_pr__nfet_01v8 L=0.5u W=1u
M14915 o7 ibias vss vss sky130_fd_pr__nfet_01v8 L=0.5u W=1u
M14916 o7 ibias vss vss sky130_fd_pr__nfet_01v8 L=0.5u W=1u
M14917 o7 ibias vss vss sky130_fd_pr__nfet_01v8 L=0.5u W=1u
M14918 o7 ibias vss vss sky130_fd_pr__nfet_01v8 L=0.5u W=1u
M14919 o7 ibias vss vss sky130_fd_pr__nfet_01v8 L=0.5u W=1u
M14920 o7 ibias vss vss sky130_fd_pr__nfet_01v8 L=0.5u W=1u
M14921 o7 ibias vss vss sky130_fd_pr__nfet_01v8 L=0.5u W=1u
M14922 o7 ibias vss vss sky130_fd_pr__nfet_01v8 L=0.5u W=1u
M14923 o7 ibias vss vss sky130_fd_pr__nfet_01v8 L=0.5u W=1u
M14924 o7 ibias vss vss sky130_fd_pr__nfet_01v8 L=0.5u W=1u
M14925 o7 ibias vss vss sky130_fd_pr__nfet_01v8 L=0.5u W=1u
M14926 o7 ibias vss vss sky130_fd_pr__nfet_01v8 L=0.5u W=1u
M14927 o7 ibias vss vss sky130_fd_pr__nfet_01v8 L=0.5u W=1u
M14928 o7 ibias vss vss sky130_fd_pr__nfet_01v8 L=0.5u W=1u
M14929 o7 ibias vss vss sky130_fd_pr__nfet_01v8 L=0.5u W=1u
M14930 o7 ibias vss vss sky130_fd_pr__nfet_01v8 L=0.5u W=1u
M14931 o7 ibias vss vss sky130_fd_pr__nfet_01v8 L=0.5u W=1u
M14932 o7 ibias vss vss sky130_fd_pr__nfet_01v8 L=0.5u W=1u
M14933 o7 ibias vss vss sky130_fd_pr__nfet_01v8 L=0.5u W=1u
M14934 o7 ibias vss vss sky130_fd_pr__nfet_01v8 L=0.5u W=1u
M14935 o7 ibias vss vss sky130_fd_pr__nfet_01v8 L=0.5u W=1u
M14936 o7 ibias vss vss sky130_fd_pr__nfet_01v8 L=0.5u W=1u
M14937 o7 ibias vss vss sky130_fd_pr__nfet_01v8 L=0.5u W=1u
M14938 o7 ibias vss vss sky130_fd_pr__nfet_01v8 L=0.5u W=1u
M14939 o7 ibias vss vss sky130_fd_pr__nfet_01v8 L=0.5u W=1u
M14940 o7 ibias vss vss sky130_fd_pr__nfet_01v8 L=0.5u W=1u
M14941 o7 ibias vss vss sky130_fd_pr__nfet_01v8 L=0.5u W=1u
M14942 o7 ibias vss vss sky130_fd_pr__nfet_01v8 L=0.5u W=1u
M14943 o7 ibias vss vss sky130_fd_pr__nfet_01v8 L=0.5u W=1u
M14944 o7 ibias vss vss sky130_fd_pr__nfet_01v8 L=0.5u W=1u
M14945 o7 ibias vss vss sky130_fd_pr__nfet_01v8 L=0.5u W=1u
M14946 o7 ibias vss vss sky130_fd_pr__nfet_01v8 L=0.5u W=1u
M14947 o7 ibias vss vss sky130_fd_pr__nfet_01v8 L=0.5u W=1u
M14948 o7 ibias vss vss sky130_fd_pr__nfet_01v8 L=0.5u W=1u
M14949 o7 ibias vss vss sky130_fd_pr__nfet_01v8 L=0.5u W=1u
M14950 o7 ibias vss vss sky130_fd_pr__nfet_01v8 L=0.5u W=1u
M14951 o7 ibias vss vss sky130_fd_pr__nfet_01v8 L=0.5u W=1u
M14952 o7 ibias vss vss sky130_fd_pr__nfet_01v8 L=0.5u W=1u
M14953 o7 ibias vss vss sky130_fd_pr__nfet_01v8 L=0.5u W=1u
M14954 o7 ibias vss vss sky130_fd_pr__nfet_01v8 L=0.5u W=1u
M14955 o7 ibias vss vss sky130_fd_pr__nfet_01v8 L=0.5u W=1u
M14956 o7 ibias vss vss sky130_fd_pr__nfet_01v8 L=0.5u W=1u
M14957 o7 ibias vss vss sky130_fd_pr__nfet_01v8 L=0.5u W=1u
M14958 o7 ibias vss vss sky130_fd_pr__nfet_01v8 L=0.5u W=1u
M14959 o7 ibias vss vss sky130_fd_pr__nfet_01v8 L=0.5u W=1u
M14960 o7 ibias vss vss sky130_fd_pr__nfet_01v8 L=0.5u W=1u
M14961 o7 ibias vss vss sky130_fd_pr__nfet_01v8 L=0.5u W=1u
M14962 o7 ibias vss vss sky130_fd_pr__nfet_01v8 L=0.5u W=1u
M14963 o7 ibias vss vss sky130_fd_pr__nfet_01v8 L=0.5u W=1u
M14964 o7 ibias vss vss sky130_fd_pr__nfet_01v8 L=0.5u W=1u
M14965 o7 ibias vss vss sky130_fd_pr__nfet_01v8 L=0.5u W=1u
M14966 o7 ibias vss vss sky130_fd_pr__nfet_01v8 L=0.5u W=1u
M14967 o7 ibias vss vss sky130_fd_pr__nfet_01v8 L=0.5u W=1u
M14968 o7 ibias vss vss sky130_fd_pr__nfet_01v8 L=0.5u W=1u
M14969 o7 ibias vss vss sky130_fd_pr__nfet_01v8 L=0.5u W=1u
M14970 o7 ibias vss vss sky130_fd_pr__nfet_01v8 L=0.5u W=1u
M14971 o7 ibias vss vss sky130_fd_pr__nfet_01v8 L=0.5u W=1u
M14972 o7 ibias vss vss sky130_fd_pr__nfet_01v8 L=0.5u W=1u
M14973 o7 ibias vss vss sky130_fd_pr__nfet_01v8 L=0.5u W=1u
M14974 o7 ibias vss vss sky130_fd_pr__nfet_01v8 L=0.5u W=1u
M14975 o7 ibias vss vss sky130_fd_pr__nfet_01v8 L=0.5u W=1u
M14976 o7 ibias vss vss sky130_fd_pr__nfet_01v8 L=0.5u W=1u
M14977 o7 ibias vss vss sky130_fd_pr__nfet_01v8 L=0.5u W=1u
M14978 o7 ibias vss vss sky130_fd_pr__nfet_01v8 L=0.5u W=1u
M14979 o7 ibias vss vss sky130_fd_pr__nfet_01v8 L=0.5u W=1u
M14980 o7 ibias vss vss sky130_fd_pr__nfet_01v8 L=0.5u W=1u
M14981 o7 ibias vss vss sky130_fd_pr__nfet_01v8 L=0.5u W=1u
M14982 o7 ibias vss vss sky130_fd_pr__nfet_01v8 L=0.5u W=1u
M14983 o7 ibias vss vss sky130_fd_pr__nfet_01v8 L=0.5u W=1u
M14984 o7 ibias vss vss sky130_fd_pr__nfet_01v8 L=0.5u W=1u
M14985 o7 ibias vss vss sky130_fd_pr__nfet_01v8 L=0.5u W=1u
M14986 o7 ibias vss vss sky130_fd_pr__nfet_01v8 L=0.5u W=1u
M14987 o7 ibias vss vss sky130_fd_pr__nfet_01v8 L=0.5u W=1u
M14988 o7 ibias vss vss sky130_fd_pr__nfet_01v8 L=0.5u W=1u
M14989 o7 ibias vss vss sky130_fd_pr__nfet_01v8 L=0.5u W=1u
M14990 o7 ibias vss vss sky130_fd_pr__nfet_01v8 L=0.5u W=1u
M14991 o7 ibias vss vss sky130_fd_pr__nfet_01v8 L=0.5u W=1u
M14992 o7 ibias vss vss sky130_fd_pr__nfet_01v8 L=0.5u W=1u
M14993 o7 ibias vss vss sky130_fd_pr__nfet_01v8 L=0.5u W=1u
M14994 o7 ibias vss vss sky130_fd_pr__nfet_01v8 L=0.5u W=1u
M14995 o7 ibias vss vss sky130_fd_pr__nfet_01v8 L=0.5u W=1u
M14996 o7 ibias vss vss sky130_fd_pr__nfet_01v8 L=0.5u W=1u
M14997 o7 ibias vss vss sky130_fd_pr__nfet_01v8 L=0.5u W=1u
M14998 o7 ibias vss vss sky130_fd_pr__nfet_01v8 L=0.5u W=1u
M14999 o7 ibias vss vss sky130_fd_pr__nfet_01v8 L=0.5u W=1u
M15000 o7 ibias vss vss sky130_fd_pr__nfet_01v8 L=0.5u W=1u
M15001 o7 ibias vss vss sky130_fd_pr__nfet_01v8 L=0.5u W=1u
M15002 o7 ibias vss vss sky130_fd_pr__nfet_01v8 L=0.5u W=1u
M15003 o7 ibias vss vss sky130_fd_pr__nfet_01v8 L=0.5u W=1u
M15004 o7 ibias vss vss sky130_fd_pr__nfet_01v8 L=0.5u W=1u
M15005 o7 ibias vss vss sky130_fd_pr__nfet_01v8 L=0.5u W=1u
M15006 o7 ibias vss vss sky130_fd_pr__nfet_01v8 L=0.5u W=1u
M15007 o7 ibias vss vss sky130_fd_pr__nfet_01v8 L=0.5u W=1u
M15008 o7 ibias vss vss sky130_fd_pr__nfet_01v8 L=0.5u W=1u
M15009 o7 ibias vss vss sky130_fd_pr__nfet_01v8 L=0.5u W=1u
M15010 o7 ibias vss vss sky130_fd_pr__nfet_01v8 L=0.5u W=1u
M15011 o7 ibias vss vss sky130_fd_pr__nfet_01v8 L=0.5u W=1u
M15012 o7 ibias vss vss sky130_fd_pr__nfet_01v8 L=0.5u W=1u
M15013 o7 ibias vss vss sky130_fd_pr__nfet_01v8 L=0.5u W=1u
M15014 o7 ibias vss vss sky130_fd_pr__nfet_01v8 L=0.5u W=1u
M15015 o7 ibias vss vss sky130_fd_pr__nfet_01v8 L=0.5u W=1u
M15016 o7 ibias vss vss sky130_fd_pr__nfet_01v8 L=0.5u W=1u
M15017 o7 ibias vss vss sky130_fd_pr__nfet_01v8 L=0.5u W=1u
M15018 o7 ibias vss vss sky130_fd_pr__nfet_01v8 L=0.5u W=1u
M15019 o7 ibias vss vss sky130_fd_pr__nfet_01v8 L=0.5u W=1u
M15020 o7 ibias vss vss sky130_fd_pr__nfet_01v8 L=0.5u W=1u
M15021 o7 ibias vss vss sky130_fd_pr__nfet_01v8 L=0.5u W=1u
M15022 o7 ibias vss vss sky130_fd_pr__nfet_01v8 L=0.5u W=1u
M15023 o7 ibias vss vss sky130_fd_pr__nfet_01v8 L=0.5u W=1u
M15024 o7 ibias vss vss sky130_fd_pr__nfet_01v8 L=0.5u W=1u
M15025 o7 ibias vss vss sky130_fd_pr__nfet_01v8 L=0.5u W=1u
M15026 o7 ibias vss vss sky130_fd_pr__nfet_01v8 L=0.5u W=1u
M15027 o7 ibias vss vss sky130_fd_pr__nfet_01v8 L=0.5u W=1u
M15028 o7 ibias vss vss sky130_fd_pr__nfet_01v8 L=0.5u W=1u
M15029 o7 ibias vss vss sky130_fd_pr__nfet_01v8 L=0.5u W=1u
M15030 o7 ibias vss vss sky130_fd_pr__nfet_01v8 L=0.5u W=1u
M15031 o7 ibias vss vss sky130_fd_pr__nfet_01v8 L=0.5u W=1u
M15032 o7 ibias vss vss sky130_fd_pr__nfet_01v8 L=0.5u W=1u
M15033 o7 ibias vss vss sky130_fd_pr__nfet_01v8 L=0.5u W=1u
M15034 o7 ibias vss vss sky130_fd_pr__nfet_01v8 L=0.5u W=1u
M15035 o7 ibias vss vss sky130_fd_pr__nfet_01v8 L=0.5u W=1u
M15036 o7 ibias vss vss sky130_fd_pr__nfet_01v8 L=0.5u W=1u
M15037 o7 ibias vss vss sky130_fd_pr__nfet_01v8 L=0.5u W=1u
M15038 o7 ibias vss vss sky130_fd_pr__nfet_01v8 L=0.5u W=1u
M15039 o7 ibias vss vss sky130_fd_pr__nfet_01v8 L=0.5u W=1u
M15040 o7 ibias vss vss sky130_fd_pr__nfet_01v8 L=0.5u W=1u
M15041 o7 ibias vss vss sky130_fd_pr__nfet_01v8 L=0.5u W=1u
M15042 o7 ibias vss vss sky130_fd_pr__nfet_01v8 L=0.5u W=1u
M15043 o7 ibias vss vss sky130_fd_pr__nfet_01v8 L=0.5u W=1u
M15044 o7 ibias vss vss sky130_fd_pr__nfet_01v8 L=0.5u W=1u
M15045 o7 ibias vss vss sky130_fd_pr__nfet_01v8 L=0.5u W=1u
M15046 o7 ibias vss vss sky130_fd_pr__nfet_01v8 L=0.5u W=1u
M15047 o7 ibias vss vss sky130_fd_pr__nfet_01v8 L=0.5u W=1u
M15048 o7 ibias vss vss sky130_fd_pr__nfet_01v8 L=0.5u W=1u
M15049 o7 ibias vss vss sky130_fd_pr__nfet_01v8 L=0.5u W=1u
M15050 o7 ibias vss vss sky130_fd_pr__nfet_01v8 L=0.5u W=1u
M15051 o7 ibias vss vss sky130_fd_pr__nfet_01v8 L=0.5u W=1u
M15052 o7 ibias vss vss sky130_fd_pr__nfet_01v8 L=0.5u W=1u
M15053 o7 ibias vss vss sky130_fd_pr__nfet_01v8 L=0.5u W=1u
M15054 o7 ibias vss vss sky130_fd_pr__nfet_01v8 L=0.5u W=1u
M15055 o7 ibias vss vss sky130_fd_pr__nfet_01v8 L=0.5u W=1u
M15056 o7 ibias vss vss sky130_fd_pr__nfet_01v8 L=0.5u W=1u
M15057 o7 ibias vss vss sky130_fd_pr__nfet_01v8 L=0.5u W=1u
M15058 o7 ibias vss vss sky130_fd_pr__nfet_01v8 L=0.5u W=1u
M15059 o7 ibias vss vss sky130_fd_pr__nfet_01v8 L=0.5u W=1u
M15060 o7 ibias vss vss sky130_fd_pr__nfet_01v8 L=0.5u W=1u
M15061 o7 ibias vss vss sky130_fd_pr__nfet_01v8 L=0.5u W=1u
M15062 o7 ibias vss vss sky130_fd_pr__nfet_01v8 L=0.5u W=1u
M15063 o7 ibias vss vss sky130_fd_pr__nfet_01v8 L=0.5u W=1u
M15064 o7 ibias vss vss sky130_fd_pr__nfet_01v8 L=0.5u W=1u
M15065 o7 ibias vss vss sky130_fd_pr__nfet_01v8 L=0.5u W=1u
M15066 o7 ibias vss vss sky130_fd_pr__nfet_01v8 L=0.5u W=1u
M15067 o7 ibias vss vss sky130_fd_pr__nfet_01v8 L=0.5u W=1u
M15068 o7 ibias vss vss sky130_fd_pr__nfet_01v8 L=0.5u W=1u
M15069 o7 ibias vss vss sky130_fd_pr__nfet_01v8 L=0.5u W=1u
M15070 o7 ibias vss vss sky130_fd_pr__nfet_01v8 L=0.5u W=1u
M15071 o7 ibias vss vss sky130_fd_pr__nfet_01v8 L=0.5u W=1u
M15072 o7 ibias vss vss sky130_fd_pr__nfet_01v8 L=0.5u W=1u
M15073 o7 ibias vss vss sky130_fd_pr__nfet_01v8 L=0.5u W=1u
M15074 o7 ibias vss vss sky130_fd_pr__nfet_01v8 L=0.5u W=1u
M15075 o7 ibias vss vss sky130_fd_pr__nfet_01v8 L=0.5u W=1u
M15076 o7 ibias vss vss sky130_fd_pr__nfet_01v8 L=0.5u W=1u
M15077 o7 ibias vss vss sky130_fd_pr__nfet_01v8 L=0.5u W=1u
M15078 o7 ibias vss vss sky130_fd_pr__nfet_01v8 L=0.5u W=1u
M15079 o7 ibias vss vss sky130_fd_pr__nfet_01v8 L=0.5u W=1u
M15080 o7 ibias vss vss sky130_fd_pr__nfet_01v8 L=0.5u W=1u
M15081 o7 ibias vss vss sky130_fd_pr__nfet_01v8 L=0.5u W=1u
M15082 o7 ibias vss vss sky130_fd_pr__nfet_01v8 L=0.5u W=1u
M15083 o7 ibias vss vss sky130_fd_pr__nfet_01v8 L=0.5u W=1u
M15084 o7 ibias vss vss sky130_fd_pr__nfet_01v8 L=0.5u W=1u
M15085 o7 ibias vss vss sky130_fd_pr__nfet_01v8 L=0.5u W=1u
M15086 o7 ibias vss vss sky130_fd_pr__nfet_01v8 L=0.5u W=1u
M15087 o7 ibias vss vss sky130_fd_pr__nfet_01v8 L=0.5u W=1u
M15088 o7 ibias vss vss sky130_fd_pr__nfet_01v8 L=0.5u W=1u
M15089 o7 ibias vss vss sky130_fd_pr__nfet_01v8 L=0.5u W=1u
M15090 o7 ibias vss vss sky130_fd_pr__nfet_01v8 L=0.5u W=1u
M15091 o7 ibias vss vss sky130_fd_pr__nfet_01v8 L=0.5u W=1u
M15092 o7 ibias vss vss sky130_fd_pr__nfet_01v8 L=0.5u W=1u
M15093 o7 ibias vss vss sky130_fd_pr__nfet_01v8 L=0.5u W=1u
M15094 o7 ibias vss vss sky130_fd_pr__nfet_01v8 L=0.5u W=1u
M15095 o7 ibias vss vss sky130_fd_pr__nfet_01v8 L=0.5u W=1u
M15096 o7 ibias vss vss sky130_fd_pr__nfet_01v8 L=0.5u W=1u
M15097 o7 ibias vss vss sky130_fd_pr__nfet_01v8 L=0.5u W=1u
M15098 o7 ibias vss vss sky130_fd_pr__nfet_01v8 L=0.5u W=1u
M15099 o7 ibias vss vss sky130_fd_pr__nfet_01v8 L=0.5u W=1u
M15100 o7 ibias vss vss sky130_fd_pr__nfet_01v8 L=0.5u W=1u
M15101 o7 ibias vss vss sky130_fd_pr__nfet_01v8 L=0.5u W=1u
M15102 o7 ibias vss vss sky130_fd_pr__nfet_01v8 L=0.5u W=1u
M15103 o7 ibias vss vss sky130_fd_pr__nfet_01v8 L=0.5u W=1u
M15104 o7 ibias vss vss sky130_fd_pr__nfet_01v8 L=0.5u W=1u
M15105 o7 ibias vss vss sky130_fd_pr__nfet_01v8 L=0.5u W=1u
M15106 o7 ibias vss vss sky130_fd_pr__nfet_01v8 L=0.5u W=1u
M15107 o7 ibias vss vss sky130_fd_pr__nfet_01v8 L=0.5u W=1u
M15108 o7 ibias vss vss sky130_fd_pr__nfet_01v8 L=0.5u W=1u
M15109 o7 ibias vss vss sky130_fd_pr__nfet_01v8 L=0.5u W=1u
M15110 o7 ibias vss vss sky130_fd_pr__nfet_01v8 L=0.5u W=1u
M15111 o7 ibias vss vss sky130_fd_pr__nfet_01v8 L=0.5u W=1u
M15112 o7 ibias vss vss sky130_fd_pr__nfet_01v8 L=0.5u W=1u
M15113 o7 ibias vss vss sky130_fd_pr__nfet_01v8 L=0.5u W=1u
M15114 o7 ibias vss vss sky130_fd_pr__nfet_01v8 L=0.5u W=1u
M15115 o7 ibias vss vss sky130_fd_pr__nfet_01v8 L=0.5u W=1u
M15116 o7 ibias vss vss sky130_fd_pr__nfet_01v8 L=0.5u W=1u
M15117 o7 ibias vss vss sky130_fd_pr__nfet_01v8 L=0.5u W=1u
M15118 o7 ibias vss vss sky130_fd_pr__nfet_01v8 L=0.5u W=1u
M15119 o7 ibias vss vss sky130_fd_pr__nfet_01v8 L=0.5u W=1u
M15120 o7 ibias vss vss sky130_fd_pr__nfet_01v8 L=0.5u W=1u
M15121 o7 ibias vss vss sky130_fd_pr__nfet_01v8 L=0.5u W=1u
M15122 o7 ibias vss vss sky130_fd_pr__nfet_01v8 L=0.5u W=1u
M15123 o7 ibias vss vss sky130_fd_pr__nfet_01v8 L=0.5u W=1u
M15124 o7 ibias vss vss sky130_fd_pr__nfet_01v8 L=0.5u W=1u
M15125 o7 ibias vss vss sky130_fd_pr__nfet_01v8 L=0.5u W=1u
M15126 o7 ibias vss vss sky130_fd_pr__nfet_01v8 L=0.5u W=1u
M15127 o7 ibias vss vss sky130_fd_pr__nfet_01v8 L=0.5u W=1u
M15128 o7 ibias vss vss sky130_fd_pr__nfet_01v8 L=0.5u W=1u
M15129 o7 ibias vss vss sky130_fd_pr__nfet_01v8 L=0.5u W=1u
M15130 o7 ibias vss vss sky130_fd_pr__nfet_01v8 L=0.5u W=1u
M15131 o7 ibias vss vss sky130_fd_pr__nfet_01v8 L=0.5u W=1u
M15132 o7 ibias vss vss sky130_fd_pr__nfet_01v8 L=0.5u W=1u
M15133 o7 ibias vss vss sky130_fd_pr__nfet_01v8 L=0.5u W=1u
M15134 o7 ibias vss vss sky130_fd_pr__nfet_01v8 L=0.5u W=1u
M15135 o7 ibias vss vss sky130_fd_pr__nfet_01v8 L=0.5u W=1u
M15136 o7 ibias vss vss sky130_fd_pr__nfet_01v8 L=0.5u W=1u
M15137 o7 ibias vss vss sky130_fd_pr__nfet_01v8 L=0.5u W=1u
M15138 o7 ibias vss vss sky130_fd_pr__nfet_01v8 L=0.5u W=1u
M15139 o7 ibias vss vss sky130_fd_pr__nfet_01v8 L=0.5u W=1u
M15140 o7 ibias vss vss sky130_fd_pr__nfet_01v8 L=0.5u W=1u
M15141 o7 ibias vss vss sky130_fd_pr__nfet_01v8 L=0.5u W=1u
M15142 o7 ibias vss vss sky130_fd_pr__nfet_01v8 L=0.5u W=1u
M15143 o7 ibias vss vss sky130_fd_pr__nfet_01v8 L=0.5u W=1u
M15144 o7 ibias vss vss sky130_fd_pr__nfet_01v8 L=0.5u W=1u
M15145 o7 ibias vss vss sky130_fd_pr__nfet_01v8 L=0.5u W=1u
M15146 o7 ibias vss vss sky130_fd_pr__nfet_01v8 L=0.5u W=1u
M15147 o7 ibias vss vss sky130_fd_pr__nfet_01v8 L=0.5u W=1u
M15148 o7 ibias vss vss sky130_fd_pr__nfet_01v8 L=0.5u W=1u
M15149 o7 ibias vss vss sky130_fd_pr__nfet_01v8 L=0.5u W=1u
M15150 o7 ibias vss vss sky130_fd_pr__nfet_01v8 L=0.5u W=1u
M15151 o7 ibias vss vss sky130_fd_pr__nfet_01v8 L=0.5u W=1u
M15152 o7 ibias vss vss sky130_fd_pr__nfet_01v8 L=0.5u W=1u
M15153 o7 ibias vss vss sky130_fd_pr__nfet_01v8 L=0.5u W=1u
M15154 o7 ibias vss vss sky130_fd_pr__nfet_01v8 L=0.5u W=1u
M15155 o7 ibias vss vss sky130_fd_pr__nfet_01v8 L=0.5u W=1u
M15156 o7 ibias vss vss sky130_fd_pr__nfet_01v8 L=0.5u W=1u
M15157 o7 ibias vss vss sky130_fd_pr__nfet_01v8 L=0.5u W=1u
M15158 o7 ibias vss vss sky130_fd_pr__nfet_01v8 L=0.5u W=1u
M15159 o7 ibias vss vss sky130_fd_pr__nfet_01v8 L=0.5u W=1u
M15160 o7 ibias vss vss sky130_fd_pr__nfet_01v8 L=0.5u W=1u
M15161 o7 ibias vss vss sky130_fd_pr__nfet_01v8 L=0.5u W=1u
M15162 o7 ibias vss vss sky130_fd_pr__nfet_01v8 L=0.5u W=1u
M15163 o7 ibias vss vss sky130_fd_pr__nfet_01v8 L=0.5u W=1u
M15164 o7 ibias vss vss sky130_fd_pr__nfet_01v8 L=0.5u W=1u
M15165 o7 ibias vss vss sky130_fd_pr__nfet_01v8 L=0.5u W=1u
M15166 o7 ibias vss vss sky130_fd_pr__nfet_01v8 L=0.5u W=1u
M15167 o7 ibias vss vss sky130_fd_pr__nfet_01v8 L=0.5u W=1u
M15168 o7 ibias vss vss sky130_fd_pr__nfet_01v8 L=0.5u W=1u
M15169 o7 ibias vss vss sky130_fd_pr__nfet_01v8 L=0.5u W=1u
M15170 o7 ibias vss vss sky130_fd_pr__nfet_01v8 L=0.5u W=1u
M15171 o7 ibias vss vss sky130_fd_pr__nfet_01v8 L=0.5u W=1u
M15172 o7 ibias vss vss sky130_fd_pr__nfet_01v8 L=0.5u W=1u
M15173 o7 ibias vss vss sky130_fd_pr__nfet_01v8 L=0.5u W=1u
M15174 o7 ibias vss vss sky130_fd_pr__nfet_01v8 L=0.5u W=1u
M15175 o7 ibias vss vss sky130_fd_pr__nfet_01v8 L=0.5u W=1u
M15176 o7 ibias vss vss sky130_fd_pr__nfet_01v8 L=0.5u W=1u
M15177 o7 ibias vss vss sky130_fd_pr__nfet_01v8 L=0.5u W=1u
M15178 o7 ibias vss vss sky130_fd_pr__nfet_01v8 L=0.5u W=1u
M15179 o7 ibias vss vss sky130_fd_pr__nfet_01v8 L=0.5u W=1u
M15180 o7 ibias vss vss sky130_fd_pr__nfet_01v8 L=0.5u W=1u
M15181 o7 ibias vss vss sky130_fd_pr__nfet_01v8 L=0.5u W=1u
M15182 o7 ibias vss vss sky130_fd_pr__nfet_01v8 L=0.5u W=1u
M15183 o7 ibias vss vss sky130_fd_pr__nfet_01v8 L=0.5u W=1u
M15184 o7 ibias vss vss sky130_fd_pr__nfet_01v8 L=0.5u W=1u
M15185 o7 ibias vss vss sky130_fd_pr__nfet_01v8 L=0.5u W=1u
M15186 o7 ibias vss vss sky130_fd_pr__nfet_01v8 L=0.5u W=1u
M15187 o7 ibias vss vss sky130_fd_pr__nfet_01v8 L=0.5u W=1u
M15188 o7 ibias vss vss sky130_fd_pr__nfet_01v8 L=0.5u W=1u
M15189 o7 ibias vss vss sky130_fd_pr__nfet_01v8 L=0.5u W=1u
M15190 o7 ibias vss vss sky130_fd_pr__nfet_01v8 L=0.5u W=1u
M15191 o7 ibias vss vss sky130_fd_pr__nfet_01v8 L=0.5u W=1u
M15192 o7 ibias vss vss sky130_fd_pr__nfet_01v8 L=0.5u W=1u
M15193 o7 ibias vss vss sky130_fd_pr__nfet_01v8 L=0.5u W=1u
M15194 o7 ibias vss vss sky130_fd_pr__nfet_01v8 L=0.5u W=1u
M15195 o7 ibias vss vss sky130_fd_pr__nfet_01v8 L=0.5u W=1u
M15196 o7 ibias vss vss sky130_fd_pr__nfet_01v8 L=0.5u W=1u
M15197 o7 ibias vss vss sky130_fd_pr__nfet_01v8 L=0.5u W=1u
M15198 o7 ibias vss vss sky130_fd_pr__nfet_01v8 L=0.5u W=1u
M15199 o7 ibias vss vss sky130_fd_pr__nfet_01v8 L=0.5u W=1u
M15200 o7 ibias vss vss sky130_fd_pr__nfet_01v8 L=0.5u W=1u
M15201 o7 ibias vss vss sky130_fd_pr__nfet_01v8 L=0.5u W=1u
M15202 o7 ibias vss vss sky130_fd_pr__nfet_01v8 L=0.5u W=1u
M15203 o7 ibias vss vss sky130_fd_pr__nfet_01v8 L=0.5u W=1u
M15204 o7 ibias vss vss sky130_fd_pr__nfet_01v8 L=0.5u W=1u
M15205 o7 ibias vss vss sky130_fd_pr__nfet_01v8 L=0.5u W=1u
M15206 o7 ibias vss vss sky130_fd_pr__nfet_01v8 L=0.5u W=1u
M15207 o7 ibias vss vss sky130_fd_pr__nfet_01v8 L=0.5u W=1u
M15208 o7 ibias vss vss sky130_fd_pr__nfet_01v8 L=0.5u W=1u
M15209 o7 ibias vss vss sky130_fd_pr__nfet_01v8 L=0.5u W=1u
M15210 o7 ibias vss vss sky130_fd_pr__nfet_01v8 L=0.5u W=1u
M15211 o7 ibias vss vss sky130_fd_pr__nfet_01v8 L=0.5u W=1u
M15212 o7 ibias vss vss sky130_fd_pr__nfet_01v8 L=0.5u W=1u
M15213 o7 ibias vss vss sky130_fd_pr__nfet_01v8 L=0.5u W=1u
M15214 o7 ibias vss vss sky130_fd_pr__nfet_01v8 L=0.5u W=1u
M15215 o7 ibias vss vss sky130_fd_pr__nfet_01v8 L=0.5u W=1u
M15216 o7 ibias vss vss sky130_fd_pr__nfet_01v8 L=0.5u W=1u
M15217 o7 ibias vss vss sky130_fd_pr__nfet_01v8 L=0.5u W=1u
M15218 o7 ibias vss vss sky130_fd_pr__nfet_01v8 L=0.5u W=1u
M15219 o7 ibias vss vss sky130_fd_pr__nfet_01v8 L=0.5u W=1u
M15220 o7 ibias vss vss sky130_fd_pr__nfet_01v8 L=0.5u W=1u
M15221 o7 ibias vss vss sky130_fd_pr__nfet_01v8 L=0.5u W=1u
M15222 o7 ibias vss vss sky130_fd_pr__nfet_01v8 L=0.5u W=1u
M15223 o7 ibias vss vss sky130_fd_pr__nfet_01v8 L=0.5u W=1u
M15224 o7 ibias vss vss sky130_fd_pr__nfet_01v8 L=0.5u W=1u
M15225 o7 ibias vss vss sky130_fd_pr__nfet_01v8 L=0.5u W=1u
M15226 o7 ibias vss vss sky130_fd_pr__nfet_01v8 L=0.5u W=1u
M15227 o7 ibias vss vss sky130_fd_pr__nfet_01v8 L=0.5u W=1u
M15228 o7 ibias vss vss sky130_fd_pr__nfet_01v8 L=0.5u W=1u
M15229 o7 ibias vss vss sky130_fd_pr__nfet_01v8 L=0.5u W=1u
M15230 o7 ibias vss vss sky130_fd_pr__nfet_01v8 L=0.5u W=1u
M15231 o7 ibias vss vss sky130_fd_pr__nfet_01v8 L=0.5u W=1u
M15232 o7 ibias vss vss sky130_fd_pr__nfet_01v8 L=0.5u W=1u
M15233 o7 ibias vss vss sky130_fd_pr__nfet_01v8 L=0.5u W=1u
M15234 o7 ibias vss vss sky130_fd_pr__nfet_01v8 L=0.5u W=1u
M15235 o7 ibias vss vss sky130_fd_pr__nfet_01v8 L=0.5u W=1u
M15236 o7 ibias vss vss sky130_fd_pr__nfet_01v8 L=0.5u W=1u
M15237 o7 ibias vss vss sky130_fd_pr__nfet_01v8 L=0.5u W=1u
M15238 o7 ibias vss vss sky130_fd_pr__nfet_01v8 L=0.5u W=1u
M15239 o7 ibias vss vss sky130_fd_pr__nfet_01v8 L=0.5u W=1u
M15240 o7 ibias vss vss sky130_fd_pr__nfet_01v8 L=0.5u W=1u
M15241 o7 ibias vss vss sky130_fd_pr__nfet_01v8 L=0.5u W=1u
M15242 o7 ibias vss vss sky130_fd_pr__nfet_01v8 L=0.5u W=1u
M15243 o7 ibias vss vss sky130_fd_pr__nfet_01v8 L=0.5u W=1u
M15244 o7 ibias vss vss sky130_fd_pr__nfet_01v8 L=0.5u W=1u
M15245 o7 ibias vss vss sky130_fd_pr__nfet_01v8 L=0.5u W=1u
M15246 o7 ibias vss vss sky130_fd_pr__nfet_01v8 L=0.5u W=1u
M15247 o7 ibias vss vss sky130_fd_pr__nfet_01v8 L=0.5u W=1u
M15248 o7 ibias vss vss sky130_fd_pr__nfet_01v8 L=0.5u W=1u
M15249 o7 ibias vss vss sky130_fd_pr__nfet_01v8 L=0.5u W=1u
M15250 o7 ibias vss vss sky130_fd_pr__nfet_01v8 L=0.5u W=1u
M15251 o7 ibias vss vss sky130_fd_pr__nfet_01v8 L=0.5u W=1u
M15252 o7 ibias vss vss sky130_fd_pr__nfet_01v8 L=0.5u W=1u
M15253 o7 ibias vss vss sky130_fd_pr__nfet_01v8 L=0.5u W=1u
M15254 o7 ibias vss vss sky130_fd_pr__nfet_01v8 L=0.5u W=1u
M15255 o7 ibias vss vss sky130_fd_pr__nfet_01v8 L=0.5u W=1u
M15256 o7 ibias vss vss sky130_fd_pr__nfet_01v8 L=0.5u W=1u
M15257 o7 ibias vss vss sky130_fd_pr__nfet_01v8 L=0.5u W=1u
M15258 o7 ibias vss vss sky130_fd_pr__nfet_01v8 L=0.5u W=1u
M15259 o7 ibias vss vss sky130_fd_pr__nfet_01v8 L=0.5u W=1u
M15260 o7 ibias vss vss sky130_fd_pr__nfet_01v8 L=0.5u W=1u
M15261 o7 ibias vss vss sky130_fd_pr__nfet_01v8 L=0.5u W=1u
M15262 o7 ibias vss vss sky130_fd_pr__nfet_01v8 L=0.5u W=1u
M15263 o7 ibias vss vss sky130_fd_pr__nfet_01v8 L=0.5u W=1u
M15264 o7 ibias vss vss sky130_fd_pr__nfet_01v8 L=0.5u W=1u
M15265 o7 ibias vss vss sky130_fd_pr__nfet_01v8 L=0.5u W=1u
M15266 o7 ibias vss vss sky130_fd_pr__nfet_01v8 L=0.5u W=1u
M15267 o7 ibias vss vss sky130_fd_pr__nfet_01v8 L=0.5u W=1u
M15268 o7 ibias vss vss sky130_fd_pr__nfet_01v8 L=0.5u W=1u
M15269 o7 ibias vss vss sky130_fd_pr__nfet_01v8 L=0.5u W=1u
M15270 o7 ibias vss vss sky130_fd_pr__nfet_01v8 L=0.5u W=1u
M15271 o7 ibias vss vss sky130_fd_pr__nfet_01v8 L=0.5u W=1u
M15272 o7 ibias vss vss sky130_fd_pr__nfet_01v8 L=0.5u W=1u
M15273 o7 ibias vss vss sky130_fd_pr__nfet_01v8 L=0.5u W=1u
M15274 o7 ibias vss vss sky130_fd_pr__nfet_01v8 L=0.5u W=1u
M15275 o7 ibias vss vss sky130_fd_pr__nfet_01v8 L=0.5u W=1u
M15276 o7 ibias vss vss sky130_fd_pr__nfet_01v8 L=0.5u W=1u
M15277 o7 ibias vss vss sky130_fd_pr__nfet_01v8 L=0.5u W=1u
M15278 o7 ibias vss vss sky130_fd_pr__nfet_01v8 L=0.5u W=1u
M15279 o7 ibias vss vss sky130_fd_pr__nfet_01v8 L=0.5u W=1u
M15280 o7 ibias vss vss sky130_fd_pr__nfet_01v8 L=0.5u W=1u
M15281 o7 ibias vss vss sky130_fd_pr__nfet_01v8 L=0.5u W=1u
M15282 o7 ibias vss vss sky130_fd_pr__nfet_01v8 L=0.5u W=1u
M15283 o7 ibias vss vss sky130_fd_pr__nfet_01v8 L=0.5u W=1u
M15284 o7 ibias vss vss sky130_fd_pr__nfet_01v8 L=0.5u W=1u
M15285 o7 ibias vss vss sky130_fd_pr__nfet_01v8 L=0.5u W=1u
M15286 o7 ibias vss vss sky130_fd_pr__nfet_01v8 L=0.5u W=1u
M15287 o7 ibias vss vss sky130_fd_pr__nfet_01v8 L=0.5u W=1u
M15288 o7 ibias vss vss sky130_fd_pr__nfet_01v8 L=0.5u W=1u
M15289 o7 ibias vss vss sky130_fd_pr__nfet_01v8 L=0.5u W=1u
M15290 o7 ibias vss vss sky130_fd_pr__nfet_01v8 L=0.5u W=1u
M15291 o7 ibias vss vss sky130_fd_pr__nfet_01v8 L=0.5u W=1u
M15292 o7 ibias vss vss sky130_fd_pr__nfet_01v8 L=0.5u W=1u
M15293 o7 ibias vss vss sky130_fd_pr__nfet_01v8 L=0.5u W=1u
M15294 o7 ibias vss vss sky130_fd_pr__nfet_01v8 L=0.5u W=1u
M15295 o7 ibias vss vss sky130_fd_pr__nfet_01v8 L=0.5u W=1u
M15296 o7 ibias vss vss sky130_fd_pr__nfet_01v8 L=0.5u W=1u
M15297 o7 ibias vss vss sky130_fd_pr__nfet_01v8 L=0.5u W=1u
M15298 o7 ibias vss vss sky130_fd_pr__nfet_01v8 L=0.5u W=1u
M15299 o7 ibias vss vss sky130_fd_pr__nfet_01v8 L=0.5u W=1u
M15300 o7 ibias vss vss sky130_fd_pr__nfet_01v8 L=0.5u W=1u
M15301 o7 ibias vss vss sky130_fd_pr__nfet_01v8 L=0.5u W=1u
M15302 o7 ibias vss vss sky130_fd_pr__nfet_01v8 L=0.5u W=1u
M15303 o7 ibias vss vss sky130_fd_pr__nfet_01v8 L=0.5u W=1u
M15304 o7 ibias vss vss sky130_fd_pr__nfet_01v8 L=0.5u W=1u
M15305 o7 ibias vss vss sky130_fd_pr__nfet_01v8 L=0.5u W=1u
M15306 o7 ibias vss vss sky130_fd_pr__nfet_01v8 L=0.5u W=1u
M15307 o7 ibias vss vss sky130_fd_pr__nfet_01v8 L=0.5u W=1u
M15308 o7 ibias vss vss sky130_fd_pr__nfet_01v8 L=0.5u W=1u
M15309 o7 ibias vss vss sky130_fd_pr__nfet_01v8 L=0.5u W=1u
M15310 o7 ibias vss vss sky130_fd_pr__nfet_01v8 L=0.5u W=1u
M15311 o7 ibias vss vss sky130_fd_pr__nfet_01v8 L=0.5u W=1u
M15312 o7 ibias vss vss sky130_fd_pr__nfet_01v8 L=0.5u W=1u
M15313 o7 ibias vss vss sky130_fd_pr__nfet_01v8 L=0.5u W=1u
M15314 o7 ibias vss vss sky130_fd_pr__nfet_01v8 L=0.5u W=1u
M15315 o7 ibias vss vss sky130_fd_pr__nfet_01v8 L=0.5u W=1u
M15316 o7 ibias vss vss sky130_fd_pr__nfet_01v8 L=0.5u W=1u
M15317 o7 ibias vss vss sky130_fd_pr__nfet_01v8 L=0.5u W=1u
M15318 o7 ibias vss vss sky130_fd_pr__nfet_01v8 L=0.5u W=1u
M15319 o7 ibias vss vss sky130_fd_pr__nfet_01v8 L=0.5u W=1u
M15320 o7 ibias vss vss sky130_fd_pr__nfet_01v8 L=0.5u W=1u
M15321 o7 ibias vss vss sky130_fd_pr__nfet_01v8 L=0.5u W=1u
M15322 o7 ibias vss vss sky130_fd_pr__nfet_01v8 L=0.5u W=1u
M15323 o7 ibias vss vss sky130_fd_pr__nfet_01v8 L=0.5u W=1u
M15324 o7 ibias vss vss sky130_fd_pr__nfet_01v8 L=0.5u W=1u
M15325 o7 ibias vss vss sky130_fd_pr__nfet_01v8 L=0.5u W=1u
M15326 o7 ibias vss vss sky130_fd_pr__nfet_01v8 L=0.5u W=1u
M15327 o7 ibias vss vss sky130_fd_pr__nfet_01v8 L=0.5u W=1u
M15328 o7 ibias vss vss sky130_fd_pr__nfet_01v8 L=0.5u W=1u
M15329 o7 ibias vss vss sky130_fd_pr__nfet_01v8 L=0.5u W=1u
M15330 o7 ibias vss vss sky130_fd_pr__nfet_01v8 L=0.5u W=1u
M15331 o7 ibias vss vss sky130_fd_pr__nfet_01v8 L=0.5u W=1u
M15332 o7 ibias vss vss sky130_fd_pr__nfet_01v8 L=0.5u W=1u
M15333 o7 ibias vss vss sky130_fd_pr__nfet_01v8 L=0.5u W=1u
M15334 o7 ibias vss vss sky130_fd_pr__nfet_01v8 L=0.5u W=1u
M15335 o7 ibias vss vss sky130_fd_pr__nfet_01v8 L=0.5u W=1u
M15336 o7 ibias vss vss sky130_fd_pr__nfet_01v8 L=0.5u W=1u
M15337 o7 ibias vss vss sky130_fd_pr__nfet_01v8 L=0.5u W=1u
M15338 o7 ibias vss vss sky130_fd_pr__nfet_01v8 L=0.5u W=1u
M15339 o7 ibias vss vss sky130_fd_pr__nfet_01v8 L=0.5u W=1u
M15340 o7 ibias vss vss sky130_fd_pr__nfet_01v8 L=0.5u W=1u
M15341 o7 ibias vss vss sky130_fd_pr__nfet_01v8 L=0.5u W=1u
M15342 o7 ibias vss vss sky130_fd_pr__nfet_01v8 L=0.5u W=1u
M15343 o7 ibias vss vss sky130_fd_pr__nfet_01v8 L=0.5u W=1u
M15344 o7 ibias vss vss sky130_fd_pr__nfet_01v8 L=0.5u W=1u
M15345 o7 ibias vss vss sky130_fd_pr__nfet_01v8 L=0.5u W=1u
M15346 o7 ibias vss vss sky130_fd_pr__nfet_01v8 L=0.5u W=1u
M15347 o7 ibias vss vss sky130_fd_pr__nfet_01v8 L=0.5u W=1u
M15348 o7 ibias vss vss sky130_fd_pr__nfet_01v8 L=0.5u W=1u
M15349 o7 ibias vss vss sky130_fd_pr__nfet_01v8 L=0.5u W=1u
M15350 o7 ibias vss vss sky130_fd_pr__nfet_01v8 L=0.5u W=1u
M15351 o7 ibias vss vss sky130_fd_pr__nfet_01v8 L=0.5u W=1u
M15352 o7 ibias vss vss sky130_fd_pr__nfet_01v8 L=0.5u W=1u
M15353 o7 ibias vss vss sky130_fd_pr__nfet_01v8 L=0.5u W=1u
M15354 o7 ibias vss vss sky130_fd_pr__nfet_01v8 L=0.5u W=1u
M15355 o7 ibias vss vss sky130_fd_pr__nfet_01v8 L=0.5u W=1u
M15356 o7 ibias vss vss sky130_fd_pr__nfet_01v8 L=0.5u W=1u
M15357 o7 ibias vss vss sky130_fd_pr__nfet_01v8 L=0.5u W=1u
M15358 o7 ibias vss vss sky130_fd_pr__nfet_01v8 L=0.5u W=1u
M15359 o7 ibias vss vss sky130_fd_pr__nfet_01v8 L=0.5u W=1u
M15360 o7 ibias vss vss sky130_fd_pr__nfet_01v8 L=0.5u W=1u
M15361 o7 ibias vss vss sky130_fd_pr__nfet_01v8 L=0.5u W=1u
M15362 o7 ibias vss vss sky130_fd_pr__nfet_01v8 L=0.5u W=1u
M15363 o7 ibias vss vss sky130_fd_pr__nfet_01v8 L=0.5u W=1u
M15364 o7 ibias vss vss sky130_fd_pr__nfet_01v8 L=0.5u W=1u
M15365 o7 ibias vss vss sky130_fd_pr__nfet_01v8 L=0.5u W=1u
M15366 o7 ibias vss vss sky130_fd_pr__nfet_01v8 L=0.5u W=1u
M15367 o7 ibias vss vss sky130_fd_pr__nfet_01v8 L=0.5u W=1u
M15368 o7 ibias vss vss sky130_fd_pr__nfet_01v8 L=0.5u W=1u
M15369 o7 ibias vss vss sky130_fd_pr__nfet_01v8 L=0.5u W=1u
M15370 o7 ibias vss vss sky130_fd_pr__nfet_01v8 L=0.5u W=1u
M15371 o7 ibias vss vss sky130_fd_pr__nfet_01v8 L=0.5u W=1u
M15372 o7 ibias vss vss sky130_fd_pr__nfet_01v8 L=0.5u W=1u
M15373 o7 ibias vss vss sky130_fd_pr__nfet_01v8 L=0.5u W=1u
M15374 o7 ibias vss vss sky130_fd_pr__nfet_01v8 L=0.5u W=1u
M15375 o7 ibias vss vss sky130_fd_pr__nfet_01v8 L=0.5u W=1u
M15376 o7 ibias vss vss sky130_fd_pr__nfet_01v8 L=0.5u W=1u
M15377 o7 ibias vss vss sky130_fd_pr__nfet_01v8 L=0.5u W=1u
M15378 o7 ibias vss vss sky130_fd_pr__nfet_01v8 L=0.5u W=1u
M15379 o7 ibias vss vss sky130_fd_pr__nfet_01v8 L=0.5u W=1u
M15380 o7 ibias vss vss sky130_fd_pr__nfet_01v8 L=0.5u W=1u
M15381 o7 ibias vss vss sky130_fd_pr__nfet_01v8 L=0.5u W=1u
M15382 o7 ibias vss vss sky130_fd_pr__nfet_01v8 L=0.5u W=1u
M15383 o7 ibias vss vss sky130_fd_pr__nfet_01v8 L=0.5u W=1u
M15384 o7 ibias vss vss sky130_fd_pr__nfet_01v8 L=0.5u W=1u
M15385 o7 ibias vss vss sky130_fd_pr__nfet_01v8 L=0.5u W=1u
M15386 o7 ibias vss vss sky130_fd_pr__nfet_01v8 L=0.5u W=1u
M15387 o7 ibias vss vss sky130_fd_pr__nfet_01v8 L=0.5u W=1u
M15388 o7 ibias vss vss sky130_fd_pr__nfet_01v8 L=0.5u W=1u
M15389 o7 ibias vss vss sky130_fd_pr__nfet_01v8 L=0.5u W=1u
M15390 o7 ibias vss vss sky130_fd_pr__nfet_01v8 L=0.5u W=1u
M15391 o7 ibias vss vss sky130_fd_pr__nfet_01v8 L=0.5u W=1u
M15392 o7 ibias vss vss sky130_fd_pr__nfet_01v8 L=0.5u W=1u
M15393 o7 ibias vss vss sky130_fd_pr__nfet_01v8 L=0.5u W=1u
M15394 o7 ibias vss vss sky130_fd_pr__nfet_01v8 L=0.5u W=1u
M15395 o7 ibias vss vss sky130_fd_pr__nfet_01v8 L=0.5u W=1u
M15396 o7 ibias vss vss sky130_fd_pr__nfet_01v8 L=0.5u W=1u
M15397 o7 ibias vss vss sky130_fd_pr__nfet_01v8 L=0.5u W=1u
M15398 o7 ibias vss vss sky130_fd_pr__nfet_01v8 L=0.5u W=1u
M15399 o7 ibias vss vss sky130_fd_pr__nfet_01v8 L=0.5u W=1u
M15400 o7 ibias vss vss sky130_fd_pr__nfet_01v8 L=0.5u W=1u
M15401 o7 ibias vss vss sky130_fd_pr__nfet_01v8 L=0.5u W=1u
M15402 o7 ibias vss vss sky130_fd_pr__nfet_01v8 L=0.5u W=1u
M15403 o7 ibias vss vss sky130_fd_pr__nfet_01v8 L=0.5u W=1u
M15404 o7 ibias vss vss sky130_fd_pr__nfet_01v8 L=0.5u W=1u
M15405 o7 ibias vss vss sky130_fd_pr__nfet_01v8 L=0.5u W=1u
M15406 o7 ibias vss vss sky130_fd_pr__nfet_01v8 L=0.5u W=1u
M15407 o7 ibias vss vss sky130_fd_pr__nfet_01v8 L=0.5u W=1u
M15408 o7 ibias vss vss sky130_fd_pr__nfet_01v8 L=0.5u W=1u
M15409 o7 ibias vss vss sky130_fd_pr__nfet_01v8 L=0.5u W=1u
M15410 o7 ibias vss vss sky130_fd_pr__nfet_01v8 L=0.5u W=1u
M15411 o7 ibias vss vss sky130_fd_pr__nfet_01v8 L=0.5u W=1u
M15412 o7 ibias vss vss sky130_fd_pr__nfet_01v8 L=0.5u W=1u
M15413 o7 ibias vss vss sky130_fd_pr__nfet_01v8 L=0.5u W=1u
M15414 o7 ibias vss vss sky130_fd_pr__nfet_01v8 L=0.5u W=1u
M15415 o7 ibias vss vss sky130_fd_pr__nfet_01v8 L=0.5u W=1u
M15416 o7 ibias vss vss sky130_fd_pr__nfet_01v8 L=0.5u W=1u
M15417 o7 ibias vss vss sky130_fd_pr__nfet_01v8 L=0.5u W=1u
M15418 o7 ibias vss vss sky130_fd_pr__nfet_01v8 L=0.5u W=1u
M15419 o7 ibias vss vss sky130_fd_pr__nfet_01v8 L=0.5u W=1u
M15420 o7 ibias vss vss sky130_fd_pr__nfet_01v8 L=0.5u W=1u
M15421 o7 ibias vss vss sky130_fd_pr__nfet_01v8 L=0.5u W=1u
M15422 o7 ibias vss vss sky130_fd_pr__nfet_01v8 L=0.5u W=1u
M15423 o7 ibias vss vss sky130_fd_pr__nfet_01v8 L=0.5u W=1u
M15424 o7 ibias vss vss sky130_fd_pr__nfet_01v8 L=0.5u W=1u
M15425 o7 ibias vss vss sky130_fd_pr__nfet_01v8 L=0.5u W=1u
M15426 o7 ibias vss vss sky130_fd_pr__nfet_01v8 L=0.5u W=1u
M15427 o7 ibias vss vss sky130_fd_pr__nfet_01v8 L=0.5u W=1u
M15428 o7 ibias vss vss sky130_fd_pr__nfet_01v8 L=0.5u W=1u
M15429 o7 ibias vss vss sky130_fd_pr__nfet_01v8 L=0.5u W=1u
M15430 o7 ibias vss vss sky130_fd_pr__nfet_01v8 L=0.5u W=1u
M15431 o7 ibias vss vss sky130_fd_pr__nfet_01v8 L=0.5u W=1u
M15432 o7 ibias vss vss sky130_fd_pr__nfet_01v8 L=0.5u W=1u
M15433 o7 ibias vss vss sky130_fd_pr__nfet_01v8 L=0.5u W=1u
M15434 o7 ibias vss vss sky130_fd_pr__nfet_01v8 L=0.5u W=1u
M15435 o7 ibias vss vss sky130_fd_pr__nfet_01v8 L=0.5u W=1u
M15436 o7 ibias vss vss sky130_fd_pr__nfet_01v8 L=0.5u W=1u
M15437 o7 ibias vss vss sky130_fd_pr__nfet_01v8 L=0.5u W=1u
M15438 o7 ibias vss vss sky130_fd_pr__nfet_01v8 L=0.5u W=1u
M15439 o7 ibias vss vss sky130_fd_pr__nfet_01v8 L=0.5u W=1u
M15440 o7 ibias vss vss sky130_fd_pr__nfet_01v8 L=0.5u W=1u
M15441 o7 ibias vss vss sky130_fd_pr__nfet_01v8 L=0.5u W=1u
M15442 o7 ibias vss vss sky130_fd_pr__nfet_01v8 L=0.5u W=1u
M15443 o7 ibias vss vss sky130_fd_pr__nfet_01v8 L=0.5u W=1u
M15444 o7 ibias vss vss sky130_fd_pr__nfet_01v8 L=0.5u W=1u
M15445 o7 ibias vss vss sky130_fd_pr__nfet_01v8 L=0.5u W=1u
M15446 o7 ibias vss vss sky130_fd_pr__nfet_01v8 L=0.5u W=1u
M15447 o7 ibias vss vss sky130_fd_pr__nfet_01v8 L=0.5u W=1u
M15448 o7 ibias vss vss sky130_fd_pr__nfet_01v8 L=0.5u W=1u
M15449 o7 ibias vss vss sky130_fd_pr__nfet_01v8 L=0.5u W=1u
M15450 o7 ibias vss vss sky130_fd_pr__nfet_01v8 L=0.5u W=1u
M15451 o7 ibias vss vss sky130_fd_pr__nfet_01v8 L=0.5u W=1u
M15452 o7 ibias vss vss sky130_fd_pr__nfet_01v8 L=0.5u W=1u
M15453 o7 ibias vss vss sky130_fd_pr__nfet_01v8 L=0.5u W=1u
M15454 o7 ibias vss vss sky130_fd_pr__nfet_01v8 L=0.5u W=1u
M15455 o7 ibias vss vss sky130_fd_pr__nfet_01v8 L=0.5u W=1u
M15456 o7 ibias vss vss sky130_fd_pr__nfet_01v8 L=0.5u W=1u
M15457 o7 ibias vss vss sky130_fd_pr__nfet_01v8 L=0.5u W=1u
M15458 o7 ibias vss vss sky130_fd_pr__nfet_01v8 L=0.5u W=1u
M15459 o7 ibias vss vss sky130_fd_pr__nfet_01v8 L=0.5u W=1u
M15460 o7 ibias vss vss sky130_fd_pr__nfet_01v8 L=0.5u W=1u
M15461 o7 ibias vss vss sky130_fd_pr__nfet_01v8 L=0.5u W=1u
M15462 o7 ibias vss vss sky130_fd_pr__nfet_01v8 L=0.5u W=1u
M15463 o7 ibias vss vss sky130_fd_pr__nfet_01v8 L=0.5u W=1u
M15464 o7 ibias vss vss sky130_fd_pr__nfet_01v8 L=0.5u W=1u
M15465 o7 ibias vss vss sky130_fd_pr__nfet_01v8 L=0.5u W=1u
M15466 o7 ibias vss vss sky130_fd_pr__nfet_01v8 L=0.5u W=1u
M15467 o7 ibias vss vss sky130_fd_pr__nfet_01v8 L=0.5u W=1u
M15468 o7 ibias vss vss sky130_fd_pr__nfet_01v8 L=0.5u W=1u
M15469 o7 ibias vss vss sky130_fd_pr__nfet_01v8 L=0.5u W=1u
M15470 o7 ibias vss vss sky130_fd_pr__nfet_01v8 L=0.5u W=1u
M15471 o7 ibias vss vss sky130_fd_pr__nfet_01v8 L=0.5u W=1u
M15472 o7 ibias vss vss sky130_fd_pr__nfet_01v8 L=0.5u W=1u
M15473 o7 ibias vss vss sky130_fd_pr__nfet_01v8 L=0.5u W=1u
M15474 o7 ibias vss vss sky130_fd_pr__nfet_01v8 L=0.5u W=1u
M15475 o7 ibias vss vss sky130_fd_pr__nfet_01v8 L=0.5u W=1u
M15476 o7 ibias vss vss sky130_fd_pr__nfet_01v8 L=0.5u W=1u
M15477 o7 ibias vss vss sky130_fd_pr__nfet_01v8 L=0.5u W=1u
M15478 o7 ibias vss vss sky130_fd_pr__nfet_01v8 L=0.5u W=1u
M15479 o7 ibias vss vss sky130_fd_pr__nfet_01v8 L=0.5u W=1u
M15480 o7 ibias vss vss sky130_fd_pr__nfet_01v8 L=0.5u W=1u
M15481 o7 ibias vss vss sky130_fd_pr__nfet_01v8 L=0.5u W=1u
M15482 o7 ibias vss vss sky130_fd_pr__nfet_01v8 L=0.5u W=1u
M15483 o7 ibias vss vss sky130_fd_pr__nfet_01v8 L=0.5u W=1u
M15484 o7 ibias vss vss sky130_fd_pr__nfet_01v8 L=0.5u W=1u
M15485 o7 ibias vss vss sky130_fd_pr__nfet_01v8 L=0.5u W=1u
M15486 o7 ibias vss vss sky130_fd_pr__nfet_01v8 L=0.5u W=1u
M15487 o7 ibias vss vss sky130_fd_pr__nfet_01v8 L=0.5u W=1u
M15488 o7 ibias vss vss sky130_fd_pr__nfet_01v8 L=0.5u W=1u
M15489 o7 ibias vss vss sky130_fd_pr__nfet_01v8 L=0.5u W=1u
M15490 o7 ibias vss vss sky130_fd_pr__nfet_01v8 L=0.5u W=1u
M15491 o7 ibias vss vss sky130_fd_pr__nfet_01v8 L=0.5u W=1u
M15492 o7 ibias vss vss sky130_fd_pr__nfet_01v8 L=0.5u W=1u
M15493 o7 ibias vss vss sky130_fd_pr__nfet_01v8 L=0.5u W=1u
M15494 o7 ibias vss vss sky130_fd_pr__nfet_01v8 L=0.5u W=1u
M15495 o7 ibias vss vss sky130_fd_pr__nfet_01v8 L=0.5u W=1u
M15496 o7 ibias vss vss sky130_fd_pr__nfet_01v8 L=0.5u W=1u
M15497 o7 ibias vss vss sky130_fd_pr__nfet_01v8 L=0.5u W=1u
M15498 o7 ibias vss vss sky130_fd_pr__nfet_01v8 L=0.5u W=1u
M15499 o7 ibias vss vss sky130_fd_pr__nfet_01v8 L=0.5u W=1u
M15500 o7 ibias vss vss sky130_fd_pr__nfet_01v8 L=0.5u W=1u
M15501 o7 ibias vss vss sky130_fd_pr__nfet_01v8 L=0.5u W=1u
M15502 o7 ibias vss vss sky130_fd_pr__nfet_01v8 L=0.5u W=1u
M15503 o7 ibias vss vss sky130_fd_pr__nfet_01v8 L=0.5u W=1u
M15504 o7 ibias vss vss sky130_fd_pr__nfet_01v8 L=0.5u W=1u
M15505 o7 ibias vss vss sky130_fd_pr__nfet_01v8 L=0.5u W=1u
M15506 o7 ibias vss vss sky130_fd_pr__nfet_01v8 L=0.5u W=1u
M15507 o7 ibias vss vss sky130_fd_pr__nfet_01v8 L=0.5u W=1u
M15508 o7 ibias vss vss sky130_fd_pr__nfet_01v8 L=0.5u W=1u
M15509 o7 ibias vss vss sky130_fd_pr__nfet_01v8 L=0.5u W=1u
M15510 o7 ibias vss vss sky130_fd_pr__nfet_01v8 L=0.5u W=1u
M15511 o7 ibias vss vss sky130_fd_pr__nfet_01v8 L=0.5u W=1u
M15512 o7 ibias vss vss sky130_fd_pr__nfet_01v8 L=0.5u W=1u
M15513 o7 ibias vss vss sky130_fd_pr__nfet_01v8 L=0.5u W=1u
M15514 o7 ibias vss vss sky130_fd_pr__nfet_01v8 L=0.5u W=1u
M15515 o7 ibias vss vss sky130_fd_pr__nfet_01v8 L=0.5u W=1u
M15516 o7 ibias vss vss sky130_fd_pr__nfet_01v8 L=0.5u W=1u
M15517 o7 ibias vss vss sky130_fd_pr__nfet_01v8 L=0.5u W=1u
M15518 o7 ibias vss vss sky130_fd_pr__nfet_01v8 L=0.5u W=1u
M15519 o7 ibias vss vss sky130_fd_pr__nfet_01v8 L=0.5u W=1u
M15520 o7 ibias vss vss sky130_fd_pr__nfet_01v8 L=0.5u W=1u
M15521 o7 ibias vss vss sky130_fd_pr__nfet_01v8 L=0.5u W=1u
M15522 o7 ibias vss vss sky130_fd_pr__nfet_01v8 L=0.5u W=1u
M15523 o7 ibias vss vss sky130_fd_pr__nfet_01v8 L=0.5u W=1u
M15524 o7 ibias vss vss sky130_fd_pr__nfet_01v8 L=0.5u W=1u
M15525 o7 ibias vss vss sky130_fd_pr__nfet_01v8 L=0.5u W=1u
M15526 o7 ibias vss vss sky130_fd_pr__nfet_01v8 L=0.5u W=1u
M15527 o7 ibias vss vss sky130_fd_pr__nfet_01v8 L=0.5u W=1u
M15528 o7 ibias vss vss sky130_fd_pr__nfet_01v8 L=0.5u W=1u
M15529 o7 ibias vss vss sky130_fd_pr__nfet_01v8 L=0.5u W=1u
M15530 o7 ibias vss vss sky130_fd_pr__nfet_01v8 L=0.5u W=1u
M15531 o7 ibias vss vss sky130_fd_pr__nfet_01v8 L=0.5u W=1u
M15532 o7 ibias vss vss sky130_fd_pr__nfet_01v8 L=0.5u W=1u
M15533 o7 ibias vss vss sky130_fd_pr__nfet_01v8 L=0.5u W=1u
M15534 o7 ibias vss vss sky130_fd_pr__nfet_01v8 L=0.5u W=1u
M15535 o7 ibias vss vss sky130_fd_pr__nfet_01v8 L=0.5u W=1u
M15536 o7 ibias vss vss sky130_fd_pr__nfet_01v8 L=0.5u W=1u
M15537 o7 ibias vss vss sky130_fd_pr__nfet_01v8 L=0.5u W=1u
M15538 o7 ibias vss vss sky130_fd_pr__nfet_01v8 L=0.5u W=1u
M15539 o7 ibias vss vss sky130_fd_pr__nfet_01v8 L=0.5u W=1u
M15540 o7 ibias vss vss sky130_fd_pr__nfet_01v8 L=0.5u W=1u
M15541 o7 ibias vss vss sky130_fd_pr__nfet_01v8 L=0.5u W=1u
M15542 o7 ibias vss vss sky130_fd_pr__nfet_01v8 L=0.5u W=1u
M15543 o7 ibias vss vss sky130_fd_pr__nfet_01v8 L=0.5u W=1u
M15544 o7 ibias vss vss sky130_fd_pr__nfet_01v8 L=0.5u W=1u
M15545 o7 ibias vss vss sky130_fd_pr__nfet_01v8 L=0.5u W=1u
M15546 o7 ibias vss vss sky130_fd_pr__nfet_01v8 L=0.5u W=1u
M15547 o7 ibias vss vss sky130_fd_pr__nfet_01v8 L=0.5u W=1u
M15548 o7 ibias vss vss sky130_fd_pr__nfet_01v8 L=0.5u W=1u
M15549 o7 ibias vss vss sky130_fd_pr__nfet_01v8 L=0.5u W=1u
M15550 o7 ibias vss vss sky130_fd_pr__nfet_01v8 L=0.5u W=1u
M15551 o7 ibias vss vss sky130_fd_pr__nfet_01v8 L=0.5u W=1u
M15552 o7 ibias vss vss sky130_fd_pr__nfet_01v8 L=0.5u W=1u
M15553 o7 ibias vss vss sky130_fd_pr__nfet_01v8 L=0.5u W=1u
M15554 o7 ibias vss vss sky130_fd_pr__nfet_01v8 L=0.5u W=1u
M15555 o7 ibias vss vss sky130_fd_pr__nfet_01v8 L=0.5u W=1u
M15556 o7 ibias vss vss sky130_fd_pr__nfet_01v8 L=0.5u W=1u
M15557 o7 ibias vss vss sky130_fd_pr__nfet_01v8 L=0.5u W=1u
M15558 o7 ibias vss vss sky130_fd_pr__nfet_01v8 L=0.5u W=1u
M15559 o7 ibias vss vss sky130_fd_pr__nfet_01v8 L=0.5u W=1u
M15560 o7 ibias vss vss sky130_fd_pr__nfet_01v8 L=0.5u W=1u
M15561 o7 ibias vss vss sky130_fd_pr__nfet_01v8 L=0.5u W=1u
M15562 o7 ibias vss vss sky130_fd_pr__nfet_01v8 L=0.5u W=1u
M15563 o7 ibias vss vss sky130_fd_pr__nfet_01v8 L=0.5u W=1u
M15564 o7 ibias vss vss sky130_fd_pr__nfet_01v8 L=0.5u W=1u
M15565 o7 ibias vss vss sky130_fd_pr__nfet_01v8 L=0.5u W=1u
M15566 o7 ibias vss vss sky130_fd_pr__nfet_01v8 L=0.5u W=1u
M15567 o7 ibias vss vss sky130_fd_pr__nfet_01v8 L=0.5u W=1u
M15568 o7 ibias vss vss sky130_fd_pr__nfet_01v8 L=0.5u W=1u
M15569 o7 ibias vss vss sky130_fd_pr__nfet_01v8 L=0.5u W=1u
M15570 o7 ibias vss vss sky130_fd_pr__nfet_01v8 L=0.5u W=1u
M15571 o7 ibias vss vss sky130_fd_pr__nfet_01v8 L=0.5u W=1u
M15572 o7 ibias vss vss sky130_fd_pr__nfet_01v8 L=0.5u W=1u
M15573 o7 ibias vss vss sky130_fd_pr__nfet_01v8 L=0.5u W=1u
M15574 o7 ibias vss vss sky130_fd_pr__nfet_01v8 L=0.5u W=1u
M15575 o7 ibias vss vss sky130_fd_pr__nfet_01v8 L=0.5u W=1u
M15576 o7 ibias vss vss sky130_fd_pr__nfet_01v8 L=0.5u W=1u
M15577 o7 ibias vss vss sky130_fd_pr__nfet_01v8 L=0.5u W=1u
M15578 o7 ibias vss vss sky130_fd_pr__nfet_01v8 L=0.5u W=1u
M15579 o7 ibias vss vss sky130_fd_pr__nfet_01v8 L=0.5u W=1u
M15580 o7 ibias vss vss sky130_fd_pr__nfet_01v8 L=0.5u W=1u
M15581 o7 ibias vss vss sky130_fd_pr__nfet_01v8 L=0.5u W=1u
M15582 o7 ibias vss vss sky130_fd_pr__nfet_01v8 L=0.5u W=1u
M15583 o7 ibias vss vss sky130_fd_pr__nfet_01v8 L=0.5u W=1u
M15584 o7 ibias vss vss sky130_fd_pr__nfet_01v8 L=0.5u W=1u
M15585 o7 ibias vss vss sky130_fd_pr__nfet_01v8 L=0.5u W=1u
M15586 o7 ibias vss vss sky130_fd_pr__nfet_01v8 L=0.5u W=1u
M15587 o7 ibias vss vss sky130_fd_pr__nfet_01v8 L=0.5u W=1u
M15588 o7 ibias vss vss sky130_fd_pr__nfet_01v8 L=0.5u W=1u
M15589 o7 ibias vss vss sky130_fd_pr__nfet_01v8 L=0.5u W=1u
M15590 o7 ibias vss vss sky130_fd_pr__nfet_01v8 L=0.5u W=1u
M15591 o7 ibias vss vss sky130_fd_pr__nfet_01v8 L=0.5u W=1u
M15592 o7 ibias vss vss sky130_fd_pr__nfet_01v8 L=0.5u W=1u
M15593 o7 ibias vss vss sky130_fd_pr__nfet_01v8 L=0.5u W=1u
M15594 o7 ibias vss vss sky130_fd_pr__nfet_01v8 L=0.5u W=1u
M15595 o7 ibias vss vss sky130_fd_pr__nfet_01v8 L=0.5u W=1u
M15596 o7 ibias vss vss sky130_fd_pr__nfet_01v8 L=0.5u W=1u
M15597 o7 ibias vss vss sky130_fd_pr__nfet_01v8 L=0.5u W=1u
M15598 o7 ibias vss vss sky130_fd_pr__nfet_01v8 L=0.5u W=1u
M15599 o7 ibias vss vss sky130_fd_pr__nfet_01v8 L=0.5u W=1u
M15600 o7 ibias vss vss sky130_fd_pr__nfet_01v8 L=0.5u W=1u
M15601 o7 ibias vss vss sky130_fd_pr__nfet_01v8 L=0.5u W=1u
M15602 o7 ibias vss vss sky130_fd_pr__nfet_01v8 L=0.5u W=1u
M15603 o7 ibias vss vss sky130_fd_pr__nfet_01v8 L=0.5u W=1u
M15604 o7 ibias vss vss sky130_fd_pr__nfet_01v8 L=0.5u W=1u
M15605 o7 ibias vss vss sky130_fd_pr__nfet_01v8 L=0.5u W=1u
M15606 o7 ibias vss vss sky130_fd_pr__nfet_01v8 L=0.5u W=1u
M15607 o7 ibias vss vss sky130_fd_pr__nfet_01v8 L=0.5u W=1u
M15608 o7 ibias vss vss sky130_fd_pr__nfet_01v8 L=0.5u W=1u
M15609 o7 ibias vss vss sky130_fd_pr__nfet_01v8 L=0.5u W=1u
M15610 o7 ibias vss vss sky130_fd_pr__nfet_01v8 L=0.5u W=1u
M15611 o7 ibias vss vss sky130_fd_pr__nfet_01v8 L=0.5u W=1u
M15612 o7 ibias vss vss sky130_fd_pr__nfet_01v8 L=0.5u W=1u
M15613 o7 ibias vss vss sky130_fd_pr__nfet_01v8 L=0.5u W=1u
M15614 o7 ibias vss vss sky130_fd_pr__nfet_01v8 L=0.5u W=1u
M15615 o7 ibias vss vss sky130_fd_pr__nfet_01v8 L=0.5u W=1u
M15616 o7 ibias vss vss sky130_fd_pr__nfet_01v8 L=0.5u W=1u
M15617 o7 ibias vss vss sky130_fd_pr__nfet_01v8 L=0.5u W=1u
M15618 o7 ibias vss vss sky130_fd_pr__nfet_01v8 L=0.5u W=1u
M15619 o7 ibias vss vss sky130_fd_pr__nfet_01v8 L=0.5u W=1u
M15620 o7 ibias vss vss sky130_fd_pr__nfet_01v8 L=0.5u W=1u
M15621 o7 ibias vss vss sky130_fd_pr__nfet_01v8 L=0.5u W=1u
M15622 o7 ibias vss vss sky130_fd_pr__nfet_01v8 L=0.5u W=1u
M15623 o7 ibias vss vss sky130_fd_pr__nfet_01v8 L=0.5u W=1u
M15624 o7 ibias vss vss sky130_fd_pr__nfet_01v8 L=0.5u W=1u
M15625 o7 ibias vss vss sky130_fd_pr__nfet_01v8 L=0.5u W=1u
M15626 o7 ibias vss vss sky130_fd_pr__nfet_01v8 L=0.5u W=1u
M15627 o7 ibias vss vss sky130_fd_pr__nfet_01v8 L=0.5u W=1u
M15628 o7 ibias vss vss sky130_fd_pr__nfet_01v8 L=0.5u W=1u
M15629 o7 ibias vss vss sky130_fd_pr__nfet_01v8 L=0.5u W=1u
M15630 o7 ibias vss vss sky130_fd_pr__nfet_01v8 L=0.5u W=1u
M15631 o7 ibias vss vss sky130_fd_pr__nfet_01v8 L=0.5u W=1u
M15632 o7 ibias vss vss sky130_fd_pr__nfet_01v8 L=0.5u W=1u
M15633 o7 ibias vss vss sky130_fd_pr__nfet_01v8 L=0.5u W=1u
M15634 o7 ibias vss vss sky130_fd_pr__nfet_01v8 L=0.5u W=1u
M15635 o7 ibias vss vss sky130_fd_pr__nfet_01v8 L=0.5u W=1u
M15636 o7 ibias vss vss sky130_fd_pr__nfet_01v8 L=0.5u W=1u
M15637 o7 ibias vss vss sky130_fd_pr__nfet_01v8 L=0.5u W=1u
M15638 o7 ibias vss vss sky130_fd_pr__nfet_01v8 L=0.5u W=1u
M15639 o7 ibias vss vss sky130_fd_pr__nfet_01v8 L=0.5u W=1u
M15640 o7 ibias vss vss sky130_fd_pr__nfet_01v8 L=0.5u W=1u
M15641 o7 ibias vss vss sky130_fd_pr__nfet_01v8 L=0.5u W=1u
M15642 o7 ibias vss vss sky130_fd_pr__nfet_01v8 L=0.5u W=1u
M15643 o7 ibias vss vss sky130_fd_pr__nfet_01v8 L=0.5u W=1u
M15644 o7 ibias vss vss sky130_fd_pr__nfet_01v8 L=0.5u W=1u
M15645 o7 ibias vss vss sky130_fd_pr__nfet_01v8 L=0.5u W=1u
M15646 o7 ibias vss vss sky130_fd_pr__nfet_01v8 L=0.5u W=1u
M15647 o7 ibias vss vss sky130_fd_pr__nfet_01v8 L=0.5u W=1u
M15648 o7 ibias vss vss sky130_fd_pr__nfet_01v8 L=0.5u W=1u
M15649 o7 ibias vss vss sky130_fd_pr__nfet_01v8 L=0.5u W=1u
M15650 o7 ibias vss vss sky130_fd_pr__nfet_01v8 L=0.5u W=1u
M15651 o7 ibias vss vss sky130_fd_pr__nfet_01v8 L=0.5u W=1u
M15652 o7 ibias vss vss sky130_fd_pr__nfet_01v8 L=0.5u W=1u
M15653 o7 ibias vss vss sky130_fd_pr__nfet_01v8 L=0.5u W=1u
M15654 o7 ibias vss vss sky130_fd_pr__nfet_01v8 L=0.5u W=1u
M15655 o7 ibias vss vss sky130_fd_pr__nfet_01v8 L=0.5u W=1u
M15656 o7 ibias vss vss sky130_fd_pr__nfet_01v8 L=0.5u W=1u
M15657 o7 ibias vss vss sky130_fd_pr__nfet_01v8 L=0.5u W=1u
M15658 o7 ibias vss vss sky130_fd_pr__nfet_01v8 L=0.5u W=1u
M15659 o7 ibias vss vss sky130_fd_pr__nfet_01v8 L=0.5u W=1u
M15660 o7 ibias vss vss sky130_fd_pr__nfet_01v8 L=0.5u W=1u
M15661 o7 ibias vss vss sky130_fd_pr__nfet_01v8 L=0.5u W=1u
M15662 o7 ibias vss vss sky130_fd_pr__nfet_01v8 L=0.5u W=1u
M15663 o7 ibias vss vss sky130_fd_pr__nfet_01v8 L=0.5u W=1u
M15664 o7 ibias vss vss sky130_fd_pr__nfet_01v8 L=0.5u W=1u
M15665 o7 ibias vss vss sky130_fd_pr__nfet_01v8 L=0.5u W=1u
M15666 o7 ibias vss vss sky130_fd_pr__nfet_01v8 L=0.5u W=1u
M15667 o7 ibias vss vss sky130_fd_pr__nfet_01v8 L=0.5u W=1u
M15668 o7 ibias vss vss sky130_fd_pr__nfet_01v8 L=0.5u W=1u
M15669 o7 ibias vss vss sky130_fd_pr__nfet_01v8 L=0.5u W=1u
M15670 o7 ibias vss vss sky130_fd_pr__nfet_01v8 L=0.5u W=1u
M15671 o7 ibias vss vss sky130_fd_pr__nfet_01v8 L=0.5u W=1u
M15672 o7 ibias vss vss sky130_fd_pr__nfet_01v8 L=0.5u W=1u
M15673 o7 ibias vss vss sky130_fd_pr__nfet_01v8 L=0.5u W=1u
M15674 o7 ibias vss vss sky130_fd_pr__nfet_01v8 L=0.5u W=1u
M15675 o7 ibias vss vss sky130_fd_pr__nfet_01v8 L=0.5u W=1u
M15676 o7 ibias vss vss sky130_fd_pr__nfet_01v8 L=0.5u W=1u
M15677 o7 ibias vss vss sky130_fd_pr__nfet_01v8 L=0.5u W=1u
M15678 o7 ibias vss vss sky130_fd_pr__nfet_01v8 L=0.5u W=1u
M15679 o7 ibias vss vss sky130_fd_pr__nfet_01v8 L=0.5u W=1u
M15680 o7 ibias vss vss sky130_fd_pr__nfet_01v8 L=0.5u W=1u
M15681 o7 ibias vss vss sky130_fd_pr__nfet_01v8 L=0.5u W=1u
M15682 o7 ibias vss vss sky130_fd_pr__nfet_01v8 L=0.5u W=1u
M15683 o7 ibias vss vss sky130_fd_pr__nfet_01v8 L=0.5u W=1u
M15684 o7 ibias vss vss sky130_fd_pr__nfet_01v8 L=0.5u W=1u
M15685 o7 ibias vss vss sky130_fd_pr__nfet_01v8 L=0.5u W=1u
M15686 o7 ibias vss vss sky130_fd_pr__nfet_01v8 L=0.5u W=1u
M15687 o7 ibias vss vss sky130_fd_pr__nfet_01v8 L=0.5u W=1u
M15688 o7 ibias vss vss sky130_fd_pr__nfet_01v8 L=0.5u W=1u
M15689 o7 ibias vss vss sky130_fd_pr__nfet_01v8 L=0.5u W=1u
M15690 o7 ibias vss vss sky130_fd_pr__nfet_01v8 L=0.5u W=1u
M15691 o7 ibias vss vss sky130_fd_pr__nfet_01v8 L=0.5u W=1u
M15692 o7 ibias vss vss sky130_fd_pr__nfet_01v8 L=0.5u W=1u
M15693 o7 ibias vss vss sky130_fd_pr__nfet_01v8 L=0.5u W=1u
M15694 o7 ibias vss vss sky130_fd_pr__nfet_01v8 L=0.5u W=1u
M15695 o7 ibias vss vss sky130_fd_pr__nfet_01v8 L=0.5u W=1u
M15696 o7 ibias vss vss sky130_fd_pr__nfet_01v8 L=0.5u W=1u
M15697 o7 ibias vss vss sky130_fd_pr__nfet_01v8 L=0.5u W=1u
M15698 o7 ibias vss vss sky130_fd_pr__nfet_01v8 L=0.5u W=1u
M15699 o7 ibias vss vss sky130_fd_pr__nfet_01v8 L=0.5u W=1u
M15700 o7 ibias vss vss sky130_fd_pr__nfet_01v8 L=0.5u W=1u
M15701 o7 ibias vss vss sky130_fd_pr__nfet_01v8 L=0.5u W=1u
M15702 o7 ibias vss vss sky130_fd_pr__nfet_01v8 L=0.5u W=1u
M15703 o7 ibias vss vss sky130_fd_pr__nfet_01v8 L=0.5u W=1u
M15704 o7 ibias vss vss sky130_fd_pr__nfet_01v8 L=0.5u W=1u
M15705 o7 ibias vss vss sky130_fd_pr__nfet_01v8 L=0.5u W=1u
M15706 o7 ibias vss vss sky130_fd_pr__nfet_01v8 L=0.5u W=1u
M15707 o7 ibias vss vss sky130_fd_pr__nfet_01v8 L=0.5u W=1u
M15708 o7 ibias vss vss sky130_fd_pr__nfet_01v8 L=0.5u W=1u
M15709 o7 ibias vss vss sky130_fd_pr__nfet_01v8 L=0.5u W=1u
M15710 o7 ibias vss vss sky130_fd_pr__nfet_01v8 L=0.5u W=1u
M15711 o7 ibias vss vss sky130_fd_pr__nfet_01v8 L=0.5u W=1u
M15712 o7 ibias vss vss sky130_fd_pr__nfet_01v8 L=0.5u W=1u
M15713 o7 ibias vss vss sky130_fd_pr__nfet_01v8 L=0.5u W=1u
M15714 o7 ibias vss vss sky130_fd_pr__nfet_01v8 L=0.5u W=1u
M15715 o7 ibias vss vss sky130_fd_pr__nfet_01v8 L=0.5u W=1u
M15716 o7 ibias vss vss sky130_fd_pr__nfet_01v8 L=0.5u W=1u
M15717 o7 ibias vss vss sky130_fd_pr__nfet_01v8 L=0.5u W=1u
M15718 o7 ibias vss vss sky130_fd_pr__nfet_01v8 L=0.5u W=1u
M15719 o7 ibias vss vss sky130_fd_pr__nfet_01v8 L=0.5u W=1u
M15720 o7 ibias vss vss sky130_fd_pr__nfet_01v8 L=0.5u W=1u
M15721 o7 ibias vss vss sky130_fd_pr__nfet_01v8 L=0.5u W=1u
M15722 o7 ibias vss vss sky130_fd_pr__nfet_01v8 L=0.5u W=1u
M15723 o7 ibias vss vss sky130_fd_pr__nfet_01v8 L=0.5u W=1u
M15724 o7 ibias vss vss sky130_fd_pr__nfet_01v8 L=0.5u W=1u
M15725 o7 ibias vss vss sky130_fd_pr__nfet_01v8 L=0.5u W=1u
M15726 o7 ibias vss vss sky130_fd_pr__nfet_01v8 L=0.5u W=1u
M15727 o7 ibias vss vss sky130_fd_pr__nfet_01v8 L=0.5u W=1u
M15728 o7 ibias vss vss sky130_fd_pr__nfet_01v8 L=0.5u W=1u
M15729 o7 ibias vss vss sky130_fd_pr__nfet_01v8 L=0.5u W=1u
M15730 o7 ibias vss vss sky130_fd_pr__nfet_01v8 L=0.5u W=1u
M15731 o7 ibias vss vss sky130_fd_pr__nfet_01v8 L=0.5u W=1u
M15732 o7 ibias vss vss sky130_fd_pr__nfet_01v8 L=0.5u W=1u
M15733 o7 ibias vss vss sky130_fd_pr__nfet_01v8 L=0.5u W=1u
M15734 o7 ibias vss vss sky130_fd_pr__nfet_01v8 L=0.5u W=1u
M15735 o7 ibias vss vss sky130_fd_pr__nfet_01v8 L=0.5u W=1u
M15736 o7 ibias vss vss sky130_fd_pr__nfet_01v8 L=0.5u W=1u
M15737 o7 ibias vss vss sky130_fd_pr__nfet_01v8 L=0.5u W=1u
M15738 o7 ibias vss vss sky130_fd_pr__nfet_01v8 L=0.5u W=1u
M15739 o7 ibias vss vss sky130_fd_pr__nfet_01v8 L=0.5u W=1u
M15740 o7 ibias vss vss sky130_fd_pr__nfet_01v8 L=0.5u W=1u
M15741 o7 ibias vss vss sky130_fd_pr__nfet_01v8 L=0.5u W=1u
M15742 o7 ibias vss vss sky130_fd_pr__nfet_01v8 L=0.5u W=1u
M15743 o7 ibias vss vss sky130_fd_pr__nfet_01v8 L=0.5u W=1u
M15744 o7 ibias vss vss sky130_fd_pr__nfet_01v8 L=0.5u W=1u
M15745 o7 ibias vss vss sky130_fd_pr__nfet_01v8 L=0.5u W=1u
M15746 o7 ibias vss vss sky130_fd_pr__nfet_01v8 L=0.5u W=1u
M15747 o7 ibias vss vss sky130_fd_pr__nfet_01v8 L=0.5u W=1u
M15748 o7 ibias vss vss sky130_fd_pr__nfet_01v8 L=0.5u W=1u
M15749 o7 ibias vss vss sky130_fd_pr__nfet_01v8 L=0.5u W=1u
M15750 o7 ibias vss vss sky130_fd_pr__nfet_01v8 L=0.5u W=1u
M15751 o7 ibias vss vss sky130_fd_pr__nfet_01v8 L=0.5u W=1u
M15752 o7 ibias vss vss sky130_fd_pr__nfet_01v8 L=0.5u W=1u
M15753 o7 ibias vss vss sky130_fd_pr__nfet_01v8 L=0.5u W=1u
M15754 o7 ibias vss vss sky130_fd_pr__nfet_01v8 L=0.5u W=1u
M15755 o7 ibias vss vss sky130_fd_pr__nfet_01v8 L=0.5u W=1u
M15756 o7 ibias vss vss sky130_fd_pr__nfet_01v8 L=0.5u W=1u
M15757 o7 ibias vss vss sky130_fd_pr__nfet_01v8 L=0.5u W=1u
M15758 o7 ibias vss vss sky130_fd_pr__nfet_01v8 L=0.5u W=1u
M15759 o7 ibias vss vss sky130_fd_pr__nfet_01v8 L=0.5u W=1u
M15760 o7 ibias vss vss sky130_fd_pr__nfet_01v8 L=0.5u W=1u
M15761 o7 ibias vss vss sky130_fd_pr__nfet_01v8 L=0.5u W=1u
M15762 o7 ibias vss vss sky130_fd_pr__nfet_01v8 L=0.5u W=1u
M15763 o7 ibias vss vss sky130_fd_pr__nfet_01v8 L=0.5u W=1u
M15764 o7 ibias vss vss sky130_fd_pr__nfet_01v8 L=0.5u W=1u
M15765 o7 ibias vss vss sky130_fd_pr__nfet_01v8 L=0.5u W=1u
M15766 o7 ibias vss vss sky130_fd_pr__nfet_01v8 L=0.5u W=1u
M15767 o7 ibias vss vss sky130_fd_pr__nfet_01v8 L=0.5u W=1u
M15768 o7 ibias vss vss sky130_fd_pr__nfet_01v8 L=0.5u W=1u
M15769 o7 ibias vss vss sky130_fd_pr__nfet_01v8 L=0.5u W=1u
M15770 o7 ibias vss vss sky130_fd_pr__nfet_01v8 L=0.5u W=1u
M15771 o7 ibias vss vss sky130_fd_pr__nfet_01v8 L=0.5u W=1u
M15772 o7 ibias vss vss sky130_fd_pr__nfet_01v8 L=0.5u W=1u
M15773 o7 ibias vss vss sky130_fd_pr__nfet_01v8 L=0.5u W=1u
M15774 o7 ibias vss vss sky130_fd_pr__nfet_01v8 L=0.5u W=1u
M15775 o7 ibias vss vss sky130_fd_pr__nfet_01v8 L=0.5u W=1u
M15776 o7 ibias vss vss sky130_fd_pr__nfet_01v8 L=0.5u W=1u
M15777 o7 ibias vss vss sky130_fd_pr__nfet_01v8 L=0.5u W=1u
M15778 o7 ibias vss vss sky130_fd_pr__nfet_01v8 L=0.5u W=1u
M15779 o7 ibias vss vss sky130_fd_pr__nfet_01v8 L=0.5u W=1u
M15780 o7 ibias vss vss sky130_fd_pr__nfet_01v8 L=0.5u W=1u
M15781 o7 ibias vss vss sky130_fd_pr__nfet_01v8 L=0.5u W=1u
M15782 o7 ibias vss vss sky130_fd_pr__nfet_01v8 L=0.5u W=1u
M15783 o7 ibias vss vss sky130_fd_pr__nfet_01v8 L=0.5u W=1u
M15784 o7 ibias vss vss sky130_fd_pr__nfet_01v8 L=0.5u W=1u
M15785 o7 ibias vss vss sky130_fd_pr__nfet_01v8 L=0.5u W=1u
M15786 o7 ibias vss vss sky130_fd_pr__nfet_01v8 L=0.5u W=1u
M15787 o7 ibias vss vss sky130_fd_pr__nfet_01v8 L=0.5u W=1u
M15788 o7 ibias vss vss sky130_fd_pr__nfet_01v8 L=0.5u W=1u
M15789 o7 ibias vss vss sky130_fd_pr__nfet_01v8 L=0.5u W=1u
M15790 o7 ibias vss vss sky130_fd_pr__nfet_01v8 L=0.5u W=1u
M15791 o7 ibias vss vss sky130_fd_pr__nfet_01v8 L=0.5u W=1u
M15792 o7 ibias vss vss sky130_fd_pr__nfet_01v8 L=0.5u W=1u
M15793 o7 ibias vss vss sky130_fd_pr__nfet_01v8 L=0.5u W=1u
M15794 o7 ibias vss vss sky130_fd_pr__nfet_01v8 L=0.5u W=1u
M15795 o7 ibias vss vss sky130_fd_pr__nfet_01v8 L=0.5u W=1u
M15796 o7 ibias vss vss sky130_fd_pr__nfet_01v8 L=0.5u W=1u
M15797 o7 ibias vss vss sky130_fd_pr__nfet_01v8 L=0.5u W=1u
M15798 o7 ibias vss vss sky130_fd_pr__nfet_01v8 L=0.5u W=1u
M15799 o7 ibias vss vss sky130_fd_pr__nfet_01v8 L=0.5u W=1u
M15800 o7 ibias vss vss sky130_fd_pr__nfet_01v8 L=0.5u W=1u
M15801 o7 ibias vss vss sky130_fd_pr__nfet_01v8 L=0.5u W=1u
M15802 o7 ibias vss vss sky130_fd_pr__nfet_01v8 L=0.5u W=1u
M15803 o7 ibias vss vss sky130_fd_pr__nfet_01v8 L=0.5u W=1u
M15804 o7 ibias vss vss sky130_fd_pr__nfet_01v8 L=0.5u W=1u
M15805 o7 ibias vss vss sky130_fd_pr__nfet_01v8 L=0.5u W=1u
M15806 o7 ibias vss vss sky130_fd_pr__nfet_01v8 L=0.5u W=1u
M15807 o7 ibias vss vss sky130_fd_pr__nfet_01v8 L=0.5u W=1u
M15808 o7 ibias vss vss sky130_fd_pr__nfet_01v8 L=0.5u W=1u
M15809 o7 ibias vss vss sky130_fd_pr__nfet_01v8 L=0.5u W=1u
M15810 o7 ibias vss vss sky130_fd_pr__nfet_01v8 L=0.5u W=1u
M15811 o7 ibias vss vss sky130_fd_pr__nfet_01v8 L=0.5u W=1u
M15812 o7 ibias vss vss sky130_fd_pr__nfet_01v8 L=0.5u W=1u
M15813 o7 ibias vss vss sky130_fd_pr__nfet_01v8 L=0.5u W=1u
M15814 o7 ibias vss vss sky130_fd_pr__nfet_01v8 L=0.5u W=1u
M15815 o7 ibias vss vss sky130_fd_pr__nfet_01v8 L=0.5u W=1u
M15816 o7 ibias vss vss sky130_fd_pr__nfet_01v8 L=0.5u W=1u
M15817 o7 ibias vss vss sky130_fd_pr__nfet_01v8 L=0.5u W=1u
M15818 o7 ibias vss vss sky130_fd_pr__nfet_01v8 L=0.5u W=1u
M15819 o7 ibias vss vss sky130_fd_pr__nfet_01v8 L=0.5u W=1u
M15820 o7 ibias vss vss sky130_fd_pr__nfet_01v8 L=0.5u W=1u
M15821 o7 ibias vss vss sky130_fd_pr__nfet_01v8 L=0.5u W=1u
M15822 o7 ibias vss vss sky130_fd_pr__nfet_01v8 L=0.5u W=1u
M15823 o7 ibias vss vss sky130_fd_pr__nfet_01v8 L=0.5u W=1u
M15824 o7 ibias vss vss sky130_fd_pr__nfet_01v8 L=0.5u W=1u
M15825 o7 ibias vss vss sky130_fd_pr__nfet_01v8 L=0.5u W=1u
M15826 o7 ibias vss vss sky130_fd_pr__nfet_01v8 L=0.5u W=1u
M15827 o7 ibias vss vss sky130_fd_pr__nfet_01v8 L=0.5u W=1u
M15828 o7 ibias vss vss sky130_fd_pr__nfet_01v8 L=0.5u W=1u
M15829 o7 ibias vss vss sky130_fd_pr__nfet_01v8 L=0.5u W=1u
M15830 o7 ibias vss vss sky130_fd_pr__nfet_01v8 L=0.5u W=1u
M15831 o7 ibias vss vss sky130_fd_pr__nfet_01v8 L=0.5u W=1u
M15832 o7 ibias vss vss sky130_fd_pr__nfet_01v8 L=0.5u W=1u
M15833 o7 ibias vss vss sky130_fd_pr__nfet_01v8 L=0.5u W=1u
M15834 o7 ibias vss vss sky130_fd_pr__nfet_01v8 L=0.5u W=1u
M15835 o7 ibias vss vss sky130_fd_pr__nfet_01v8 L=0.5u W=1u
M15836 o7 ibias vss vss sky130_fd_pr__nfet_01v8 L=0.5u W=1u
M15837 o7 ibias vss vss sky130_fd_pr__nfet_01v8 L=0.5u W=1u
M15838 o7 ibias vss vss sky130_fd_pr__nfet_01v8 L=0.5u W=1u
M15839 o7 ibias vss vss sky130_fd_pr__nfet_01v8 L=0.5u W=1u
M15840 o7 ibias vss vss sky130_fd_pr__nfet_01v8 L=0.5u W=1u
M15841 o7 ibias vss vss sky130_fd_pr__nfet_01v8 L=0.5u W=1u
M15842 o7 ibias vss vss sky130_fd_pr__nfet_01v8 L=0.5u W=1u
M15843 o7 ibias vss vss sky130_fd_pr__nfet_01v8 L=0.5u W=1u
M15844 o7 ibias vss vss sky130_fd_pr__nfet_01v8 L=0.5u W=1u
M15845 o7 ibias vss vss sky130_fd_pr__nfet_01v8 L=0.5u W=1u
M15846 o7 ibias vss vss sky130_fd_pr__nfet_01v8 L=0.5u W=1u
M15847 o7 ibias vss vss sky130_fd_pr__nfet_01v8 L=0.5u W=1u
M15848 o7 ibias vss vss sky130_fd_pr__nfet_01v8 L=0.5u W=1u
M15849 o7 ibias vss vss sky130_fd_pr__nfet_01v8 L=0.5u W=1u
M15850 o7 ibias vss vss sky130_fd_pr__nfet_01v8 L=0.5u W=1u
M15851 o7 ibias vss vss sky130_fd_pr__nfet_01v8 L=0.5u W=1u
M15852 o7 ibias vss vss sky130_fd_pr__nfet_01v8 L=0.5u W=1u
M15853 o7 ibias vss vss sky130_fd_pr__nfet_01v8 L=0.5u W=1u
M15854 o7 ibias vss vss sky130_fd_pr__nfet_01v8 L=0.5u W=1u
M15855 o7 ibias vss vss sky130_fd_pr__nfet_01v8 L=0.5u W=1u
M15856 o7 ibias vss vss sky130_fd_pr__nfet_01v8 L=0.5u W=1u
M15857 o7 ibias vss vss sky130_fd_pr__nfet_01v8 L=0.5u W=1u
M15858 o7 ibias vss vss sky130_fd_pr__nfet_01v8 L=0.5u W=1u
M15859 o7 ibias vss vss sky130_fd_pr__nfet_01v8 L=0.5u W=1u
M15860 o7 ibias vss vss sky130_fd_pr__nfet_01v8 L=0.5u W=1u
M15861 o7 ibias vss vss sky130_fd_pr__nfet_01v8 L=0.5u W=1u
M15862 o7 ibias vss vss sky130_fd_pr__nfet_01v8 L=0.5u W=1u
M15863 o7 ibias vss vss sky130_fd_pr__nfet_01v8 L=0.5u W=1u
M15864 o7 ibias vss vss sky130_fd_pr__nfet_01v8 L=0.5u W=1u
M15865 o7 ibias vss vss sky130_fd_pr__nfet_01v8 L=0.5u W=1u
M15866 o7 ibias vss vss sky130_fd_pr__nfet_01v8 L=0.5u W=1u
M15867 o7 ibias vss vss sky130_fd_pr__nfet_01v8 L=0.5u W=1u
M15868 o7 ibias vss vss sky130_fd_pr__nfet_01v8 L=0.5u W=1u
M15869 o7 ibias vss vss sky130_fd_pr__nfet_01v8 L=0.5u W=1u
M15870 o7 ibias vss vss sky130_fd_pr__nfet_01v8 L=0.5u W=1u
M15871 o7 ibias vss vss sky130_fd_pr__nfet_01v8 L=0.5u W=1u
M15872 o7 ibias vss vss sky130_fd_pr__nfet_01v8 L=0.5u W=1u
M15873 o7 ibias vss vss sky130_fd_pr__nfet_01v8 L=0.5u W=1u
M15874 o7 ibias vss vss sky130_fd_pr__nfet_01v8 L=0.5u W=1u
M15875 o7 ibias vss vss sky130_fd_pr__nfet_01v8 L=0.5u W=1u
M15876 o7 ibias vss vss sky130_fd_pr__nfet_01v8 L=0.5u W=1u
M15877 o7 ibias vss vss sky130_fd_pr__nfet_01v8 L=0.5u W=1u
M15878 o7 ibias vss vss sky130_fd_pr__nfet_01v8 L=0.5u W=1u
M15879 o7 ibias vss vss sky130_fd_pr__nfet_01v8 L=0.5u W=1u
M15880 o7 ibias vss vss sky130_fd_pr__nfet_01v8 L=0.5u W=1u
M15881 o7 ibias vss vss sky130_fd_pr__nfet_01v8 L=0.5u W=1u
M15882 o7 ibias vss vss sky130_fd_pr__nfet_01v8 L=0.5u W=1u
M15883 o7 ibias vss vss sky130_fd_pr__nfet_01v8 L=0.5u W=1u
M15884 o7 ibias vss vss sky130_fd_pr__nfet_01v8 L=0.5u W=1u
M15885 o7 ibias vss vss sky130_fd_pr__nfet_01v8 L=0.5u W=1u
M15886 o7 ibias vss vss sky130_fd_pr__nfet_01v8 L=0.5u W=1u
M15887 o7 ibias vss vss sky130_fd_pr__nfet_01v8 L=0.5u W=1u
M15888 o7 ibias vss vss sky130_fd_pr__nfet_01v8 L=0.5u W=1u
M15889 o7 ibias vss vss sky130_fd_pr__nfet_01v8 L=0.5u W=1u
M15890 o7 ibias vss vss sky130_fd_pr__nfet_01v8 L=0.5u W=1u
M15891 o7 ibias vss vss sky130_fd_pr__nfet_01v8 L=0.5u W=1u
M15892 o7 ibias vss vss sky130_fd_pr__nfet_01v8 L=0.5u W=1u
M15893 o7 ibias vss vss sky130_fd_pr__nfet_01v8 L=0.5u W=1u
M15894 o7 ibias vss vss sky130_fd_pr__nfet_01v8 L=0.5u W=1u
M15895 o7 ibias vss vss sky130_fd_pr__nfet_01v8 L=0.5u W=1u
M15896 o7 ibias vss vss sky130_fd_pr__nfet_01v8 L=0.5u W=1u
M15897 o7 ibias vss vss sky130_fd_pr__nfet_01v8 L=0.5u W=1u
M15898 o7 ibias vss vss sky130_fd_pr__nfet_01v8 L=0.5u W=1u
M15899 o7 ibias vss vss sky130_fd_pr__nfet_01v8 L=0.5u W=1u
M15900 o7 ibias vss vss sky130_fd_pr__nfet_01v8 L=0.5u W=1u
M15901 o7 ibias vss vss sky130_fd_pr__nfet_01v8 L=0.5u W=1u
M15902 o7 ibias vss vss sky130_fd_pr__nfet_01v8 L=0.5u W=1u
M15903 o7 ibias vss vss sky130_fd_pr__nfet_01v8 L=0.5u W=1u
M15904 o7 ibias vss vss sky130_fd_pr__nfet_01v8 L=0.5u W=1u
M15905 o7 ibias vss vss sky130_fd_pr__nfet_01v8 L=0.5u W=1u
M15906 o7 ibias vss vss sky130_fd_pr__nfet_01v8 L=0.5u W=1u
M15907 o7 ibias vss vss sky130_fd_pr__nfet_01v8 L=0.5u W=1u
M15908 o7 ibias vss vss sky130_fd_pr__nfet_01v8 L=0.5u W=1u
M15909 o7 ibias vss vss sky130_fd_pr__nfet_01v8 L=0.5u W=1u
M15910 o7 ibias vss vss sky130_fd_pr__nfet_01v8 L=0.5u W=1u
M15911 o7 ibias vss vss sky130_fd_pr__nfet_01v8 L=0.5u W=1u
M15912 o7 ibias vss vss sky130_fd_pr__nfet_01v8 L=0.5u W=1u
M15913 o7 ibias vss vss sky130_fd_pr__nfet_01v8 L=0.5u W=1u
M15914 o7 ibias vss vss sky130_fd_pr__nfet_01v8 L=0.5u W=1u
M15915 o7 ibias vss vss sky130_fd_pr__nfet_01v8 L=0.5u W=1u
M15916 o7 ibias vss vss sky130_fd_pr__nfet_01v8 L=0.5u W=1u
M15917 o7 ibias vss vss sky130_fd_pr__nfet_01v8 L=0.5u W=1u
M15918 o7 ibias vss vss sky130_fd_pr__nfet_01v8 L=0.5u W=1u
M15919 o7 ibias vss vss sky130_fd_pr__nfet_01v8 L=0.5u W=1u
M15920 o7 ibias vss vss sky130_fd_pr__nfet_01v8 L=0.5u W=1u
M15921 o7 ibias vss vss sky130_fd_pr__nfet_01v8 L=0.5u W=1u
M15922 o7 ibias vss vss sky130_fd_pr__nfet_01v8 L=0.5u W=1u
M15923 o7 ibias vss vss sky130_fd_pr__nfet_01v8 L=0.5u W=1u
M15924 o7 ibias vss vss sky130_fd_pr__nfet_01v8 L=0.5u W=1u
M15925 o7 ibias vss vss sky130_fd_pr__nfet_01v8 L=0.5u W=1u
M15926 o7 ibias vss vss sky130_fd_pr__nfet_01v8 L=0.5u W=1u
M15927 o7 ibias vss vss sky130_fd_pr__nfet_01v8 L=0.5u W=1u
M15928 o7 ibias vss vss sky130_fd_pr__nfet_01v8 L=0.5u W=1u
M15929 o7 ibias vss vss sky130_fd_pr__nfet_01v8 L=0.5u W=1u
M15930 o7 ibias vss vss sky130_fd_pr__nfet_01v8 L=0.5u W=1u
M15931 o7 ibias vss vss sky130_fd_pr__nfet_01v8 L=0.5u W=1u
M15932 o7 ibias vss vss sky130_fd_pr__nfet_01v8 L=0.5u W=1u
M15933 o7 ibias vss vss sky130_fd_pr__nfet_01v8 L=0.5u W=1u
M15934 o7 ibias vss vss sky130_fd_pr__nfet_01v8 L=0.5u W=1u
M15935 o7 ibias vss vss sky130_fd_pr__nfet_01v8 L=0.5u W=1u
M15936 o7 ibias vss vss sky130_fd_pr__nfet_01v8 L=0.5u W=1u
M15937 o7 ibias vss vss sky130_fd_pr__nfet_01v8 L=0.5u W=1u
M15938 o7 ibias vss vss sky130_fd_pr__nfet_01v8 L=0.5u W=1u
M15939 o7 ibias vss vss sky130_fd_pr__nfet_01v8 L=0.5u W=1u
M15940 o7 ibias vss vss sky130_fd_pr__nfet_01v8 L=0.5u W=1u
M15941 o7 ibias vss vss sky130_fd_pr__nfet_01v8 L=0.5u W=1u
M15942 o7 ibias vss vss sky130_fd_pr__nfet_01v8 L=0.5u W=1u
M15943 o7 ibias vss vss sky130_fd_pr__nfet_01v8 L=0.5u W=1u
M15944 o7 ibias vss vss sky130_fd_pr__nfet_01v8 L=0.5u W=1u
M15945 o7 ibias vss vss sky130_fd_pr__nfet_01v8 L=0.5u W=1u
M15946 o7 ibias vss vss sky130_fd_pr__nfet_01v8 L=0.5u W=1u
M15947 o7 ibias vss vss sky130_fd_pr__nfet_01v8 L=0.5u W=1u
M15948 o7 ibias vss vss sky130_fd_pr__nfet_01v8 L=0.5u W=1u
M15949 o7 ibias vss vss sky130_fd_pr__nfet_01v8 L=0.5u W=1u
M15950 o7 ibias vss vss sky130_fd_pr__nfet_01v8 L=0.5u W=1u
M15951 o7 ibias vss vss sky130_fd_pr__nfet_01v8 L=0.5u W=1u
M15952 o7 ibias vss vss sky130_fd_pr__nfet_01v8 L=0.5u W=1u
M15953 o7 ibias vss vss sky130_fd_pr__nfet_01v8 L=0.5u W=1u
M15954 o7 ibias vss vss sky130_fd_pr__nfet_01v8 L=0.5u W=1u
M15955 o7 ibias vss vss sky130_fd_pr__nfet_01v8 L=0.5u W=1u
M15956 o7 ibias vss vss sky130_fd_pr__nfet_01v8 L=0.5u W=1u
M15957 o7 ibias vss vss sky130_fd_pr__nfet_01v8 L=0.5u W=1u
M15958 o7 ibias vss vss sky130_fd_pr__nfet_01v8 L=0.5u W=1u
M15959 o7 ibias vss vss sky130_fd_pr__nfet_01v8 L=0.5u W=1u
M15960 o7 ibias vss vss sky130_fd_pr__nfet_01v8 L=0.5u W=1u
M15961 o7 ibias vss vss sky130_fd_pr__nfet_01v8 L=0.5u W=1u
M15962 o7 ibias vss vss sky130_fd_pr__nfet_01v8 L=0.5u W=1u
M15963 o7 ibias vss vss sky130_fd_pr__nfet_01v8 L=0.5u W=1u
M15964 o7 ibias vss vss sky130_fd_pr__nfet_01v8 L=0.5u W=1u
M15965 o7 ibias vss vss sky130_fd_pr__nfet_01v8 L=0.5u W=1u
M15966 o7 ibias vss vss sky130_fd_pr__nfet_01v8 L=0.5u W=1u
M15967 o7 ibias vss vss sky130_fd_pr__nfet_01v8 L=0.5u W=1u
M15968 o7 ibias vss vss sky130_fd_pr__nfet_01v8 L=0.5u W=1u
M15969 o7 ibias vss vss sky130_fd_pr__nfet_01v8 L=0.5u W=1u
M15970 o7 ibias vss vss sky130_fd_pr__nfet_01v8 L=0.5u W=1u
M15971 o7 ibias vss vss sky130_fd_pr__nfet_01v8 L=0.5u W=1u
M15972 o7 ibias vss vss sky130_fd_pr__nfet_01v8 L=0.5u W=1u
M15973 o7 ibias vss vss sky130_fd_pr__nfet_01v8 L=0.5u W=1u
M15974 o7 ibias vss vss sky130_fd_pr__nfet_01v8 L=0.5u W=1u
M15975 o7 ibias vss vss sky130_fd_pr__nfet_01v8 L=0.5u W=1u
M15976 o7 ibias vss vss sky130_fd_pr__nfet_01v8 L=0.5u W=1u
M15977 o7 ibias vss vss sky130_fd_pr__nfet_01v8 L=0.5u W=1u
M15978 o7 ibias vss vss sky130_fd_pr__nfet_01v8 L=0.5u W=1u
M15979 o7 ibias vss vss sky130_fd_pr__nfet_01v8 L=0.5u W=1u
M15980 o7 ibias vss vss sky130_fd_pr__nfet_01v8 L=0.5u W=1u
M15981 o7 ibias vss vss sky130_fd_pr__nfet_01v8 L=0.5u W=1u
M15982 o7 ibias vss vss sky130_fd_pr__nfet_01v8 L=0.5u W=1u
M15983 o7 ibias vss vss sky130_fd_pr__nfet_01v8 L=0.5u W=1u
M15984 o7 ibias vss vss sky130_fd_pr__nfet_01v8 L=0.5u W=1u
M15985 o7 ibias vss vss sky130_fd_pr__nfet_01v8 L=0.5u W=1u
M15986 o7 ibias vss vss sky130_fd_pr__nfet_01v8 L=0.5u W=1u
M15987 o7 ibias vss vss sky130_fd_pr__nfet_01v8 L=0.5u W=1u
M15988 o7 ibias vss vss sky130_fd_pr__nfet_01v8 L=0.5u W=1u
M15989 o7 ibias vss vss sky130_fd_pr__nfet_01v8 L=0.5u W=1u
M15990 o7 ibias vss vss sky130_fd_pr__nfet_01v8 L=0.5u W=1u
M15991 o7 ibias vss vss sky130_fd_pr__nfet_01v8 L=0.5u W=1u
M15992 o7 ibias vss vss sky130_fd_pr__nfet_01v8 L=0.5u W=1u
M15993 o7 ibias vss vss sky130_fd_pr__nfet_01v8 L=0.5u W=1u
M15994 o7 ibias vss vss sky130_fd_pr__nfet_01v8 L=0.5u W=1u
M15995 o7 ibias vss vss sky130_fd_pr__nfet_01v8 L=0.5u W=1u
M15996 o7 ibias vss vss sky130_fd_pr__nfet_01v8 L=0.5u W=1u
M15997 o7 ibias vss vss sky130_fd_pr__nfet_01v8 L=0.5u W=1u
M15998 o7 ibias vss vss sky130_fd_pr__nfet_01v8 L=0.5u W=1u
M15999 o7 ibias vss vss sky130_fd_pr__nfet_01v8 L=0.5u W=1u
M16000 o7 ibias vss vss sky130_fd_pr__nfet_01v8 L=0.5u W=1u
M16001 o7 ibias vss vss sky130_fd_pr__nfet_01v8 L=0.5u W=1u
M16002 o7 ibias vss vss sky130_fd_pr__nfet_01v8 L=0.5u W=1u
M16003 o7 ibias vss vss sky130_fd_pr__nfet_01v8 L=0.5u W=1u
M16004 o7 ibias vss vss sky130_fd_pr__nfet_01v8 L=0.5u W=1u
M16005 o7 ibias vss vss sky130_fd_pr__nfet_01v8 L=0.5u W=1u
M16006 o7 ibias vss vss sky130_fd_pr__nfet_01v8 L=0.5u W=1u
M16007 o7 ibias vss vss sky130_fd_pr__nfet_01v8 L=0.5u W=1u
M16008 o7 ibias vss vss sky130_fd_pr__nfet_01v8 L=0.5u W=1u
M16009 o7 ibias vss vss sky130_fd_pr__nfet_01v8 L=0.5u W=1u
M16010 o7 ibias vss vss sky130_fd_pr__nfet_01v8 L=0.5u W=1u
M16011 o7 ibias vss vss sky130_fd_pr__nfet_01v8 L=0.5u W=1u
M16012 o7 ibias vss vss sky130_fd_pr__nfet_01v8 L=0.5u W=1u
M16013 o7 ibias vss vss sky130_fd_pr__nfet_01v8 L=0.5u W=1u
M16014 o7 ibias vss vss sky130_fd_pr__nfet_01v8 L=0.5u W=1u
M16015 o7 ibias vss vss sky130_fd_pr__nfet_01v8 L=0.5u W=1u
M16016 o7 ibias vss vss sky130_fd_pr__nfet_01v8 L=0.5u W=1u
M16017 o7 ibias vss vss sky130_fd_pr__nfet_01v8 L=0.5u W=1u
M16018 o7 ibias vss vss sky130_fd_pr__nfet_01v8 L=0.5u W=1u
M16019 o7 ibias vss vss sky130_fd_pr__nfet_01v8 L=0.5u W=1u
M16020 o7 ibias vss vss sky130_fd_pr__nfet_01v8 L=0.5u W=1u
M16021 o7 ibias vss vss sky130_fd_pr__nfet_01v8 L=0.5u W=1u
M16022 o7 ibias vss vss sky130_fd_pr__nfet_01v8 L=0.5u W=1u
M16023 o7 ibias vss vss sky130_fd_pr__nfet_01v8 L=0.5u W=1u
M16024 o7 ibias vss vss sky130_fd_pr__nfet_01v8 L=0.5u W=1u
M16025 o7 ibias vss vss sky130_fd_pr__nfet_01v8 L=0.5u W=1u
M16026 o7 ibias vss vss sky130_fd_pr__nfet_01v8 L=0.5u W=1u
M16027 o7 ibias vss vss sky130_fd_pr__nfet_01v8 L=0.5u W=1u
M16028 o7 ibias vss vss sky130_fd_pr__nfet_01v8 L=0.5u W=1u
M16029 o7 ibias vss vss sky130_fd_pr__nfet_01v8 L=0.5u W=1u
M16030 o7 ibias vss vss sky130_fd_pr__nfet_01v8 L=0.5u W=1u
M16031 o7 ibias vss vss sky130_fd_pr__nfet_01v8 L=0.5u W=1u
M16032 o7 ibias vss vss sky130_fd_pr__nfet_01v8 L=0.5u W=1u
M16033 o7 ibias vss vss sky130_fd_pr__nfet_01v8 L=0.5u W=1u
M16034 o7 ibias vss vss sky130_fd_pr__nfet_01v8 L=0.5u W=1u
M16035 o7 ibias vss vss sky130_fd_pr__nfet_01v8 L=0.5u W=1u
M16036 o7 ibias vss vss sky130_fd_pr__nfet_01v8 L=0.5u W=1u
M16037 o7 ibias vss vss sky130_fd_pr__nfet_01v8 L=0.5u W=1u
M16038 o7 ibias vss vss sky130_fd_pr__nfet_01v8 L=0.5u W=1u
M16039 o7 ibias vss vss sky130_fd_pr__nfet_01v8 L=0.5u W=1u
M16040 o7 ibias vss vss sky130_fd_pr__nfet_01v8 L=0.5u W=1u
M16041 o7 ibias vss vss sky130_fd_pr__nfet_01v8 L=0.5u W=1u
M16042 o7 ibias vss vss sky130_fd_pr__nfet_01v8 L=0.5u W=1u
M16043 o7 ibias vss vss sky130_fd_pr__nfet_01v8 L=0.5u W=1u
M16044 o7 ibias vss vss sky130_fd_pr__nfet_01v8 L=0.5u W=1u
M16045 o7 ibias vss vss sky130_fd_pr__nfet_01v8 L=0.5u W=1u
M16046 o7 ibias vss vss sky130_fd_pr__nfet_01v8 L=0.5u W=1u
M16047 o7 ibias vss vss sky130_fd_pr__nfet_01v8 L=0.5u W=1u
M16048 o7 ibias vss vss sky130_fd_pr__nfet_01v8 L=0.5u W=1u
M16049 o7 ibias vss vss sky130_fd_pr__nfet_01v8 L=0.5u W=1u
M16050 o7 ibias vss vss sky130_fd_pr__nfet_01v8 L=0.5u W=1u
M16051 o7 ibias vss vss sky130_fd_pr__nfet_01v8 L=0.5u W=1u
M16052 o7 ibias vss vss sky130_fd_pr__nfet_01v8 L=0.5u W=1u
M16053 o7 ibias vss vss sky130_fd_pr__nfet_01v8 L=0.5u W=1u
M16054 o7 ibias vss vss sky130_fd_pr__nfet_01v8 L=0.5u W=1u
M16055 o7 ibias vss vss sky130_fd_pr__nfet_01v8 L=0.5u W=1u
M16056 o7 ibias vss vss sky130_fd_pr__nfet_01v8 L=0.5u W=1u
M16057 o7 ibias vss vss sky130_fd_pr__nfet_01v8 L=0.5u W=1u
M16058 o7 ibias vss vss sky130_fd_pr__nfet_01v8 L=0.5u W=1u
M16059 o7 ibias vss vss sky130_fd_pr__nfet_01v8 L=0.5u W=1u
M16060 o7 ibias vss vss sky130_fd_pr__nfet_01v8 L=0.5u W=1u
M16061 o7 ibias vss vss sky130_fd_pr__nfet_01v8 L=0.5u W=1u
M16062 o7 ibias vss vss sky130_fd_pr__nfet_01v8 L=0.5u W=1u
M16063 o7 ibias vss vss sky130_fd_pr__nfet_01v8 L=0.5u W=1u
M16064 o7 ibias vss vss sky130_fd_pr__nfet_01v8 L=0.5u W=1u
M16065 o7 ibias vss vss sky130_fd_pr__nfet_01v8 L=0.5u W=1u
M16066 o7 ibias vss vss sky130_fd_pr__nfet_01v8 L=0.5u W=1u
M16067 o7 ibias vss vss sky130_fd_pr__nfet_01v8 L=0.5u W=1u
M16068 o7 ibias vss vss sky130_fd_pr__nfet_01v8 L=0.5u W=1u
M16069 o7 ibias vss vss sky130_fd_pr__nfet_01v8 L=0.5u W=1u
M16070 o7 ibias vss vss sky130_fd_pr__nfet_01v8 L=0.5u W=1u
M16071 o7 ibias vss vss sky130_fd_pr__nfet_01v8 L=0.5u W=1u
M16072 o7 ibias vss vss sky130_fd_pr__nfet_01v8 L=0.5u W=1u
M16073 o7 ibias vss vss sky130_fd_pr__nfet_01v8 L=0.5u W=1u
M16074 o7 ibias vss vss sky130_fd_pr__nfet_01v8 L=0.5u W=1u
M16075 o7 ibias vss vss sky130_fd_pr__nfet_01v8 L=0.5u W=1u
M16076 o7 ibias vss vss sky130_fd_pr__nfet_01v8 L=0.5u W=1u
M16077 o7 ibias vss vss sky130_fd_pr__nfet_01v8 L=0.5u W=1u
M16078 o7 ibias vss vss sky130_fd_pr__nfet_01v8 L=0.5u W=1u
M16079 o7 ibias vss vss sky130_fd_pr__nfet_01v8 L=0.5u W=1u
M16080 o7 ibias vss vss sky130_fd_pr__nfet_01v8 L=0.5u W=1u
M16081 o7 ibias vss vss sky130_fd_pr__nfet_01v8 L=0.5u W=1u
M16082 o7 ibias vss vss sky130_fd_pr__nfet_01v8 L=0.5u W=1u
M16083 o7 ibias vss vss sky130_fd_pr__nfet_01v8 L=0.5u W=1u
M16084 o7 ibias vss vss sky130_fd_pr__nfet_01v8 L=0.5u W=1u
M16085 o7 ibias vss vss sky130_fd_pr__nfet_01v8 L=0.5u W=1u
M16086 o7 ibias vss vss sky130_fd_pr__nfet_01v8 L=0.5u W=1u
M16087 o7 ibias vss vss sky130_fd_pr__nfet_01v8 L=0.5u W=1u
M16088 o7 ibias vss vss sky130_fd_pr__nfet_01v8 L=0.5u W=1u
M16089 o7 ibias vss vss sky130_fd_pr__nfet_01v8 L=0.5u W=1u
M16090 o7 ibias vss vss sky130_fd_pr__nfet_01v8 L=0.5u W=1u
M16091 o7 ibias vss vss sky130_fd_pr__nfet_01v8 L=0.5u W=1u
M16092 o7 ibias vss vss sky130_fd_pr__nfet_01v8 L=0.5u W=1u
M16093 o7 ibias vss vss sky130_fd_pr__nfet_01v8 L=0.5u W=1u
M16094 o7 ibias vss vss sky130_fd_pr__nfet_01v8 L=0.5u W=1u
M16095 o7 ibias vss vss sky130_fd_pr__nfet_01v8 L=0.5u W=1u
M16096 o7 ibias vss vss sky130_fd_pr__nfet_01v8 L=0.5u W=1u
M16097 o7 ibias vss vss sky130_fd_pr__nfet_01v8 L=0.5u W=1u
M16098 o7 ibias vss vss sky130_fd_pr__nfet_01v8 L=0.5u W=1u
M16099 o7 ibias vss vss sky130_fd_pr__nfet_01v8 L=0.5u W=1u
M16100 o7 ibias vss vss sky130_fd_pr__nfet_01v8 L=0.5u W=1u
M16101 o7 ibias vss vss sky130_fd_pr__nfet_01v8 L=0.5u W=1u
M16102 o7 ibias vss vss sky130_fd_pr__nfet_01v8 L=0.5u W=1u
M16103 o7 ibias vss vss sky130_fd_pr__nfet_01v8 L=0.5u W=1u
M16104 o7 ibias vss vss sky130_fd_pr__nfet_01v8 L=0.5u W=1u
M16105 o7 ibias vss vss sky130_fd_pr__nfet_01v8 L=0.5u W=1u
M16106 o7 ibias vss vss sky130_fd_pr__nfet_01v8 L=0.5u W=1u
M16107 o7 ibias vss vss sky130_fd_pr__nfet_01v8 L=0.5u W=1u
M16108 o7 ibias vss vss sky130_fd_pr__nfet_01v8 L=0.5u W=1u
M16109 o7 ibias vss vss sky130_fd_pr__nfet_01v8 L=0.5u W=1u
M16110 o7 ibias vss vss sky130_fd_pr__nfet_01v8 L=0.5u W=1u
M16111 o7 ibias vss vss sky130_fd_pr__nfet_01v8 L=0.5u W=1u
M16112 o7 ibias vss vss sky130_fd_pr__nfet_01v8 L=0.5u W=1u
M16113 o7 ibias vss vss sky130_fd_pr__nfet_01v8 L=0.5u W=1u
M16114 o7 ibias vss vss sky130_fd_pr__nfet_01v8 L=0.5u W=1u
M16115 o7 ibias vss vss sky130_fd_pr__nfet_01v8 L=0.5u W=1u
M16116 o7 ibias vss vss sky130_fd_pr__nfet_01v8 L=0.5u W=1u
M16117 o7 ibias vss vss sky130_fd_pr__nfet_01v8 L=0.5u W=1u
M16118 o7 ibias vss vss sky130_fd_pr__nfet_01v8 L=0.5u W=1u
M16119 o7 ibias vss vss sky130_fd_pr__nfet_01v8 L=0.5u W=1u
M16120 o7 ibias vss vss sky130_fd_pr__nfet_01v8 L=0.5u W=1u
M16121 o7 ibias vss vss sky130_fd_pr__nfet_01v8 L=0.5u W=1u
M16122 o7 ibias vss vss sky130_fd_pr__nfet_01v8 L=0.5u W=1u
M16123 o7 ibias vss vss sky130_fd_pr__nfet_01v8 L=0.5u W=1u
M16124 o7 ibias vss vss sky130_fd_pr__nfet_01v8 L=0.5u W=1u
M16125 o7 ibias vss vss sky130_fd_pr__nfet_01v8 L=0.5u W=1u
M16126 o7 ibias vss vss sky130_fd_pr__nfet_01v8 L=0.5u W=1u
M16127 o7 ibias vss vss sky130_fd_pr__nfet_01v8 L=0.5u W=1u
M16128 o7 ibias vss vss sky130_fd_pr__nfet_01v8 L=0.5u W=1u
M16129 o7 ibias vss vss sky130_fd_pr__nfet_01v8 L=0.5u W=1u
M16130 o7 ibias vss vss sky130_fd_pr__nfet_01v8 L=0.5u W=1u
M16131 o7 ibias vss vss sky130_fd_pr__nfet_01v8 L=0.5u W=1u
M16132 o7 ibias vss vss sky130_fd_pr__nfet_01v8 L=0.5u W=1u
M16133 o7 ibias vss vss sky130_fd_pr__nfet_01v8 L=0.5u W=1u
M16134 o7 ibias vss vss sky130_fd_pr__nfet_01v8 L=0.5u W=1u
M16135 o7 ibias vss vss sky130_fd_pr__nfet_01v8 L=0.5u W=1u
M16136 o7 ibias vss vss sky130_fd_pr__nfet_01v8 L=0.5u W=1u
M16137 o7 ibias vss vss sky130_fd_pr__nfet_01v8 L=0.5u W=1u
M16138 o7 ibias vss vss sky130_fd_pr__nfet_01v8 L=0.5u W=1u
M16139 o7 ibias vss vss sky130_fd_pr__nfet_01v8 L=0.5u W=1u
M16140 o7 ibias vss vss sky130_fd_pr__nfet_01v8 L=0.5u W=1u
M16141 o7 ibias vss vss sky130_fd_pr__nfet_01v8 L=0.5u W=1u
M16142 o7 ibias vss vss sky130_fd_pr__nfet_01v8 L=0.5u W=1u
M16143 o7 ibias vss vss sky130_fd_pr__nfet_01v8 L=0.5u W=1u
M16144 o7 ibias vss vss sky130_fd_pr__nfet_01v8 L=0.5u W=1u
M16145 o7 ibias vss vss sky130_fd_pr__nfet_01v8 L=0.5u W=1u
M16146 o7 ibias vss vss sky130_fd_pr__nfet_01v8 L=0.5u W=1u
M16147 o7 ibias vss vss sky130_fd_pr__nfet_01v8 L=0.5u W=1u
M16148 o7 ibias vss vss sky130_fd_pr__nfet_01v8 L=0.5u W=1u
M16149 o7 ibias vss vss sky130_fd_pr__nfet_01v8 L=0.5u W=1u
M16150 o7 ibias vss vss sky130_fd_pr__nfet_01v8 L=0.5u W=1u
M16151 o7 ibias vss vss sky130_fd_pr__nfet_01v8 L=0.5u W=1u
M16152 o7 ibias vss vss sky130_fd_pr__nfet_01v8 L=0.5u W=1u
M16153 o7 ibias vss vss sky130_fd_pr__nfet_01v8 L=0.5u W=1u
M16154 o7 ibias vss vss sky130_fd_pr__nfet_01v8 L=0.5u W=1u
M16155 o7 ibias vss vss sky130_fd_pr__nfet_01v8 L=0.5u W=1u
M16156 o7 ibias vss vss sky130_fd_pr__nfet_01v8 L=0.5u W=1u
M16157 o7 ibias vss vss sky130_fd_pr__nfet_01v8 L=0.5u W=1u
M16158 o7 ibias vss vss sky130_fd_pr__nfet_01v8 L=0.5u W=1u
M16159 o7 ibias vss vss sky130_fd_pr__nfet_01v8 L=0.5u W=1u
M16160 o7 ibias vss vss sky130_fd_pr__nfet_01v8 L=0.5u W=1u
M16161 o7 ibias vss vss sky130_fd_pr__nfet_01v8 L=0.5u W=1u
M16162 o7 ibias vss vss sky130_fd_pr__nfet_01v8 L=0.5u W=1u
M16163 o7 ibias vss vss sky130_fd_pr__nfet_01v8 L=0.5u W=1u
M16164 o7 ibias vss vss sky130_fd_pr__nfet_01v8 L=0.5u W=1u
M16165 o7 ibias vss vss sky130_fd_pr__nfet_01v8 L=0.5u W=1u
M16166 o7 ibias vss vss sky130_fd_pr__nfet_01v8 L=0.5u W=1u
M16167 o7 ibias vss vss sky130_fd_pr__nfet_01v8 L=0.5u W=1u
M16168 o7 ibias vss vss sky130_fd_pr__nfet_01v8 L=0.5u W=1u
M16169 o7 ibias vss vss sky130_fd_pr__nfet_01v8 L=0.5u W=1u
M16170 o7 ibias vss vss sky130_fd_pr__nfet_01v8 L=0.5u W=1u
M16171 o7 ibias vss vss sky130_fd_pr__nfet_01v8 L=0.5u W=1u
M16172 o7 ibias vss vss sky130_fd_pr__nfet_01v8 L=0.5u W=1u
M16173 o7 ibias vss vss sky130_fd_pr__nfet_01v8 L=0.5u W=1u
M16174 o7 ibias vss vss sky130_fd_pr__nfet_01v8 L=0.5u W=1u
M16175 o7 ibias vss vss sky130_fd_pr__nfet_01v8 L=0.5u W=1u
M16176 o7 ibias vss vss sky130_fd_pr__nfet_01v8 L=0.5u W=1u
M16177 o7 ibias vss vss sky130_fd_pr__nfet_01v8 L=0.5u W=1u
M16178 o7 ibias vss vss sky130_fd_pr__nfet_01v8 L=0.5u W=1u
M16179 o7 ibias vss vss sky130_fd_pr__nfet_01v8 L=0.5u W=1u
M16180 o7 ibias vss vss sky130_fd_pr__nfet_01v8 L=0.5u W=1u
M16181 o7 ibias vss vss sky130_fd_pr__nfet_01v8 L=0.5u W=1u
M16182 o7 ibias vss vss sky130_fd_pr__nfet_01v8 L=0.5u W=1u
M16183 o7 ibias vss vss sky130_fd_pr__nfet_01v8 L=0.5u W=1u
M16184 o7 ibias vss vss sky130_fd_pr__nfet_01v8 L=0.5u W=1u
M16185 o7 ibias vss vss sky130_fd_pr__nfet_01v8 L=0.5u W=1u
M16186 o7 ibias vss vss sky130_fd_pr__nfet_01v8 L=0.5u W=1u
M16187 o7 ibias vss vss sky130_fd_pr__nfet_01v8 L=0.5u W=1u
M16188 o7 ibias vss vss sky130_fd_pr__nfet_01v8 L=0.5u W=1u
M16189 o7 ibias vss vss sky130_fd_pr__nfet_01v8 L=0.5u W=1u
M16190 o7 ibias vss vss sky130_fd_pr__nfet_01v8 L=0.5u W=1u
M16191 o7 ibias vss vss sky130_fd_pr__nfet_01v8 L=0.5u W=1u
M16192 o7 ibias vss vss sky130_fd_pr__nfet_01v8 L=0.5u W=1u
M16193 o7 ibias vss vss sky130_fd_pr__nfet_01v8 L=0.5u W=1u
M16194 o7 ibias vss vss sky130_fd_pr__nfet_01v8 L=0.5u W=1u
M16195 o7 ibias vss vss sky130_fd_pr__nfet_01v8 L=0.5u W=1u
M16196 o7 ibias vss vss sky130_fd_pr__nfet_01v8 L=0.5u W=1u
M16197 o7 ibias vss vss sky130_fd_pr__nfet_01v8 L=0.5u W=1u
M16198 o7 ibias vss vss sky130_fd_pr__nfet_01v8 L=0.5u W=1u
M16199 o7 ibias vss vss sky130_fd_pr__nfet_01v8 L=0.5u W=1u
M16200 o7 ibias vss vss sky130_fd_pr__nfet_01v8 L=0.5u W=1u
M16201 o7 ibias vss vss sky130_fd_pr__nfet_01v8 L=0.5u W=1u
M16202 o7 ibias vss vss sky130_fd_pr__nfet_01v8 L=0.5u W=1u
M16203 o7 ibias vss vss sky130_fd_pr__nfet_01v8 L=0.5u W=1u
M16204 o7 ibias vss vss sky130_fd_pr__nfet_01v8 L=0.5u W=1u
M16205 o7 ibias vss vss sky130_fd_pr__nfet_01v8 L=0.5u W=1u
M16206 o7 ibias vss vss sky130_fd_pr__nfet_01v8 L=0.5u W=1u
M16207 o7 ibias vss vss sky130_fd_pr__nfet_01v8 L=0.5u W=1u
M16208 o7 ibias vss vss sky130_fd_pr__nfet_01v8 L=0.5u W=1u
M16209 o7 ibias vss vss sky130_fd_pr__nfet_01v8 L=0.5u W=1u
M16210 o7 ibias vss vss sky130_fd_pr__nfet_01v8 L=0.5u W=1u
M16211 o7 ibias vss vss sky130_fd_pr__nfet_01v8 L=0.5u W=1u
M16212 o7 ibias vss vss sky130_fd_pr__nfet_01v8 L=0.5u W=1u
M16213 o7 ibias vss vss sky130_fd_pr__nfet_01v8 L=0.5u W=1u
M16214 o7 ibias vss vss sky130_fd_pr__nfet_01v8 L=0.5u W=1u
M16215 o7 ibias vss vss sky130_fd_pr__nfet_01v8 L=0.5u W=1u
M16216 o7 ibias vss vss sky130_fd_pr__nfet_01v8 L=0.5u W=1u
M16217 o7 ibias vss vss sky130_fd_pr__nfet_01v8 L=0.5u W=1u
M16218 o7 ibias vss vss sky130_fd_pr__nfet_01v8 L=0.5u W=1u
M16219 o7 ibias vss vss sky130_fd_pr__nfet_01v8 L=0.5u W=1u
M16220 o7 ibias vss vss sky130_fd_pr__nfet_01v8 L=0.5u W=1u
M16221 o7 ibias vss vss sky130_fd_pr__nfet_01v8 L=0.5u W=1u
M16222 o7 ibias vss vss sky130_fd_pr__nfet_01v8 L=0.5u W=1u
M16223 o7 ibias vss vss sky130_fd_pr__nfet_01v8 L=0.5u W=1u
M16224 o7 ibias vss vss sky130_fd_pr__nfet_01v8 L=0.5u W=1u
M16225 o7 ibias vss vss sky130_fd_pr__nfet_01v8 L=0.5u W=1u
M16226 o7 ibias vss vss sky130_fd_pr__nfet_01v8 L=0.5u W=1u
M16227 o7 ibias vss vss sky130_fd_pr__nfet_01v8 L=0.5u W=1u
M16228 o7 ibias vss vss sky130_fd_pr__nfet_01v8 L=0.5u W=1u
M16229 o7 ibias vss vss sky130_fd_pr__nfet_01v8 L=0.5u W=1u
M16230 o7 ibias vss vss sky130_fd_pr__nfet_01v8 L=0.5u W=1u
M16231 o7 ibias vss vss sky130_fd_pr__nfet_01v8 L=0.5u W=1u
M16232 o7 ibias vss vss sky130_fd_pr__nfet_01v8 L=0.5u W=1u
M16233 o7 ibias vss vss sky130_fd_pr__nfet_01v8 L=0.5u W=1u
M16234 o7 ibias vss vss sky130_fd_pr__nfet_01v8 L=0.5u W=1u
M16235 o7 ibias vss vss sky130_fd_pr__nfet_01v8 L=0.5u W=1u
M16236 o7 ibias vss vss sky130_fd_pr__nfet_01v8 L=0.5u W=1u
M16237 o7 ibias vss vss sky130_fd_pr__nfet_01v8 L=0.5u W=1u
M16238 o7 ibias vss vss sky130_fd_pr__nfet_01v8 L=0.5u W=1u
M16239 o7 ibias vss vss sky130_fd_pr__nfet_01v8 L=0.5u W=1u
M16240 o7 ibias vss vss sky130_fd_pr__nfet_01v8 L=0.5u W=1u
M16241 o7 ibias vss vss sky130_fd_pr__nfet_01v8 L=0.5u W=1u
M16242 o7 ibias vss vss sky130_fd_pr__nfet_01v8 L=0.5u W=1u
M16243 o7 ibias vss vss sky130_fd_pr__nfet_01v8 L=0.5u W=1u
M16244 o7 ibias vss vss sky130_fd_pr__nfet_01v8 L=0.5u W=1u
M16245 o7 ibias vss vss sky130_fd_pr__nfet_01v8 L=0.5u W=1u
M16246 o7 ibias vss vss sky130_fd_pr__nfet_01v8 L=0.5u W=1u
M16247 o7 ibias vss vss sky130_fd_pr__nfet_01v8 L=0.5u W=1u
M16248 o7 ibias vss vss sky130_fd_pr__nfet_01v8 L=0.5u W=1u
M16249 o7 ibias vss vss sky130_fd_pr__nfet_01v8 L=0.5u W=1u
M16250 o7 ibias vss vss sky130_fd_pr__nfet_01v8 L=0.5u W=1u
M16251 o7 ibias vss vss sky130_fd_pr__nfet_01v8 L=0.5u W=1u
M16252 o7 ibias vss vss sky130_fd_pr__nfet_01v8 L=0.5u W=1u
M16253 o7 ibias vss vss sky130_fd_pr__nfet_01v8 L=0.5u W=1u
M16254 o7 ibias vss vss sky130_fd_pr__nfet_01v8 L=0.5u W=1u
M16255 o7 ibias vss vss sky130_fd_pr__nfet_01v8 L=0.5u W=1u
M16256 o7 ibias vss vss sky130_fd_pr__nfet_01v8 L=0.5u W=1u
M16257 o7 ibias vss vss sky130_fd_pr__nfet_01v8 L=0.5u W=1u
M16258 o7 ibias vss vss sky130_fd_pr__nfet_01v8 L=0.5u W=1u
M16259 o7 ibias vss vss sky130_fd_pr__nfet_01v8 L=0.5u W=1u
M16260 o7 ibias vss vss sky130_fd_pr__nfet_01v8 L=0.5u W=1u
M16261 o7 ibias vss vss sky130_fd_pr__nfet_01v8 L=0.5u W=1u
M16262 o7 ibias vss vss sky130_fd_pr__nfet_01v8 L=0.5u W=1u
M16263 o7 ibias vss vss sky130_fd_pr__nfet_01v8 L=0.5u W=1u
M16264 o7 ibias vss vss sky130_fd_pr__nfet_01v8 L=0.5u W=1u
M16265 o7 ibias vss vss sky130_fd_pr__nfet_01v8 L=0.5u W=1u
M16266 o7 ibias vss vss sky130_fd_pr__nfet_01v8 L=0.5u W=1u
M16267 o7 ibias vss vss sky130_fd_pr__nfet_01v8 L=0.5u W=1u
M16268 o7 ibias vss vss sky130_fd_pr__nfet_01v8 L=0.5u W=1u
M16269 o7 ibias vss vss sky130_fd_pr__nfet_01v8 L=0.5u W=1u
M16270 o7 ibias vss vss sky130_fd_pr__nfet_01v8 L=0.5u W=1u
M16271 o7 ibias vss vss sky130_fd_pr__nfet_01v8 L=0.5u W=1u
M16272 o7 ibias vss vss sky130_fd_pr__nfet_01v8 L=0.5u W=1u
M16273 o7 ibias vss vss sky130_fd_pr__nfet_01v8 L=0.5u W=1u
M16274 o7 ibias vss vss sky130_fd_pr__nfet_01v8 L=0.5u W=1u
M16275 o7 ibias vss vss sky130_fd_pr__nfet_01v8 L=0.5u W=1u
M16276 o7 ibias vss vss sky130_fd_pr__nfet_01v8 L=0.5u W=1u
M16277 o7 ibias vss vss sky130_fd_pr__nfet_01v8 L=0.5u W=1u
M16278 o7 ibias vss vss sky130_fd_pr__nfet_01v8 L=0.5u W=1u
M16279 o7 ibias vss vss sky130_fd_pr__nfet_01v8 L=0.5u W=1u
M16280 o7 ibias vss vss sky130_fd_pr__nfet_01v8 L=0.5u W=1u
M16281 o7 ibias vss vss sky130_fd_pr__nfet_01v8 L=0.5u W=1u
M16282 o7 ibias vss vss sky130_fd_pr__nfet_01v8 L=0.5u W=1u
M16283 o7 ibias vss vss sky130_fd_pr__nfet_01v8 L=0.5u W=1u
M16284 o7 ibias vss vss sky130_fd_pr__nfet_01v8 L=0.5u W=1u
M16285 o7 ibias vss vss sky130_fd_pr__nfet_01v8 L=0.5u W=1u
M16286 o7 ibias vss vss sky130_fd_pr__nfet_01v8 L=0.5u W=1u
M16287 o7 ibias vss vss sky130_fd_pr__nfet_01v8 L=0.5u W=1u
M16288 o7 ibias vss vss sky130_fd_pr__nfet_01v8 L=0.5u W=1u
M16289 o7 ibias vss vss sky130_fd_pr__nfet_01v8 L=0.5u W=1u
M16290 o7 ibias vss vss sky130_fd_pr__nfet_01v8 L=0.5u W=1u
M16291 o7 ibias vss vss sky130_fd_pr__nfet_01v8 L=0.5u W=1u
M16292 o7 ibias vss vss sky130_fd_pr__nfet_01v8 L=0.5u W=1u
M16293 o7 ibias vss vss sky130_fd_pr__nfet_01v8 L=0.5u W=1u
M16294 o7 ibias vss vss sky130_fd_pr__nfet_01v8 L=0.5u W=1u
M16295 o7 ibias vss vss sky130_fd_pr__nfet_01v8 L=0.5u W=1u
M16296 o7 ibias vss vss sky130_fd_pr__nfet_01v8 L=0.5u W=1u
M16297 o7 ibias vss vss sky130_fd_pr__nfet_01v8 L=0.5u W=1u
M16298 o7 ibias vss vss sky130_fd_pr__nfet_01v8 L=0.5u W=1u
M16299 o7 ibias vss vss sky130_fd_pr__nfet_01v8 L=0.5u W=1u
M16300 o7 ibias vss vss sky130_fd_pr__nfet_01v8 L=0.5u W=1u
M16301 o7 ibias vss vss sky130_fd_pr__nfet_01v8 L=0.5u W=1u
M16302 o7 ibias vss vss sky130_fd_pr__nfet_01v8 L=0.5u W=1u
M16303 o7 ibias vss vss sky130_fd_pr__nfet_01v8 L=0.5u W=1u
M16304 o7 ibias vss vss sky130_fd_pr__nfet_01v8 L=0.5u W=1u
M16305 o7 ibias vss vss sky130_fd_pr__nfet_01v8 L=0.5u W=1u
M16306 o7 ibias vss vss sky130_fd_pr__nfet_01v8 L=0.5u W=1u
M16307 o7 ibias vss vss sky130_fd_pr__nfet_01v8 L=0.5u W=1u
M16308 o7 ibias vss vss sky130_fd_pr__nfet_01v8 L=0.5u W=1u
M16309 o7 ibias vss vss sky130_fd_pr__nfet_01v8 L=0.5u W=1u
M16310 o7 ibias vss vss sky130_fd_pr__nfet_01v8 L=0.5u W=1u
M16311 o7 ibias vss vss sky130_fd_pr__nfet_01v8 L=0.5u W=1u
M16312 o7 ibias vss vss sky130_fd_pr__nfet_01v8 L=0.5u W=1u
M16313 o7 ibias vss vss sky130_fd_pr__nfet_01v8 L=0.5u W=1u
M16314 o7 ibias vss vss sky130_fd_pr__nfet_01v8 L=0.5u W=1u
M16315 o7 ibias vss vss sky130_fd_pr__nfet_01v8 L=0.5u W=1u
M16316 o7 ibias vss vss sky130_fd_pr__nfet_01v8 L=0.5u W=1u
M16317 o7 ibias vss vss sky130_fd_pr__nfet_01v8 L=0.5u W=1u
M16318 o7 ibias vss vss sky130_fd_pr__nfet_01v8 L=0.5u W=1u
M16319 o7 ibias vss vss sky130_fd_pr__nfet_01v8 L=0.5u W=1u
M16320 o7 ibias vss vss sky130_fd_pr__nfet_01v8 L=0.5u W=1u
M16321 o7 ibias vss vss sky130_fd_pr__nfet_01v8 L=0.5u W=1u
M16322 o7 ibias vss vss sky130_fd_pr__nfet_01v8 L=0.5u W=1u
M16323 o7 ibias vss vss sky130_fd_pr__nfet_01v8 L=0.5u W=1u
M16324 o7 ibias vss vss sky130_fd_pr__nfet_01v8 L=0.5u W=1u
M16325 o7 ibias vss vss sky130_fd_pr__nfet_01v8 L=0.5u W=1u
M16326 o7 ibias vss vss sky130_fd_pr__nfet_01v8 L=0.5u W=1u
M16327 o7 ibias vss vss sky130_fd_pr__nfet_01v8 L=0.5u W=1u
M16328 o7 ibias vss vss sky130_fd_pr__nfet_01v8 L=0.5u W=1u
M16329 o7 ibias vss vss sky130_fd_pr__nfet_01v8 L=0.5u W=1u
M16330 o7 ibias vss vss sky130_fd_pr__nfet_01v8 L=0.5u W=1u
M16331 o7 ibias vss vss sky130_fd_pr__nfet_01v8 L=0.5u W=1u
M16332 o7 ibias vss vss sky130_fd_pr__nfet_01v8 L=0.5u W=1u
M16333 o7 ibias vss vss sky130_fd_pr__nfet_01v8 L=0.5u W=1u
M16334 o7 ibias vss vss sky130_fd_pr__nfet_01v8 L=0.5u W=1u
M16335 o7 ibias vss vss sky130_fd_pr__nfet_01v8 L=0.5u W=1u
M16336 o7 ibias vss vss sky130_fd_pr__nfet_01v8 L=0.5u W=1u
M16337 o7 ibias vss vss sky130_fd_pr__nfet_01v8 L=0.5u W=1u
M16338 o7 ibias vss vss sky130_fd_pr__nfet_01v8 L=0.5u W=1u
M16339 o7 ibias vss vss sky130_fd_pr__nfet_01v8 L=0.5u W=1u
M16340 o7 ibias vss vss sky130_fd_pr__nfet_01v8 L=0.5u W=1u
M16341 o7 ibias vss vss sky130_fd_pr__nfet_01v8 L=0.5u W=1u
M16342 o7 ibias vss vss sky130_fd_pr__nfet_01v8 L=0.5u W=1u
M16343 o7 ibias vss vss sky130_fd_pr__nfet_01v8 L=0.5u W=1u
M16344 o7 ibias vss vss sky130_fd_pr__nfet_01v8 L=0.5u W=1u
M16345 o7 ibias vss vss sky130_fd_pr__nfet_01v8 L=0.5u W=1u
M16346 o7 ibias vss vss sky130_fd_pr__nfet_01v8 L=0.5u W=1u
M16347 o7 ibias vss vss sky130_fd_pr__nfet_01v8 L=0.5u W=1u
M16348 o7 ibias vss vss sky130_fd_pr__nfet_01v8 L=0.5u W=1u
M16349 o7 ibias vss vss sky130_fd_pr__nfet_01v8 L=0.5u W=1u
M16350 o7 ibias vss vss sky130_fd_pr__nfet_01v8 L=0.5u W=1u
M16351 o7 ibias vss vss sky130_fd_pr__nfet_01v8 L=0.5u W=1u
M16352 o7 ibias vss vss sky130_fd_pr__nfet_01v8 L=0.5u W=1u
M16353 o7 ibias vss vss sky130_fd_pr__nfet_01v8 L=0.5u W=1u
M16354 o7 ibias vss vss sky130_fd_pr__nfet_01v8 L=0.5u W=1u
M16355 o7 ibias vss vss sky130_fd_pr__nfet_01v8 L=0.5u W=1u
M16356 o7 ibias vss vss sky130_fd_pr__nfet_01v8 L=0.5u W=1u
M16357 o7 ibias vss vss sky130_fd_pr__nfet_01v8 L=0.5u W=1u
M16358 o7 ibias vss vss sky130_fd_pr__nfet_01v8 L=0.5u W=1u
M16359 o7 ibias vss vss sky130_fd_pr__nfet_01v8 L=0.5u W=1u
M16360 o7 ibias vss vss sky130_fd_pr__nfet_01v8 L=0.5u W=1u
M16361 o7 ibias vss vss sky130_fd_pr__nfet_01v8 L=0.5u W=1u
M16362 o7 ibias vss vss sky130_fd_pr__nfet_01v8 L=0.5u W=1u
M16363 o7 ibias vss vss sky130_fd_pr__nfet_01v8 L=0.5u W=1u
M16364 o7 ibias vss vss sky130_fd_pr__nfet_01v8 L=0.5u W=1u
M16365 o7 ibias vss vss sky130_fd_pr__nfet_01v8 L=0.5u W=1u
M16366 o7 ibias vss vss sky130_fd_pr__nfet_01v8 L=0.5u W=1u
M16367 o7 ibias vss vss sky130_fd_pr__nfet_01v8 L=0.5u W=1u
M16368 o7 ibias vss vss sky130_fd_pr__nfet_01v8 L=0.5u W=1u
M16369 o7 ibias vss vss sky130_fd_pr__nfet_01v8 L=0.5u W=1u
M16370 o7 ibias vss vss sky130_fd_pr__nfet_01v8 L=0.5u W=1u
M16371 o7 ibias vss vss sky130_fd_pr__nfet_01v8 L=0.5u W=1u
M16372 o7 ibias vss vss sky130_fd_pr__nfet_01v8 L=0.5u W=1u
M16373 o7 ibias vss vss sky130_fd_pr__nfet_01v8 L=0.5u W=1u
M16374 o7 ibias vss vss sky130_fd_pr__nfet_01v8 L=0.5u W=1u
M16375 o7 ibias vss vss sky130_fd_pr__nfet_01v8 L=0.5u W=1u
M16376 o7 ibias vss vss sky130_fd_pr__nfet_01v8 L=0.5u W=1u
M16377 o7 ibias vss vss sky130_fd_pr__nfet_01v8 L=0.5u W=1u
M16378 o7 ibias vss vss sky130_fd_pr__nfet_01v8 L=0.5u W=1u
M16379 o7 ibias vss vss sky130_fd_pr__nfet_01v8 L=0.5u W=1u
M16380 o7 ibias vss vss sky130_fd_pr__nfet_01v8 L=0.5u W=1u
M16381 o7 ibias vss vss sky130_fd_pr__nfet_01v8 L=0.5u W=1u
M16382 o7 ibias vss vss sky130_fd_pr__nfet_01v8 L=0.5u W=1u
M16383 o7 ibias vss vss sky130_fd_pr__nfet_01v8 L=0.5u W=1u
M16384 o7 ibias vss vss sky130_fd_pr__nfet_01v8 L=0.5u W=1u
M16385 o7 ibias vss vss sky130_fd_pr__nfet_01v8 L=0.5u W=1u
M16386 o7 ibias vss vss sky130_fd_pr__nfet_01v8 L=0.5u W=1u
M16387 o7 ibias vss vss sky130_fd_pr__nfet_01v8 L=0.5u W=1u
M16388 o7 ibias vss vss sky130_fd_pr__nfet_01v8 L=0.5u W=1u
M16389 o7 ibias vss vss sky130_fd_pr__nfet_01v8 L=0.5u W=1u
M16390 o7 ibias vss vss sky130_fd_pr__nfet_01v8 L=0.5u W=1u
M16391 o7 ibias vss vss sky130_fd_pr__nfet_01v8 L=0.5u W=1u
M16392 o7 ibias vss vss sky130_fd_pr__nfet_01v8 L=0.5u W=1u
M16393 o7 ibias vss vss sky130_fd_pr__nfet_01v8 L=0.5u W=1u
M16394 o7 ibias vss vss sky130_fd_pr__nfet_01v8 L=0.5u W=1u
M16395 o7 ibias vss vss sky130_fd_pr__nfet_01v8 L=0.5u W=1u
M16396 o7 ibias vss vss sky130_fd_pr__nfet_01v8 L=0.5u W=1u
M16397 o7 ibias vss vss sky130_fd_pr__nfet_01v8 L=0.5u W=1u
M16398 o7 ibias vss vss sky130_fd_pr__nfet_01v8 L=0.5u W=1u
M16399 o7 ibias vss vss sky130_fd_pr__nfet_01v8 L=0.5u W=1u
M16400 o7 ibias vss vss sky130_fd_pr__nfet_01v8 L=0.5u W=1u
M16401 o7 ibias vss vss sky130_fd_pr__nfet_01v8 L=0.5u W=1u
M16402 o7 ibias vss vss sky130_fd_pr__nfet_01v8 L=0.5u W=1u
M16403 o7 ibias vss vss sky130_fd_pr__nfet_01v8 L=0.5u W=1u
M16404 o7 ibias vss vss sky130_fd_pr__nfet_01v8 L=0.5u W=1u
M16405 o7 ibias vss vss sky130_fd_pr__nfet_01v8 L=0.5u W=1u
M16406 o7 ibias vss vss sky130_fd_pr__nfet_01v8 L=0.5u W=1u
M16407 o7 ibias vss vss sky130_fd_pr__nfet_01v8 L=0.5u W=1u
M16408 o7 ibias vss vss sky130_fd_pr__nfet_01v8 L=0.5u W=1u
M16409 o7 ibias vss vss sky130_fd_pr__nfet_01v8 L=0.5u W=1u
M16410 o7 ibias vss vss sky130_fd_pr__nfet_01v8 L=0.5u W=1u
M16411 o7 ibias vss vss sky130_fd_pr__nfet_01v8 L=0.5u W=1u
M16412 o7 ibias vss vss sky130_fd_pr__nfet_01v8 L=0.5u W=1u
M16413 o7 ibias vss vss sky130_fd_pr__nfet_01v8 L=0.5u W=1u
M16414 o7 ibias vss vss sky130_fd_pr__nfet_01v8 L=0.5u W=1u
M16415 o7 ibias vss vss sky130_fd_pr__nfet_01v8 L=0.5u W=1u
M16416 o7 ibias vss vss sky130_fd_pr__nfet_01v8 L=0.5u W=1u
M16417 o7 ibias vss vss sky130_fd_pr__nfet_01v8 L=0.5u W=1u
M16418 o7 ibias vss vss sky130_fd_pr__nfet_01v8 L=0.5u W=1u
M16419 o7 ibias vss vss sky130_fd_pr__nfet_01v8 L=0.5u W=1u
M16420 o7 ibias vss vss sky130_fd_pr__nfet_01v8 L=0.5u W=1u
M16421 o7 ibias vss vss sky130_fd_pr__nfet_01v8 L=0.5u W=1u
M16422 o7 ibias vss vss sky130_fd_pr__nfet_01v8 L=0.5u W=1u
M16423 o7 ibias vss vss sky130_fd_pr__nfet_01v8 L=0.5u W=1u
M16424 o7 ibias vss vss sky130_fd_pr__nfet_01v8 L=0.5u W=1u
M16425 o7 ibias vss vss sky130_fd_pr__nfet_01v8 L=0.5u W=1u
M16426 o7 ibias vss vss sky130_fd_pr__nfet_01v8 L=0.5u W=1u
M16427 o7 ibias vss vss sky130_fd_pr__nfet_01v8 L=0.5u W=1u
M16428 o7 ibias vss vss sky130_fd_pr__nfet_01v8 L=0.5u W=1u
M16429 o7 ibias vss vss sky130_fd_pr__nfet_01v8 L=0.5u W=1u
M16430 o7 ibias vss vss sky130_fd_pr__nfet_01v8 L=0.5u W=1u
M16431 o7 ibias vss vss sky130_fd_pr__nfet_01v8 L=0.5u W=1u
M16432 o7 ibias vss vss sky130_fd_pr__nfet_01v8 L=0.5u W=1u
M16433 o7 ibias vss vss sky130_fd_pr__nfet_01v8 L=0.5u W=1u
M16434 o7 ibias vss vss sky130_fd_pr__nfet_01v8 L=0.5u W=1u
M16435 o7 ibias vss vss sky130_fd_pr__nfet_01v8 L=0.5u W=1u
M16436 o7 ibias vss vss sky130_fd_pr__nfet_01v8 L=0.5u W=1u
M16437 o7 ibias vss vss sky130_fd_pr__nfet_01v8 L=0.5u W=1u
M16438 o7 ibias vss vss sky130_fd_pr__nfet_01v8 L=0.5u W=1u
M16439 o7 ibias vss vss sky130_fd_pr__nfet_01v8 L=0.5u W=1u
M16440 o7 ibias vss vss sky130_fd_pr__nfet_01v8 L=0.5u W=1u
M16441 o7 ibias vss vss sky130_fd_pr__nfet_01v8 L=0.5u W=1u
M16442 o7 ibias vss vss sky130_fd_pr__nfet_01v8 L=0.5u W=1u
M16443 o7 ibias vss vss sky130_fd_pr__nfet_01v8 L=0.5u W=1u
M16444 o7 ibias vss vss sky130_fd_pr__nfet_01v8 L=0.5u W=1u
M16445 o7 ibias vss vss sky130_fd_pr__nfet_01v8 L=0.5u W=1u
M16446 o7 ibias vss vss sky130_fd_pr__nfet_01v8 L=0.5u W=1u
M16447 o7 ibias vss vss sky130_fd_pr__nfet_01v8 L=0.5u W=1u
M16448 o7 ibias vss vss sky130_fd_pr__nfet_01v8 L=0.5u W=1u
M16449 o7 ibias vss vss sky130_fd_pr__nfet_01v8 L=0.5u W=1u
M16450 o7 ibias vss vss sky130_fd_pr__nfet_01v8 L=0.5u W=1u
M16451 o7 ibias vss vss sky130_fd_pr__nfet_01v8 L=0.5u W=1u
M16452 o7 ibias vss vss sky130_fd_pr__nfet_01v8 L=0.5u W=1u
M16453 o7 ibias vss vss sky130_fd_pr__nfet_01v8 L=0.5u W=1u
M16454 o7 ibias vss vss sky130_fd_pr__nfet_01v8 L=0.5u W=1u
M16455 o7 ibias vss vss sky130_fd_pr__nfet_01v8 L=0.5u W=1u
M16456 o7 ibias vss vss sky130_fd_pr__nfet_01v8 L=0.5u W=1u
M16457 o7 ibias vss vss sky130_fd_pr__nfet_01v8 L=0.5u W=1u
M16458 o7 ibias vss vss sky130_fd_pr__nfet_01v8 L=0.5u W=1u
M16459 o7 ibias vss vss sky130_fd_pr__nfet_01v8 L=0.5u W=1u
M16460 o7 ibias vss vss sky130_fd_pr__nfet_01v8 L=0.5u W=1u
M16461 o7 ibias vss vss sky130_fd_pr__nfet_01v8 L=0.5u W=1u
M16462 o7 ibias vss vss sky130_fd_pr__nfet_01v8 L=0.5u W=1u
M16463 o7 ibias vss vss sky130_fd_pr__nfet_01v8 L=0.5u W=1u
M16464 o7 ibias vss vss sky130_fd_pr__nfet_01v8 L=0.5u W=1u
M16465 o7 ibias vss vss sky130_fd_pr__nfet_01v8 L=0.5u W=1u
M16466 o7 ibias vss vss sky130_fd_pr__nfet_01v8 L=0.5u W=1u
M16467 o7 ibias vss vss sky130_fd_pr__nfet_01v8 L=0.5u W=1u
M16468 o7 ibias vss vss sky130_fd_pr__nfet_01v8 L=0.5u W=1u
M16469 o7 ibias vss vss sky130_fd_pr__nfet_01v8 L=0.5u W=1u
M16470 o7 ibias vss vss sky130_fd_pr__nfet_01v8 L=0.5u W=1u
M16471 o7 ibias vss vss sky130_fd_pr__nfet_01v8 L=0.5u W=1u
M16472 o7 ibias vss vss sky130_fd_pr__nfet_01v8 L=0.5u W=1u
M16473 o7 ibias vss vss sky130_fd_pr__nfet_01v8 L=0.5u W=1u
M16474 o7 ibias vss vss sky130_fd_pr__nfet_01v8 L=0.5u W=1u
M16475 o7 ibias vss vss sky130_fd_pr__nfet_01v8 L=0.5u W=1u
M16476 o7 ibias vss vss sky130_fd_pr__nfet_01v8 L=0.5u W=1u
M16477 o7 ibias vss vss sky130_fd_pr__nfet_01v8 L=0.5u W=1u
M16478 o7 ibias vss vss sky130_fd_pr__nfet_01v8 L=0.5u W=1u
M16479 o7 ibias vss vss sky130_fd_pr__nfet_01v8 L=0.5u W=1u
M16480 o7 ibias vss vss sky130_fd_pr__nfet_01v8 L=0.5u W=1u
M16481 o7 ibias vss vss sky130_fd_pr__nfet_01v8 L=0.5u W=1u
M16482 o7 ibias vss vss sky130_fd_pr__nfet_01v8 L=0.5u W=1u
M16483 o7 ibias vss vss sky130_fd_pr__nfet_01v8 L=0.5u W=1u
M16484 o7 ibias vss vss sky130_fd_pr__nfet_01v8 L=0.5u W=1u
M16485 o7 ibias vss vss sky130_fd_pr__nfet_01v8 L=0.5u W=1u
M16486 o7 ibias vss vss sky130_fd_pr__nfet_01v8 L=0.5u W=1u
M16487 o7 ibias vss vss sky130_fd_pr__nfet_01v8 L=0.5u W=1u
M16488 o7 ibias vss vss sky130_fd_pr__nfet_01v8 L=0.5u W=1u
M16489 o7 ibias vss vss sky130_fd_pr__nfet_01v8 L=0.5u W=1u
M16490 o7 ibias vss vss sky130_fd_pr__nfet_01v8 L=0.5u W=1u
M16491 o7 ibias vss vss sky130_fd_pr__nfet_01v8 L=0.5u W=1u
M16492 o7 ibias vss vss sky130_fd_pr__nfet_01v8 L=0.5u W=1u
M16493 o7 ibias vss vss sky130_fd_pr__nfet_01v8 L=0.5u W=1u
M16494 o7 ibias vss vss sky130_fd_pr__nfet_01v8 L=0.5u W=1u
M16495 o7 ibias vss vss sky130_fd_pr__nfet_01v8 L=0.5u W=1u
M16496 o7 ibias vss vss sky130_fd_pr__nfet_01v8 L=0.5u W=1u
M16497 o7 ibias vss vss sky130_fd_pr__nfet_01v8 L=0.5u W=1u
M16498 o7 ibias vss vss sky130_fd_pr__nfet_01v8 L=0.5u W=1u
M16499 o7 ibias vss vss sky130_fd_pr__nfet_01v8 L=0.5u W=1u
M16500 o7 ibias vss vss sky130_fd_pr__nfet_01v8 L=0.5u W=1u
M16501 o7 ibias vss vss sky130_fd_pr__nfet_01v8 L=0.5u W=1u
M16502 o7 ibias vss vss sky130_fd_pr__nfet_01v8 L=0.5u W=1u
M16503 o7 ibias vss vss sky130_fd_pr__nfet_01v8 L=0.5u W=1u
M16504 o7 ibias vss vss sky130_fd_pr__nfet_01v8 L=0.5u W=1u
M16505 o7 ibias vss vss sky130_fd_pr__nfet_01v8 L=0.5u W=1u
M16506 o7 ibias vss vss sky130_fd_pr__nfet_01v8 L=0.5u W=1u
M16507 o7 ibias vss vss sky130_fd_pr__nfet_01v8 L=0.5u W=1u
M16508 o7 ibias vss vss sky130_fd_pr__nfet_01v8 L=0.5u W=1u
M16509 o7 ibias vss vss sky130_fd_pr__nfet_01v8 L=0.5u W=1u
M16510 o7 ibias vss vss sky130_fd_pr__nfet_01v8 L=0.5u W=1u
M16511 o7 ibias vss vss sky130_fd_pr__nfet_01v8 L=0.5u W=1u
M16512 o7 ibias vss vss sky130_fd_pr__nfet_01v8 L=0.5u W=1u
M16513 o7 ibias vss vss sky130_fd_pr__nfet_01v8 L=0.5u W=1u
M16514 o7 ibias vss vss sky130_fd_pr__nfet_01v8 L=0.5u W=1u
M16515 o7 ibias vss vss sky130_fd_pr__nfet_01v8 L=0.5u W=1u
M16516 o7 ibias vss vss sky130_fd_pr__nfet_01v8 L=0.5u W=1u
M16517 o7 ibias vss vss sky130_fd_pr__nfet_01v8 L=0.5u W=1u
M16518 o7 ibias vss vss sky130_fd_pr__nfet_01v8 L=0.5u W=1u
M16519 o7 ibias vss vss sky130_fd_pr__nfet_01v8 L=0.5u W=1u
M16520 o7 ibias vss vss sky130_fd_pr__nfet_01v8 L=0.5u W=1u
M16521 o7 ibias vss vss sky130_fd_pr__nfet_01v8 L=0.5u W=1u
M16522 o7 ibias vss vss sky130_fd_pr__nfet_01v8 L=0.5u W=1u
M16523 o7 ibias vss vss sky130_fd_pr__nfet_01v8 L=0.5u W=1u
M16524 o7 ibias vss vss sky130_fd_pr__nfet_01v8 L=0.5u W=1u
M16525 o7 ibias vss vss sky130_fd_pr__nfet_01v8 L=0.5u W=1u
M16526 o7 ibias vss vss sky130_fd_pr__nfet_01v8 L=0.5u W=1u
M16527 o7 ibias vss vss sky130_fd_pr__nfet_01v8 L=0.5u W=1u
M16528 o7 ibias vss vss sky130_fd_pr__nfet_01v8 L=0.5u W=1u
M16529 o7 ibias vss vss sky130_fd_pr__nfet_01v8 L=0.5u W=1u
M16530 o7 ibias vss vss sky130_fd_pr__nfet_01v8 L=0.5u W=1u
M16531 o7 ibias vss vss sky130_fd_pr__nfet_01v8 L=0.5u W=1u
M16532 o7 ibias vss vss sky130_fd_pr__nfet_01v8 L=0.5u W=1u
M16533 o7 ibias vss vss sky130_fd_pr__nfet_01v8 L=0.5u W=1u
M16534 o7 ibias vss vss sky130_fd_pr__nfet_01v8 L=0.5u W=1u
M16535 o7 ibias vss vss sky130_fd_pr__nfet_01v8 L=0.5u W=1u
M16536 o7 ibias vss vss sky130_fd_pr__nfet_01v8 L=0.5u W=1u
M16537 o7 ibias vss vss sky130_fd_pr__nfet_01v8 L=0.5u W=1u
M16538 o7 ibias vss vss sky130_fd_pr__nfet_01v8 L=0.5u W=1u
M16539 o7 ibias vss vss sky130_fd_pr__nfet_01v8 L=0.5u W=1u
M16540 o7 ibias vss vss sky130_fd_pr__nfet_01v8 L=0.5u W=1u
M16541 o7 ibias vss vss sky130_fd_pr__nfet_01v8 L=0.5u W=1u
M16542 o7 ibias vss vss sky130_fd_pr__nfet_01v8 L=0.5u W=1u
M16543 o7 ibias vss vss sky130_fd_pr__nfet_01v8 L=0.5u W=1u
M16544 o7 ibias vss vss sky130_fd_pr__nfet_01v8 L=0.5u W=1u
M16545 o7 ibias vss vss sky130_fd_pr__nfet_01v8 L=0.5u W=1u
M16546 o7 ibias vss vss sky130_fd_pr__nfet_01v8 L=0.5u W=1u
M16547 o7 ibias vss vss sky130_fd_pr__nfet_01v8 L=0.5u W=1u
M16548 o7 ibias vss vss sky130_fd_pr__nfet_01v8 L=0.5u W=1u
M16549 o7 ibias vss vss sky130_fd_pr__nfet_01v8 L=0.5u W=1u
M16550 o7 ibias vss vss sky130_fd_pr__nfet_01v8 L=0.5u W=1u
M16551 o7 ibias vss vss sky130_fd_pr__nfet_01v8 L=0.5u W=1u
M16552 o7 ibias vss vss sky130_fd_pr__nfet_01v8 L=0.5u W=1u
M16553 o7 ibias vss vss sky130_fd_pr__nfet_01v8 L=0.5u W=1u
M16554 o7 ibias vss vss sky130_fd_pr__nfet_01v8 L=0.5u W=1u
M16555 o7 ibias vss vss sky130_fd_pr__nfet_01v8 L=0.5u W=1u
M16556 o7 ibias vss vss sky130_fd_pr__nfet_01v8 L=0.5u W=1u
M16557 o7 ibias vss vss sky130_fd_pr__nfet_01v8 L=0.5u W=1u
M16558 o7 ibias vss vss sky130_fd_pr__nfet_01v8 L=0.5u W=1u
M16559 o7 ibias vss vss sky130_fd_pr__nfet_01v8 L=0.5u W=1u
M16560 o7 ibias vss vss sky130_fd_pr__nfet_01v8 L=0.5u W=1u
M16561 o7 ibias vss vss sky130_fd_pr__nfet_01v8 L=0.5u W=1u
M16562 o7 ibias vss vss sky130_fd_pr__nfet_01v8 L=0.5u W=1u
M16563 o7 ibias vss vss sky130_fd_pr__nfet_01v8 L=0.5u W=1u
M16564 o7 ibias vss vss sky130_fd_pr__nfet_01v8 L=0.5u W=1u
M16565 o7 ibias vss vss sky130_fd_pr__nfet_01v8 L=0.5u W=1u
M16566 o7 ibias vss vss sky130_fd_pr__nfet_01v8 L=0.5u W=1u
M16567 o7 ibias vss vss sky130_fd_pr__nfet_01v8 L=0.5u W=1u
M16568 o7 ibias vss vss sky130_fd_pr__nfet_01v8 L=0.5u W=1u
M16569 o7 ibias vss vss sky130_fd_pr__nfet_01v8 L=0.5u W=1u
M16570 o7 ibias vss vss sky130_fd_pr__nfet_01v8 L=0.5u W=1u
M16571 o7 ibias vss vss sky130_fd_pr__nfet_01v8 L=0.5u W=1u
M16572 o7 ibias vss vss sky130_fd_pr__nfet_01v8 L=0.5u W=1u
M16573 o7 ibias vss vss sky130_fd_pr__nfet_01v8 L=0.5u W=1u
M16574 o7 ibias vss vss sky130_fd_pr__nfet_01v8 L=0.5u W=1u
M16575 o7 ibias vss vss sky130_fd_pr__nfet_01v8 L=0.5u W=1u
M16576 o7 ibias vss vss sky130_fd_pr__nfet_01v8 L=0.5u W=1u
M16577 o7 ibias vss vss sky130_fd_pr__nfet_01v8 L=0.5u W=1u
M16578 o7 ibias vss vss sky130_fd_pr__nfet_01v8 L=0.5u W=1u
M16579 o7 ibias vss vss sky130_fd_pr__nfet_01v8 L=0.5u W=1u
M16580 o7 ibias vss vss sky130_fd_pr__nfet_01v8 L=0.5u W=1u
M16581 o7 ibias vss vss sky130_fd_pr__nfet_01v8 L=0.5u W=1u
M16582 o7 ibias vss vss sky130_fd_pr__nfet_01v8 L=0.5u W=1u
M16583 o7 ibias vss vss sky130_fd_pr__nfet_01v8 L=0.5u W=1u
M16584 o7 ibias vss vss sky130_fd_pr__nfet_01v8 L=0.5u W=1u
M16585 o7 ibias vss vss sky130_fd_pr__nfet_01v8 L=0.5u W=1u
M16586 o7 ibias vss vss sky130_fd_pr__nfet_01v8 L=0.5u W=1u
M16587 o7 ibias vss vss sky130_fd_pr__nfet_01v8 L=0.5u W=1u
M16588 o7 ibias vss vss sky130_fd_pr__nfet_01v8 L=0.5u W=1u
M16589 o7 ibias vss vss sky130_fd_pr__nfet_01v8 L=0.5u W=1u
M16590 o7 ibias vss vss sky130_fd_pr__nfet_01v8 L=0.5u W=1u
M16591 o7 ibias vss vss sky130_fd_pr__nfet_01v8 L=0.5u W=1u
M16592 o7 ibias vss vss sky130_fd_pr__nfet_01v8 L=0.5u W=1u
M16593 o7 ibias vss vss sky130_fd_pr__nfet_01v8 L=0.5u W=1u
M16594 o7 ibias vss vss sky130_fd_pr__nfet_01v8 L=0.5u W=1u
M16595 o7 ibias vss vss sky130_fd_pr__nfet_01v8 L=0.5u W=1u
M16596 o7 ibias vss vss sky130_fd_pr__nfet_01v8 L=0.5u W=1u
M16597 o7 ibias vss vss sky130_fd_pr__nfet_01v8 L=0.5u W=1u
M16598 o7 ibias vss vss sky130_fd_pr__nfet_01v8 L=0.5u W=1u
M16599 o7 ibias vss vss sky130_fd_pr__nfet_01v8 L=0.5u W=1u
M16600 o7 ibias vss vss sky130_fd_pr__nfet_01v8 L=0.5u W=1u
M16601 o7 ibias vss vss sky130_fd_pr__nfet_01v8 L=0.5u W=1u
M16602 o7 ibias vss vss sky130_fd_pr__nfet_01v8 L=0.5u W=1u
M16603 o7 ibias vss vss sky130_fd_pr__nfet_01v8 L=0.5u W=1u
M16604 o7 ibias vss vss sky130_fd_pr__nfet_01v8 L=0.5u W=1u
M16605 o7 ibias vss vss sky130_fd_pr__nfet_01v8 L=0.5u W=1u
M16606 o7 ibias vss vss sky130_fd_pr__nfet_01v8 L=0.5u W=1u
M16607 o7 ibias vss vss sky130_fd_pr__nfet_01v8 L=0.5u W=1u
M16608 o7 ibias vss vss sky130_fd_pr__nfet_01v8 L=0.5u W=1u
M16609 o7 ibias vss vss sky130_fd_pr__nfet_01v8 L=0.5u W=1u
M16610 o7 ibias vss vss sky130_fd_pr__nfet_01v8 L=0.5u W=1u
M16611 o7 ibias vss vss sky130_fd_pr__nfet_01v8 L=0.5u W=1u
M16612 o7 ibias vss vss sky130_fd_pr__nfet_01v8 L=0.5u W=1u
M16613 o7 ibias vss vss sky130_fd_pr__nfet_01v8 L=0.5u W=1u
M16614 o7 ibias vss vss sky130_fd_pr__nfet_01v8 L=0.5u W=1u
M16615 o7 ibias vss vss sky130_fd_pr__nfet_01v8 L=0.5u W=1u
M16616 o7 ibias vss vss sky130_fd_pr__nfet_01v8 L=0.5u W=1u
M16617 o7 ibias vss vss sky130_fd_pr__nfet_01v8 L=0.5u W=1u
M16618 o7 ibias vss vss sky130_fd_pr__nfet_01v8 L=0.5u W=1u
M16619 o7 ibias vss vss sky130_fd_pr__nfet_01v8 L=0.5u W=1u
M16620 o7 ibias vss vss sky130_fd_pr__nfet_01v8 L=0.5u W=1u
M16621 o7 ibias vss vss sky130_fd_pr__nfet_01v8 L=0.5u W=1u
M16622 o7 ibias vss vss sky130_fd_pr__nfet_01v8 L=0.5u W=1u
M16623 o7 ibias vss vss sky130_fd_pr__nfet_01v8 L=0.5u W=1u
M16624 o7 ibias vss vss sky130_fd_pr__nfet_01v8 L=0.5u W=1u
M16625 o7 ibias vss vss sky130_fd_pr__nfet_01v8 L=0.5u W=1u
M16626 o7 ibias vss vss sky130_fd_pr__nfet_01v8 L=0.5u W=1u
M16627 o7 ibias vss vss sky130_fd_pr__nfet_01v8 L=0.5u W=1u
M16628 o7 ibias vss vss sky130_fd_pr__nfet_01v8 L=0.5u W=1u
M16629 o7 ibias vss vss sky130_fd_pr__nfet_01v8 L=0.5u W=1u
M16630 o7 ibias vss vss sky130_fd_pr__nfet_01v8 L=0.5u W=1u
M16631 o7 ibias vss vss sky130_fd_pr__nfet_01v8 L=0.5u W=1u
M16632 o7 ibias vss vss sky130_fd_pr__nfet_01v8 L=0.5u W=1u
M16633 o7 ibias vss vss sky130_fd_pr__nfet_01v8 L=0.5u W=1u
M16634 o7 ibias vss vss sky130_fd_pr__nfet_01v8 L=0.5u W=1u
M16635 o7 ibias vss vss sky130_fd_pr__nfet_01v8 L=0.5u W=1u
M16636 o7 ibias vss vss sky130_fd_pr__nfet_01v8 L=0.5u W=1u
M16637 o7 ibias vss vss sky130_fd_pr__nfet_01v8 L=0.5u W=1u
M16638 o7 ibias vss vss sky130_fd_pr__nfet_01v8 L=0.5u W=1u
M16639 o7 ibias vss vss sky130_fd_pr__nfet_01v8 L=0.5u W=1u
M16640 o7 ibias vss vss sky130_fd_pr__nfet_01v8 L=0.5u W=1u
M16641 o7 ibias vss vss sky130_fd_pr__nfet_01v8 L=0.5u W=1u
M16642 o7 ibias vss vss sky130_fd_pr__nfet_01v8 L=0.5u W=1u
M16643 o7 ibias vss vss sky130_fd_pr__nfet_01v8 L=0.5u W=1u
M16644 o7 ibias vss vss sky130_fd_pr__nfet_01v8 L=0.5u W=1u
M16645 o7 ibias vss vss sky130_fd_pr__nfet_01v8 L=0.5u W=1u
M16646 o7 ibias vss vss sky130_fd_pr__nfet_01v8 L=0.5u W=1u
M16647 o7 ibias vss vss sky130_fd_pr__nfet_01v8 L=0.5u W=1u
M16648 o7 ibias vss vss sky130_fd_pr__nfet_01v8 L=0.5u W=1u
M16649 o7 ibias vss vss sky130_fd_pr__nfet_01v8 L=0.5u W=1u
M16650 o7 ibias vss vss sky130_fd_pr__nfet_01v8 L=0.5u W=1u
M16651 o7 ibias vss vss sky130_fd_pr__nfet_01v8 L=0.5u W=1u
M16652 o7 ibias vss vss sky130_fd_pr__nfet_01v8 L=0.5u W=1u
M16653 o7 ibias vss vss sky130_fd_pr__nfet_01v8 L=0.5u W=1u
M16654 o7 ibias vss vss sky130_fd_pr__nfet_01v8 L=0.5u W=1u
M16655 o7 ibias vss vss sky130_fd_pr__nfet_01v8 L=0.5u W=1u
M16656 o7 ibias vss vss sky130_fd_pr__nfet_01v8 L=0.5u W=1u
M16657 o7 ibias vss vss sky130_fd_pr__nfet_01v8 L=0.5u W=1u
M16658 o7 ibias vss vss sky130_fd_pr__nfet_01v8 L=0.5u W=1u
M16659 o7 ibias vss vss sky130_fd_pr__nfet_01v8 L=0.5u W=1u
M16660 o7 ibias vss vss sky130_fd_pr__nfet_01v8 L=0.5u W=1u
M16661 o7 ibias vss vss sky130_fd_pr__nfet_01v8 L=0.5u W=1u
M16662 o7 ibias vss vss sky130_fd_pr__nfet_01v8 L=0.5u W=1u
M16663 o7 ibias vss vss sky130_fd_pr__nfet_01v8 L=0.5u W=1u
M16664 o7 ibias vss vss sky130_fd_pr__nfet_01v8 L=0.5u W=1u
M16665 o7 ibias vss vss sky130_fd_pr__nfet_01v8 L=0.5u W=1u
M16666 o7 ibias vss vss sky130_fd_pr__nfet_01v8 L=0.5u W=1u
M16667 o7 ibias vss vss sky130_fd_pr__nfet_01v8 L=0.5u W=1u
M16668 o7 ibias vss vss sky130_fd_pr__nfet_01v8 L=0.5u W=1u
M16669 o7 ibias vss vss sky130_fd_pr__nfet_01v8 L=0.5u W=1u
M16670 o7 ibias vss vss sky130_fd_pr__nfet_01v8 L=0.5u W=1u
M16671 o7 ibias vss vss sky130_fd_pr__nfet_01v8 L=0.5u W=1u
M16672 o7 ibias vss vss sky130_fd_pr__nfet_01v8 L=0.5u W=1u
M16673 o7 ibias vss vss sky130_fd_pr__nfet_01v8 L=0.5u W=1u
M16674 o7 ibias vss vss sky130_fd_pr__nfet_01v8 L=0.5u W=1u
M16675 o7 ibias vss vss sky130_fd_pr__nfet_01v8 L=0.5u W=1u
M16676 o7 ibias vss vss sky130_fd_pr__nfet_01v8 L=0.5u W=1u
M16677 o7 ibias vss vss sky130_fd_pr__nfet_01v8 L=0.5u W=1u
M16678 o7 ibias vss vss sky130_fd_pr__nfet_01v8 L=0.5u W=1u
M16679 o7 ibias vss vss sky130_fd_pr__nfet_01v8 L=0.5u W=1u
M16680 o7 ibias vss vss sky130_fd_pr__nfet_01v8 L=0.5u W=1u
M16681 o7 ibias vss vss sky130_fd_pr__nfet_01v8 L=0.5u W=1u
M16682 o7 ibias vss vss sky130_fd_pr__nfet_01v8 L=0.5u W=1u
M16683 o7 ibias vss vss sky130_fd_pr__nfet_01v8 L=0.5u W=1u
M16684 o7 ibias vss vss sky130_fd_pr__nfet_01v8 L=0.5u W=1u
M16685 o7 ibias vss vss sky130_fd_pr__nfet_01v8 L=0.5u W=1u
M16686 o7 ibias vss vss sky130_fd_pr__nfet_01v8 L=0.5u W=1u
M16687 o7 ibias vss vss sky130_fd_pr__nfet_01v8 L=0.5u W=1u
M16688 o7 ibias vss vss sky130_fd_pr__nfet_01v8 L=0.5u W=1u
M16689 o7 ibias vss vss sky130_fd_pr__nfet_01v8 L=0.5u W=1u
M16690 o7 ibias vss vss sky130_fd_pr__nfet_01v8 L=0.5u W=1u
M16691 o7 ibias vss vss sky130_fd_pr__nfet_01v8 L=0.5u W=1u
M16692 o7 ibias vss vss sky130_fd_pr__nfet_01v8 L=0.5u W=1u
M16693 o7 ibias vss vss sky130_fd_pr__nfet_01v8 L=0.5u W=1u
M16694 o7 ibias vss vss sky130_fd_pr__nfet_01v8 L=0.5u W=1u
M16695 o7 ibias vss vss sky130_fd_pr__nfet_01v8 L=0.5u W=1u
M16696 o7 ibias vss vss sky130_fd_pr__nfet_01v8 L=0.5u W=1u
M16697 o7 ibias vss vss sky130_fd_pr__nfet_01v8 L=0.5u W=1u
M16698 o7 ibias vss vss sky130_fd_pr__nfet_01v8 L=0.5u W=1u
M16699 o7 ibias vss vss sky130_fd_pr__nfet_01v8 L=0.5u W=1u
M16700 o7 ibias vss vss sky130_fd_pr__nfet_01v8 L=0.5u W=1u
M16701 o7 ibias vss vss sky130_fd_pr__nfet_01v8 L=0.5u W=1u
M16702 o7 ibias vss vss sky130_fd_pr__nfet_01v8 L=0.5u W=1u
M16703 o7 ibias vss vss sky130_fd_pr__nfet_01v8 L=0.5u W=1u
M16704 o7 ibias vss vss sky130_fd_pr__nfet_01v8 L=0.5u W=1u
M16705 o7 ibias vss vss sky130_fd_pr__nfet_01v8 L=0.5u W=1u
M16706 o7 ibias vss vss sky130_fd_pr__nfet_01v8 L=0.5u W=1u
M16707 o7 ibias vss vss sky130_fd_pr__nfet_01v8 L=0.5u W=1u
M16708 o7 ibias vss vss sky130_fd_pr__nfet_01v8 L=0.5u W=1u
M16709 o7 ibias vss vss sky130_fd_pr__nfet_01v8 L=0.5u W=1u
M16710 o7 ibias vss vss sky130_fd_pr__nfet_01v8 L=0.5u W=1u
M16711 o7 ibias vss vss sky130_fd_pr__nfet_01v8 L=0.5u W=1u
M16712 o7 ibias vss vss sky130_fd_pr__nfet_01v8 L=0.5u W=1u
M16713 o7 ibias vss vss sky130_fd_pr__nfet_01v8 L=0.5u W=1u
M16714 o7 ibias vss vss sky130_fd_pr__nfet_01v8 L=0.5u W=1u
M16715 o7 ibias vss vss sky130_fd_pr__nfet_01v8 L=0.5u W=1u
M16716 o7 ibias vss vss sky130_fd_pr__nfet_01v8 L=0.5u W=1u
M16717 o7 ibias vss vss sky130_fd_pr__nfet_01v8 L=0.5u W=1u
M16718 o7 ibias vss vss sky130_fd_pr__nfet_01v8 L=0.5u W=1u
M16719 o7 ibias vss vss sky130_fd_pr__nfet_01v8 L=0.5u W=1u
M16720 o7 ibias vss vss sky130_fd_pr__nfet_01v8 L=0.5u W=1u
M16721 o7 ibias vss vss sky130_fd_pr__nfet_01v8 L=0.5u W=1u
M16722 o7 ibias vss vss sky130_fd_pr__nfet_01v8 L=0.5u W=1u
M16723 o7 ibias vss vss sky130_fd_pr__nfet_01v8 L=0.5u W=1u
M16724 o7 ibias vss vss sky130_fd_pr__nfet_01v8 L=0.5u W=1u
M16725 o7 ibias vss vss sky130_fd_pr__nfet_01v8 L=0.5u W=1u
M16726 o7 ibias vss vss sky130_fd_pr__nfet_01v8 L=0.5u W=1u
M16727 o7 ibias vss vss sky130_fd_pr__nfet_01v8 L=0.5u W=1u
M16728 o7 ibias vss vss sky130_fd_pr__nfet_01v8 L=0.5u W=1u
M16729 o7 ibias vss vss sky130_fd_pr__nfet_01v8 L=0.5u W=1u
M16730 o7 ibias vss vss sky130_fd_pr__nfet_01v8 L=0.5u W=1u
M16731 o7 ibias vss vss sky130_fd_pr__nfet_01v8 L=0.5u W=1u
M16732 o7 ibias vss vss sky130_fd_pr__nfet_01v8 L=0.5u W=1u
M16733 o7 ibias vss vss sky130_fd_pr__nfet_01v8 L=0.5u W=1u
M16734 o7 ibias vss vss sky130_fd_pr__nfet_01v8 L=0.5u W=1u
M16735 o7 ibias vss vss sky130_fd_pr__nfet_01v8 L=0.5u W=1u
M16736 o7 ibias vss vss sky130_fd_pr__nfet_01v8 L=0.5u W=1u
M16737 o7 ibias vss vss sky130_fd_pr__nfet_01v8 L=0.5u W=1u
M16738 o7 ibias vss vss sky130_fd_pr__nfet_01v8 L=0.5u W=1u
M16739 o7 ibias vss vss sky130_fd_pr__nfet_01v8 L=0.5u W=1u
M16740 o7 ibias vss vss sky130_fd_pr__nfet_01v8 L=0.5u W=1u
M16741 o7 ibias vss vss sky130_fd_pr__nfet_01v8 L=0.5u W=1u
M16742 o7 ibias vss vss sky130_fd_pr__nfet_01v8 L=0.5u W=1u
M16743 o7 ibias vss vss sky130_fd_pr__nfet_01v8 L=0.5u W=1u
M16744 o7 ibias vss vss sky130_fd_pr__nfet_01v8 L=0.5u W=1u
M16745 o7 ibias vss vss sky130_fd_pr__nfet_01v8 L=0.5u W=1u
M16746 o7 ibias vss vss sky130_fd_pr__nfet_01v8 L=0.5u W=1u
M16747 o7 ibias vss vss sky130_fd_pr__nfet_01v8 L=0.5u W=1u
M16748 o7 ibias vss vss sky130_fd_pr__nfet_01v8 L=0.5u W=1u
M16749 o7 ibias vss vss sky130_fd_pr__nfet_01v8 L=0.5u W=1u
M16750 o7 ibias vss vss sky130_fd_pr__nfet_01v8 L=0.5u W=1u
M16751 o7 ibias vss vss sky130_fd_pr__nfet_01v8 L=0.5u W=1u
M16752 o7 ibias vss vss sky130_fd_pr__nfet_01v8 L=0.5u W=1u
M16753 o7 ibias vss vss sky130_fd_pr__nfet_01v8 L=0.5u W=1u
M16754 o7 ibias vss vss sky130_fd_pr__nfet_01v8 L=0.5u W=1u
M16755 o7 ibias vss vss sky130_fd_pr__nfet_01v8 L=0.5u W=1u
M16756 o7 ibias vss vss sky130_fd_pr__nfet_01v8 L=0.5u W=1u
M16757 o7 ibias vss vss sky130_fd_pr__nfet_01v8 L=0.5u W=1u
M16758 o7 ibias vss vss sky130_fd_pr__nfet_01v8 L=0.5u W=1u
M16759 o7 ibias vss vss sky130_fd_pr__nfet_01v8 L=0.5u W=1u
M16760 o7 ibias vss vss sky130_fd_pr__nfet_01v8 L=0.5u W=1u
M16761 o7 ibias vss vss sky130_fd_pr__nfet_01v8 L=0.5u W=1u
M16762 o7 ibias vss vss sky130_fd_pr__nfet_01v8 L=0.5u W=1u
M16763 o7 ibias vss vss sky130_fd_pr__nfet_01v8 L=0.5u W=1u
M16764 o7 ibias vss vss sky130_fd_pr__nfet_01v8 L=0.5u W=1u
M16765 o7 ibias vss vss sky130_fd_pr__nfet_01v8 L=0.5u W=1u
M16766 o7 ibias vss vss sky130_fd_pr__nfet_01v8 L=0.5u W=1u
M16767 o7 ibias vss vss sky130_fd_pr__nfet_01v8 L=0.5u W=1u
M16768 o7 ibias vss vss sky130_fd_pr__nfet_01v8 L=0.5u W=1u
M16769 o7 ibias vss vss sky130_fd_pr__nfet_01v8 L=0.5u W=1u
M16770 o7 ibias vss vss sky130_fd_pr__nfet_01v8 L=0.5u W=1u
M16771 o7 ibias vss vss sky130_fd_pr__nfet_01v8 L=0.5u W=1u
M16772 o7 ibias vss vss sky130_fd_pr__nfet_01v8 L=0.5u W=1u
M16773 o7 ibias vss vss sky130_fd_pr__nfet_01v8 L=0.5u W=1u
M16774 o7 ibias vss vss sky130_fd_pr__nfet_01v8 L=0.5u W=1u
M16775 o7 ibias vss vss sky130_fd_pr__nfet_01v8 L=0.5u W=1u
M16776 o7 ibias vss vss sky130_fd_pr__nfet_01v8 L=0.5u W=1u
M16777 o7 ibias vss vss sky130_fd_pr__nfet_01v8 L=0.5u W=1u
M16778 o7 ibias vss vss sky130_fd_pr__nfet_01v8 L=0.5u W=1u
M16779 o7 ibias vss vss sky130_fd_pr__nfet_01v8 L=0.5u W=1u
M16780 o7 ibias vss vss sky130_fd_pr__nfet_01v8 L=0.5u W=1u
M16781 o7 ibias vss vss sky130_fd_pr__nfet_01v8 L=0.5u W=1u
M16782 o7 ibias vss vss sky130_fd_pr__nfet_01v8 L=0.5u W=1u
M16783 o7 ibias vss vss sky130_fd_pr__nfet_01v8 L=0.5u W=1u
M16784 o7 ibias vss vss sky130_fd_pr__nfet_01v8 L=0.5u W=1u
M16785 o7 ibias vss vss sky130_fd_pr__nfet_01v8 L=0.5u W=1u
M16786 o7 ibias vss vss sky130_fd_pr__nfet_01v8 L=0.5u W=1u
M16787 o7 ibias vss vss sky130_fd_pr__nfet_01v8 L=0.5u W=1u
M16788 o7 ibias vss vss sky130_fd_pr__nfet_01v8 L=0.5u W=1u
M16789 o7 ibias vss vss sky130_fd_pr__nfet_01v8 L=0.5u W=1u
M16790 o7 ibias vss vss sky130_fd_pr__nfet_01v8 L=0.5u W=1u
M16791 o7 ibias vss vss sky130_fd_pr__nfet_01v8 L=0.5u W=1u
M16792 o7 ibias vss vss sky130_fd_pr__nfet_01v8 L=0.5u W=1u
M16793 o7 ibias vss vss sky130_fd_pr__nfet_01v8 L=0.5u W=1u
M16794 o7 ibias vss vss sky130_fd_pr__nfet_01v8 L=0.5u W=1u
M16795 o7 ibias vss vss sky130_fd_pr__nfet_01v8 L=0.5u W=1u
M16796 o7 ibias vss vss sky130_fd_pr__nfet_01v8 L=0.5u W=1u
M16797 o7 ibias vss vss sky130_fd_pr__nfet_01v8 L=0.5u W=1u
M16798 o7 ibias vss vss sky130_fd_pr__nfet_01v8 L=0.5u W=1u
M16799 o7 ibias vss vss sky130_fd_pr__nfet_01v8 L=0.5u W=1u
M16800 o7 ibias vss vss sky130_fd_pr__nfet_01v8 L=0.5u W=1u
M16801 o7 ibias vss vss sky130_fd_pr__nfet_01v8 L=0.5u W=1u
M16802 o7 ibias vss vss sky130_fd_pr__nfet_01v8 L=0.5u W=1u
M16803 o7 ibias vss vss sky130_fd_pr__nfet_01v8 L=0.5u W=1u
M16804 o7 ibias vss vss sky130_fd_pr__nfet_01v8 L=0.5u W=1u
M16805 o7 ibias vss vss sky130_fd_pr__nfet_01v8 L=0.5u W=1u
M16806 o7 ibias vss vss sky130_fd_pr__nfet_01v8 L=0.5u W=1u
M16807 o7 ibias vss vss sky130_fd_pr__nfet_01v8 L=0.5u W=1u
M16808 o7 ibias vss vss sky130_fd_pr__nfet_01v8 L=0.5u W=1u
M16809 o7 ibias vss vss sky130_fd_pr__nfet_01v8 L=0.5u W=1u
M16810 o7 ibias vss vss sky130_fd_pr__nfet_01v8 L=0.5u W=1u
M16811 o7 ibias vss vss sky130_fd_pr__nfet_01v8 L=0.5u W=1u
M16812 o7 ibias vss vss sky130_fd_pr__nfet_01v8 L=0.5u W=1u
M16813 o7 ibias vss vss sky130_fd_pr__nfet_01v8 L=0.5u W=1u
M16814 o7 ibias vss vss sky130_fd_pr__nfet_01v8 L=0.5u W=1u
M16815 o7 ibias vss vss sky130_fd_pr__nfet_01v8 L=0.5u W=1u
M16816 o7 ibias vss vss sky130_fd_pr__nfet_01v8 L=0.5u W=1u
M16817 o7 ibias vss vss sky130_fd_pr__nfet_01v8 L=0.5u W=1u
M16818 o7 ibias vss vss sky130_fd_pr__nfet_01v8 L=0.5u W=1u
M16819 o7 ibias vss vss sky130_fd_pr__nfet_01v8 L=0.5u W=1u
M16820 o7 ibias vss vss sky130_fd_pr__nfet_01v8 L=0.5u W=1u
M16821 o7 ibias vss vss sky130_fd_pr__nfet_01v8 L=0.5u W=1u
M16822 o7 ibias vss vss sky130_fd_pr__nfet_01v8 L=0.5u W=1u
M16823 o7 ibias vss vss sky130_fd_pr__nfet_01v8 L=0.5u W=1u
M16824 o7 ibias vss vss sky130_fd_pr__nfet_01v8 L=0.5u W=1u
M16825 o7 ibias vss vss sky130_fd_pr__nfet_01v8 L=0.5u W=1u
M16826 o7 ibias vss vss sky130_fd_pr__nfet_01v8 L=0.5u W=1u
M16827 o7 ibias vss vss sky130_fd_pr__nfet_01v8 L=0.5u W=1u
M16828 o7 ibias vss vss sky130_fd_pr__nfet_01v8 L=0.5u W=1u
M16829 o7 ibias vss vss sky130_fd_pr__nfet_01v8 L=0.5u W=1u
M16830 o7 ibias vss vss sky130_fd_pr__nfet_01v8 L=0.5u W=1u
M16831 o7 ibias vss vss sky130_fd_pr__nfet_01v8 L=0.5u W=1u
M16832 o7 ibias vss vss sky130_fd_pr__nfet_01v8 L=0.5u W=1u
M16833 o7 ibias vss vss sky130_fd_pr__nfet_01v8 L=0.5u W=1u
M16834 o7 ibias vss vss sky130_fd_pr__nfet_01v8 L=0.5u W=1u
M16835 o7 ibias vss vss sky130_fd_pr__nfet_01v8 L=0.5u W=1u
M16836 o7 ibias vss vss sky130_fd_pr__nfet_01v8 L=0.5u W=1u
M16837 o7 ibias vss vss sky130_fd_pr__nfet_01v8 L=0.5u W=1u
M16838 o7 ibias vss vss sky130_fd_pr__nfet_01v8 L=0.5u W=1u
M16839 o7 ibias vss vss sky130_fd_pr__nfet_01v8 L=0.5u W=1u
M16840 o7 ibias vss vss sky130_fd_pr__nfet_01v8 L=0.5u W=1u
M16841 o7 ibias vss vss sky130_fd_pr__nfet_01v8 L=0.5u W=1u
M16842 o7 ibias vss vss sky130_fd_pr__nfet_01v8 L=0.5u W=1u
M16843 o7 ibias vss vss sky130_fd_pr__nfet_01v8 L=0.5u W=1u
M16844 o7 ibias vss vss sky130_fd_pr__nfet_01v8 L=0.5u W=1u
M16845 o7 ibias vss vss sky130_fd_pr__nfet_01v8 L=0.5u W=1u
M16846 o7 ibias vss vss sky130_fd_pr__nfet_01v8 L=0.5u W=1u
M16847 o7 ibias vss vss sky130_fd_pr__nfet_01v8 L=0.5u W=1u
M16848 o7 ibias vss vss sky130_fd_pr__nfet_01v8 L=0.5u W=1u
M16849 o7 ibias vss vss sky130_fd_pr__nfet_01v8 L=0.5u W=1u
M16850 o7 ibias vss vss sky130_fd_pr__nfet_01v8 L=0.5u W=1u
M16851 o7 ibias vss vss sky130_fd_pr__nfet_01v8 L=0.5u W=1u
M16852 o7 ibias vss vss sky130_fd_pr__nfet_01v8 L=0.5u W=1u
M16853 o7 ibias vss vss sky130_fd_pr__nfet_01v8 L=0.5u W=1u
M16854 o7 ibias vss vss sky130_fd_pr__nfet_01v8 L=0.5u W=1u
M16855 o7 ibias vss vss sky130_fd_pr__nfet_01v8 L=0.5u W=1u
M16856 o7 ibias vss vss sky130_fd_pr__nfet_01v8 L=0.5u W=1u
M16857 o7 ibias vss vss sky130_fd_pr__nfet_01v8 L=0.5u W=1u
M16858 o7 ibias vss vss sky130_fd_pr__nfet_01v8 L=0.5u W=1u
M16859 o7 ibias vss vss sky130_fd_pr__nfet_01v8 L=0.5u W=1u
M16860 o7 ibias vss vss sky130_fd_pr__nfet_01v8 L=0.5u W=1u
M16861 o7 ibias vss vss sky130_fd_pr__nfet_01v8 L=0.5u W=1u
M16862 o7 ibias vss vss sky130_fd_pr__nfet_01v8 L=0.5u W=1u
M16863 o7 ibias vss vss sky130_fd_pr__nfet_01v8 L=0.5u W=1u
M16864 o7 ibias vss vss sky130_fd_pr__nfet_01v8 L=0.5u W=1u
M16865 o7 ibias vss vss sky130_fd_pr__nfet_01v8 L=0.5u W=1u
M16866 o7 ibias vss vss sky130_fd_pr__nfet_01v8 L=0.5u W=1u
M16867 o7 ibias vss vss sky130_fd_pr__nfet_01v8 L=0.5u W=1u
M16868 o7 ibias vss vss sky130_fd_pr__nfet_01v8 L=0.5u W=1u
M16869 o7 ibias vss vss sky130_fd_pr__nfet_01v8 L=0.5u W=1u
M16870 o7 ibias vss vss sky130_fd_pr__nfet_01v8 L=0.5u W=1u
M16871 o7 ibias vss vss sky130_fd_pr__nfet_01v8 L=0.5u W=1u
M16872 o7 ibias vss vss sky130_fd_pr__nfet_01v8 L=0.5u W=1u
M16873 o7 ibias vss vss sky130_fd_pr__nfet_01v8 L=0.5u W=1u
M16874 o7 ibias vss vss sky130_fd_pr__nfet_01v8 L=0.5u W=1u
M16875 o7 ibias vss vss sky130_fd_pr__nfet_01v8 L=0.5u W=1u
M16876 o7 ibias vss vss sky130_fd_pr__nfet_01v8 L=0.5u W=1u
M16877 o7 ibias vss vss sky130_fd_pr__nfet_01v8 L=0.5u W=1u
M16878 o7 ibias vss vss sky130_fd_pr__nfet_01v8 L=0.5u W=1u
M16879 o7 ibias vss vss sky130_fd_pr__nfet_01v8 L=0.5u W=1u
M16880 o7 ibias vss vss sky130_fd_pr__nfet_01v8 L=0.5u W=1u
M16881 o7 ibias vss vss sky130_fd_pr__nfet_01v8 L=0.5u W=1u
M16882 o7 ibias vss vss sky130_fd_pr__nfet_01v8 L=0.5u W=1u
M16883 o7 ibias vss vss sky130_fd_pr__nfet_01v8 L=0.5u W=1u
M16884 o7 ibias vss vss sky130_fd_pr__nfet_01v8 L=0.5u W=1u
M16885 o7 ibias vss vss sky130_fd_pr__nfet_01v8 L=0.5u W=1u
M16886 o7 ibias vss vss sky130_fd_pr__nfet_01v8 L=0.5u W=1u
M16887 o7 ibias vss vss sky130_fd_pr__nfet_01v8 L=0.5u W=1u
M16888 o7 ibias vss vss sky130_fd_pr__nfet_01v8 L=0.5u W=1u
M16889 o7 ibias vss vss sky130_fd_pr__nfet_01v8 L=0.5u W=1u
M16890 o7 ibias vss vss sky130_fd_pr__nfet_01v8 L=0.5u W=1u
M16891 o7 ibias vss vss sky130_fd_pr__nfet_01v8 L=0.5u W=1u
M16892 o7 ibias vss vss sky130_fd_pr__nfet_01v8 L=0.5u W=1u
M16893 o7 ibias vss vss sky130_fd_pr__nfet_01v8 L=0.5u W=1u
M16894 o7 ibias vss vss sky130_fd_pr__nfet_01v8 L=0.5u W=1u
M16895 o7 ibias vss vss sky130_fd_pr__nfet_01v8 L=0.5u W=1u
M16896 o7 ibias vss vss sky130_fd_pr__nfet_01v8 L=0.5u W=1u
M16897 o7 ibias vss vss sky130_fd_pr__nfet_01v8 L=0.5u W=1u
M16898 o7 ibias vss vss sky130_fd_pr__nfet_01v8 L=0.5u W=1u
M16899 o7 ibias vss vss sky130_fd_pr__nfet_01v8 L=0.5u W=1u
M16900 o7 ibias vss vss sky130_fd_pr__nfet_01v8 L=0.5u W=1u
M16901 o7 ibias vss vss sky130_fd_pr__nfet_01v8 L=0.5u W=1u
M16902 o7 ibias vss vss sky130_fd_pr__nfet_01v8 L=0.5u W=1u
M16903 o7 ibias vss vss sky130_fd_pr__nfet_01v8 L=0.5u W=1u
M16904 o7 ibias vss vss sky130_fd_pr__nfet_01v8 L=0.5u W=1u
M16905 o7 ibias vss vss sky130_fd_pr__nfet_01v8 L=0.5u W=1u
M16906 o7 ibias vss vss sky130_fd_pr__nfet_01v8 L=0.5u W=1u
M16907 o7 ibias vss vss sky130_fd_pr__nfet_01v8 L=0.5u W=1u
M16908 o7 ibias vss vss sky130_fd_pr__nfet_01v8 L=0.5u W=1u
M16909 o7 ibias vss vss sky130_fd_pr__nfet_01v8 L=0.5u W=1u
M16910 o7 ibias vss vss sky130_fd_pr__nfet_01v8 L=0.5u W=1u
M16911 o7 ibias vss vss sky130_fd_pr__nfet_01v8 L=0.5u W=1u
M16912 o7 ibias vss vss sky130_fd_pr__nfet_01v8 L=0.5u W=1u
M16913 o7 ibias vss vss sky130_fd_pr__nfet_01v8 L=0.5u W=1u
M16914 o7 ibias vss vss sky130_fd_pr__nfet_01v8 L=0.5u W=1u
M16915 o7 ibias vss vss sky130_fd_pr__nfet_01v8 L=0.5u W=1u
M16916 o7 ibias vss vss sky130_fd_pr__nfet_01v8 L=0.5u W=1u
M16917 o7 ibias vss vss sky130_fd_pr__nfet_01v8 L=0.5u W=1u
M16918 o7 ibias vss vss sky130_fd_pr__nfet_01v8 L=0.5u W=1u
M16919 o7 ibias vss vss sky130_fd_pr__nfet_01v8 L=0.5u W=1u
M16920 o7 ibias vss vss sky130_fd_pr__nfet_01v8 L=0.5u W=1u
M16921 o7 ibias vss vss sky130_fd_pr__nfet_01v8 L=0.5u W=1u
M16922 o7 ibias vss vss sky130_fd_pr__nfet_01v8 L=0.5u W=1u
M16923 o7 ibias vss vss sky130_fd_pr__nfet_01v8 L=0.5u W=1u
M16924 o7 ibias vss vss sky130_fd_pr__nfet_01v8 L=0.5u W=1u
M16925 o7 ibias vss vss sky130_fd_pr__nfet_01v8 L=0.5u W=1u
M16926 o7 ibias vss vss sky130_fd_pr__nfet_01v8 L=0.5u W=1u
M16927 o7 ibias vss vss sky130_fd_pr__nfet_01v8 L=0.5u W=1u
M16928 o7 ibias vss vss sky130_fd_pr__nfet_01v8 L=0.5u W=1u
M16929 o7 ibias vss vss sky130_fd_pr__nfet_01v8 L=0.5u W=1u
M16930 o7 ibias vss vss sky130_fd_pr__nfet_01v8 L=0.5u W=1u
M16931 o7 ibias vss vss sky130_fd_pr__nfet_01v8 L=0.5u W=1u
M16932 o7 ibias vss vss sky130_fd_pr__nfet_01v8 L=0.5u W=1u
M16933 o7 ibias vss vss sky130_fd_pr__nfet_01v8 L=0.5u W=1u
M16934 o7 ibias vss vss sky130_fd_pr__nfet_01v8 L=0.5u W=1u
M16935 o7 ibias vss vss sky130_fd_pr__nfet_01v8 L=0.5u W=1u
M16936 o7 ibias vss vss sky130_fd_pr__nfet_01v8 L=0.5u W=1u
M16937 o7 ibias vss vss sky130_fd_pr__nfet_01v8 L=0.5u W=1u
M16938 o7 ibias vss vss sky130_fd_pr__nfet_01v8 L=0.5u W=1u
M16939 o7 ibias vss vss sky130_fd_pr__nfet_01v8 L=0.5u W=1u
M16940 o7 ibias vss vss sky130_fd_pr__nfet_01v8 L=0.5u W=1u
M16941 o7 ibias vss vss sky130_fd_pr__nfet_01v8 L=0.5u W=1u
M16942 o7 ibias vss vss sky130_fd_pr__nfet_01v8 L=0.5u W=1u
M16943 o7 ibias vss vss sky130_fd_pr__nfet_01v8 L=0.5u W=1u
M16944 o7 ibias vss vss sky130_fd_pr__nfet_01v8 L=0.5u W=1u
M16945 o7 ibias vss vss sky130_fd_pr__nfet_01v8 L=0.5u W=1u
M16946 o7 ibias vss vss sky130_fd_pr__nfet_01v8 L=0.5u W=1u
M16947 o7 ibias vss vss sky130_fd_pr__nfet_01v8 L=0.5u W=1u
M16948 o7 ibias vss vss sky130_fd_pr__nfet_01v8 L=0.5u W=1u
M16949 o7 ibias vss vss sky130_fd_pr__nfet_01v8 L=0.5u W=1u
M16950 o7 ibias vss vss sky130_fd_pr__nfet_01v8 L=0.5u W=1u
M16951 o7 ibias vss vss sky130_fd_pr__nfet_01v8 L=0.5u W=1u
M16952 o7 ibias vss vss sky130_fd_pr__nfet_01v8 L=0.5u W=1u
M16953 o7 ibias vss vss sky130_fd_pr__nfet_01v8 L=0.5u W=1u
M16954 o7 ibias vss vss sky130_fd_pr__nfet_01v8 L=0.5u W=1u
M16955 o7 ibias vss vss sky130_fd_pr__nfet_01v8 L=0.5u W=1u
M16956 o7 ibias vss vss sky130_fd_pr__nfet_01v8 L=0.5u W=1u
M16957 o7 ibias vss vss sky130_fd_pr__nfet_01v8 L=0.5u W=1u
M16958 o7 ibias vss vss sky130_fd_pr__nfet_01v8 L=0.5u W=1u
M16959 o7 ibias vss vss sky130_fd_pr__nfet_01v8 L=0.5u W=1u
M16960 o7 ibias vss vss sky130_fd_pr__nfet_01v8 L=0.5u W=1u
M16961 o7 ibias vss vss sky130_fd_pr__nfet_01v8 L=0.5u W=1u
M16962 o7 ibias vss vss sky130_fd_pr__nfet_01v8 L=0.5u W=1u
M16963 o7 ibias vss vss sky130_fd_pr__nfet_01v8 L=0.5u W=1u
M16964 o7 ibias vss vss sky130_fd_pr__nfet_01v8 L=0.5u W=1u
M16965 o7 ibias vss vss sky130_fd_pr__nfet_01v8 L=0.5u W=1u
M16966 o7 ibias vss vss sky130_fd_pr__nfet_01v8 L=0.5u W=1u
M16967 o7 ibias vss vss sky130_fd_pr__nfet_01v8 L=0.5u W=1u
M16968 o7 ibias vss vss sky130_fd_pr__nfet_01v8 L=0.5u W=1u
M16969 o7 ibias vss vss sky130_fd_pr__nfet_01v8 L=0.5u W=1u
M16970 o7 ibias vss vss sky130_fd_pr__nfet_01v8 L=0.5u W=1u
M16971 o7 ibias vss vss sky130_fd_pr__nfet_01v8 L=0.5u W=1u
M16972 o7 ibias vss vss sky130_fd_pr__nfet_01v8 L=0.5u W=1u
M16973 o7 ibias vss vss sky130_fd_pr__nfet_01v8 L=0.5u W=1u
M16974 o7 ibias vss vss sky130_fd_pr__nfet_01v8 L=0.5u W=1u
M16975 o7 ibias vss vss sky130_fd_pr__nfet_01v8 L=0.5u W=1u
M16976 o7 ibias vss vss sky130_fd_pr__nfet_01v8 L=0.5u W=1u
M16977 o7 ibias vss vss sky130_fd_pr__nfet_01v8 L=0.5u W=1u
M16978 o7 ibias vss vss sky130_fd_pr__nfet_01v8 L=0.5u W=1u
M16979 o7 ibias vss vss sky130_fd_pr__nfet_01v8 L=0.5u W=1u
M16980 o7 ibias vss vss sky130_fd_pr__nfet_01v8 L=0.5u W=1u
M16981 o7 ibias vss vss sky130_fd_pr__nfet_01v8 L=0.5u W=1u
M16982 o7 ibias vss vss sky130_fd_pr__nfet_01v8 L=0.5u W=1u
M16983 o7 ibias vss vss sky130_fd_pr__nfet_01v8 L=0.5u W=1u
M16984 o7 ibias vss vss sky130_fd_pr__nfet_01v8 L=0.5u W=1u
M16985 o7 ibias vss vss sky130_fd_pr__nfet_01v8 L=0.5u W=1u
M16986 o7 ibias vss vss sky130_fd_pr__nfet_01v8 L=0.5u W=1u
M16987 o7 ibias vss vss sky130_fd_pr__nfet_01v8 L=0.5u W=1u
M16988 o7 ibias vss vss sky130_fd_pr__nfet_01v8 L=0.5u W=1u
M16989 o7 ibias vss vss sky130_fd_pr__nfet_01v8 L=0.5u W=1u
M16990 o7 ibias vss vss sky130_fd_pr__nfet_01v8 L=0.5u W=1u
M16991 o7 ibias vss vss sky130_fd_pr__nfet_01v8 L=0.5u W=1u
M16992 o7 ibias vss vss sky130_fd_pr__nfet_01v8 L=0.5u W=1u
M16993 o7 ibias vss vss sky130_fd_pr__nfet_01v8 L=0.5u W=1u
M16994 o7 ibias vss vss sky130_fd_pr__nfet_01v8 L=0.5u W=1u
M16995 o7 ibias vss vss sky130_fd_pr__nfet_01v8 L=0.5u W=1u
M16996 o7 ibias vss vss sky130_fd_pr__nfet_01v8 L=0.5u W=1u
M16997 o7 ibias vss vss sky130_fd_pr__nfet_01v8 L=0.5u W=1u
M16998 o7 ibias vss vss sky130_fd_pr__nfet_01v8 L=0.5u W=1u
M16999 o7 ibias vss vss sky130_fd_pr__nfet_01v8 L=0.5u W=1u
M17000 o7 ibias vss vss sky130_fd_pr__nfet_01v8 L=0.5u W=1u
M17001 o7 ibias vss vss sky130_fd_pr__nfet_01v8 L=0.5u W=1u
M17002 o7 ibias vss vss sky130_fd_pr__nfet_01v8 L=0.5u W=1u
M17003 o7 ibias vss vss sky130_fd_pr__nfet_01v8 L=0.5u W=1u
M17004 o7 ibias vss vss sky130_fd_pr__nfet_01v8 L=0.5u W=1u
M17005 o7 ibias vss vss sky130_fd_pr__nfet_01v8 L=0.5u W=1u
M17006 o7 ibias vss vss sky130_fd_pr__nfet_01v8 L=0.5u W=1u
M17007 o7 ibias vss vss sky130_fd_pr__nfet_01v8 L=0.5u W=1u
M17008 o7 ibias vss vss sky130_fd_pr__nfet_01v8 L=0.5u W=1u
M17009 o7 ibias vss vss sky130_fd_pr__nfet_01v8 L=0.5u W=1u
M17010 o7 ibias vss vss sky130_fd_pr__nfet_01v8 L=0.5u W=1u
M17011 o7 ibias vss vss sky130_fd_pr__nfet_01v8 L=0.5u W=1u
M17012 o7 ibias vss vss sky130_fd_pr__nfet_01v8 L=0.5u W=1u
M17013 o7 ibias vss vss sky130_fd_pr__nfet_01v8 L=0.5u W=1u
M17014 o7 ibias vss vss sky130_fd_pr__nfet_01v8 L=0.5u W=1u
M17015 o7 ibias vss vss sky130_fd_pr__nfet_01v8 L=0.5u W=1u
M17016 o7 ibias vss vss sky130_fd_pr__nfet_01v8 L=0.5u W=1u
M17017 o7 ibias vss vss sky130_fd_pr__nfet_01v8 L=0.5u W=1u
M17018 o7 ibias vss vss sky130_fd_pr__nfet_01v8 L=0.5u W=1u
M17019 o7 ibias vss vss sky130_fd_pr__nfet_01v8 L=0.5u W=1u
M17020 o7 ibias vss vss sky130_fd_pr__nfet_01v8 L=0.5u W=1u
M17021 o7 ibias vss vss sky130_fd_pr__nfet_01v8 L=0.5u W=1u
M17022 o7 ibias vss vss sky130_fd_pr__nfet_01v8 L=0.5u W=1u
M17023 o7 ibias vss vss sky130_fd_pr__nfet_01v8 L=0.5u W=1u
M17024 o7 ibias vss vss sky130_fd_pr__nfet_01v8 L=0.5u W=1u
M17025 o7 ibias vss vss sky130_fd_pr__nfet_01v8 L=0.5u W=1u
M17026 o7 ibias vss vss sky130_fd_pr__nfet_01v8 L=0.5u W=1u
M17027 o7 ibias vss vss sky130_fd_pr__nfet_01v8 L=0.5u W=1u
M17028 o7 ibias vss vss sky130_fd_pr__nfet_01v8 L=0.5u W=1u
M17029 o7 ibias vss vss sky130_fd_pr__nfet_01v8 L=0.5u W=1u
M17030 o7 ibias vss vss sky130_fd_pr__nfet_01v8 L=0.5u W=1u
M17031 o7 ibias vss vss sky130_fd_pr__nfet_01v8 L=0.5u W=1u
M17032 o7 ibias vss vss sky130_fd_pr__nfet_01v8 L=0.5u W=1u
M17033 o7 ibias vss vss sky130_fd_pr__nfet_01v8 L=0.5u W=1u
M17034 o7 ibias vss vss sky130_fd_pr__nfet_01v8 L=0.5u W=1u
M17035 o7 ibias vss vss sky130_fd_pr__nfet_01v8 L=0.5u W=1u
M17036 o7 ibias vss vss sky130_fd_pr__nfet_01v8 L=0.5u W=1u
M17037 o7 ibias vss vss sky130_fd_pr__nfet_01v8 L=0.5u W=1u
M17038 o7 ibias vss vss sky130_fd_pr__nfet_01v8 L=0.5u W=1u
M17039 o7 ibias vss vss sky130_fd_pr__nfet_01v8 L=0.5u W=1u
M17040 o7 ibias vss vss sky130_fd_pr__nfet_01v8 L=0.5u W=1u
M17041 o7 ibias vss vss sky130_fd_pr__nfet_01v8 L=0.5u W=1u
M17042 o7 ibias vss vss sky130_fd_pr__nfet_01v8 L=0.5u W=1u
M17043 o7 ibias vss vss sky130_fd_pr__nfet_01v8 L=0.5u W=1u
M17044 o7 ibias vss vss sky130_fd_pr__nfet_01v8 L=0.5u W=1u
M17045 o7 ibias vss vss sky130_fd_pr__nfet_01v8 L=0.5u W=1u
M17046 o7 ibias vss vss sky130_fd_pr__nfet_01v8 L=0.5u W=1u
M17047 o7 ibias vss vss sky130_fd_pr__nfet_01v8 L=0.5u W=1u
M17048 o7 ibias vss vss sky130_fd_pr__nfet_01v8 L=0.5u W=1u
M17049 o7 ibias vss vss sky130_fd_pr__nfet_01v8 L=0.5u W=1u
M17050 o7 ibias vss vss sky130_fd_pr__nfet_01v8 L=0.5u W=1u
M17051 o7 ibias vss vss sky130_fd_pr__nfet_01v8 L=0.5u W=1u
M17052 o7 ibias vss vss sky130_fd_pr__nfet_01v8 L=0.5u W=1u
M17053 o7 ibias vss vss sky130_fd_pr__nfet_01v8 L=0.5u W=1u
M17054 o7 ibias vss vss sky130_fd_pr__nfet_01v8 L=0.5u W=1u
M17055 o7 ibias vss vss sky130_fd_pr__nfet_01v8 L=0.5u W=1u
M17056 o7 ibias vss vss sky130_fd_pr__nfet_01v8 L=0.5u W=1u
M17057 o7 ibias vss vss sky130_fd_pr__nfet_01v8 L=0.5u W=1u
M17058 o7 ibias vss vss sky130_fd_pr__nfet_01v8 L=0.5u W=1u
M17059 o7 ibias vss vss sky130_fd_pr__nfet_01v8 L=0.5u W=1u
M17060 o7 ibias vss vss sky130_fd_pr__nfet_01v8 L=0.5u W=1u
M17061 o7 ibias vss vss sky130_fd_pr__nfet_01v8 L=0.5u W=1u
M17062 o7 ibias vss vss sky130_fd_pr__nfet_01v8 L=0.5u W=1u
M17063 o7 ibias vss vss sky130_fd_pr__nfet_01v8 L=0.5u W=1u
M17064 o7 ibias vss vss sky130_fd_pr__nfet_01v8 L=0.5u W=1u
M17065 o7 ibias vss vss sky130_fd_pr__nfet_01v8 L=0.5u W=1u
M17066 o7 ibias vss vss sky130_fd_pr__nfet_01v8 L=0.5u W=1u
M17067 o7 ibias vss vss sky130_fd_pr__nfet_01v8 L=0.5u W=1u
M17068 o7 ibias vss vss sky130_fd_pr__nfet_01v8 L=0.5u W=1u
M17069 o7 ibias vss vss sky130_fd_pr__nfet_01v8 L=0.5u W=1u
M17070 o7 ibias vss vss sky130_fd_pr__nfet_01v8 L=0.5u W=1u
M17071 o7 ibias vss vss sky130_fd_pr__nfet_01v8 L=0.5u W=1u
M17072 o7 ibias vss vss sky130_fd_pr__nfet_01v8 L=0.5u W=1u
M17073 o7 ibias vss vss sky130_fd_pr__nfet_01v8 L=0.5u W=1u
M17074 o7 ibias vss vss sky130_fd_pr__nfet_01v8 L=0.5u W=1u
M17075 o7 ibias vss vss sky130_fd_pr__nfet_01v8 L=0.5u W=1u
M17076 o7 ibias vss vss sky130_fd_pr__nfet_01v8 L=0.5u W=1u
M17077 o7 ibias vss vss sky130_fd_pr__nfet_01v8 L=0.5u W=1u
M17078 o7 ibias vss vss sky130_fd_pr__nfet_01v8 L=0.5u W=1u
M17079 o7 ibias vss vss sky130_fd_pr__nfet_01v8 L=0.5u W=1u
M17080 o7 ibias vss vss sky130_fd_pr__nfet_01v8 L=0.5u W=1u
M17081 o7 ibias vss vss sky130_fd_pr__nfet_01v8 L=0.5u W=1u
M17082 o7 ibias vss vss sky130_fd_pr__nfet_01v8 L=0.5u W=1u
M17083 o7 ibias vss vss sky130_fd_pr__nfet_01v8 L=0.5u W=1u
M17084 o7 ibias vss vss sky130_fd_pr__nfet_01v8 L=0.5u W=1u
M17085 o7 ibias vss vss sky130_fd_pr__nfet_01v8 L=0.5u W=1u
M17086 o7 ibias vss vss sky130_fd_pr__nfet_01v8 L=0.5u W=1u
M17087 o7 ibias vss vss sky130_fd_pr__nfet_01v8 L=0.5u W=1u
M17088 o7 ibias vss vss sky130_fd_pr__nfet_01v8 L=0.5u W=1u
M17089 o7 ibias vss vss sky130_fd_pr__nfet_01v8 L=0.5u W=1u
M17090 o7 ibias vss vss sky130_fd_pr__nfet_01v8 L=0.5u W=1u
M17091 o7 ibias vss vss sky130_fd_pr__nfet_01v8 L=0.5u W=1u
M17092 o7 ibias vss vss sky130_fd_pr__nfet_01v8 L=0.5u W=1u
M17093 o7 ibias vss vss sky130_fd_pr__nfet_01v8 L=0.5u W=1u
M17094 o7 ibias vss vss sky130_fd_pr__nfet_01v8 L=0.5u W=1u
M17095 o7 ibias vss vss sky130_fd_pr__nfet_01v8 L=0.5u W=1u
M17096 o7 ibias vss vss sky130_fd_pr__nfet_01v8 L=0.5u W=1u
M17097 o7 ibias vss vss sky130_fd_pr__nfet_01v8 L=0.5u W=1u
M17098 o7 ibias vss vss sky130_fd_pr__nfet_01v8 L=0.5u W=1u
M17099 o7 ibias vss vss sky130_fd_pr__nfet_01v8 L=0.5u W=1u
M17100 o7 ibias vss vss sky130_fd_pr__nfet_01v8 L=0.5u W=1u
M17101 o7 ibias vss vss sky130_fd_pr__nfet_01v8 L=0.5u W=1u
M17102 o7 ibias vss vss sky130_fd_pr__nfet_01v8 L=0.5u W=1u
M17103 o7 ibias vss vss sky130_fd_pr__nfet_01v8 L=0.5u W=1u
M17104 o7 ibias vss vss sky130_fd_pr__nfet_01v8 L=0.5u W=1u
M17105 o7 ibias vss vss sky130_fd_pr__nfet_01v8 L=0.5u W=1u
M17106 o7 ibias vss vss sky130_fd_pr__nfet_01v8 L=0.5u W=1u
M17107 o7 ibias vss vss sky130_fd_pr__nfet_01v8 L=0.5u W=1u
M17108 o7 ibias vss vss sky130_fd_pr__nfet_01v8 L=0.5u W=1u
M17109 o7 ibias vss vss sky130_fd_pr__nfet_01v8 L=0.5u W=1u
M17110 o7 ibias vss vss sky130_fd_pr__nfet_01v8 L=0.5u W=1u
M17111 o7 ibias vss vss sky130_fd_pr__nfet_01v8 L=0.5u W=1u
M17112 o7 ibias vss vss sky130_fd_pr__nfet_01v8 L=0.5u W=1u
M17113 o7 ibias vss vss sky130_fd_pr__nfet_01v8 L=0.5u W=1u
M17114 o7 ibias vss vss sky130_fd_pr__nfet_01v8 L=0.5u W=1u
M17115 o7 ibias vss vss sky130_fd_pr__nfet_01v8 L=0.5u W=1u
M17116 o7 ibias vss vss sky130_fd_pr__nfet_01v8 L=0.5u W=1u
M17117 o7 ibias vss vss sky130_fd_pr__nfet_01v8 L=0.5u W=1u
M17118 o7 ibias vss vss sky130_fd_pr__nfet_01v8 L=0.5u W=1u
M17119 o7 ibias vss vss sky130_fd_pr__nfet_01v8 L=0.5u W=1u
M17120 o7 ibias vss vss sky130_fd_pr__nfet_01v8 L=0.5u W=1u
M17121 o7 ibias vss vss sky130_fd_pr__nfet_01v8 L=0.5u W=1u
M17122 o7 ibias vss vss sky130_fd_pr__nfet_01v8 L=0.5u W=1u
M17123 o7 ibias vss vss sky130_fd_pr__nfet_01v8 L=0.5u W=1u
M17124 o7 ibias vss vss sky130_fd_pr__nfet_01v8 L=0.5u W=1u
M17125 o7 ibias vss vss sky130_fd_pr__nfet_01v8 L=0.5u W=1u
M17126 o7 ibias vss vss sky130_fd_pr__nfet_01v8 L=0.5u W=1u
M17127 o7 ibias vss vss sky130_fd_pr__nfet_01v8 L=0.5u W=1u
M17128 o7 ibias vss vss sky130_fd_pr__nfet_01v8 L=0.5u W=1u
M17129 o7 ibias vss vss sky130_fd_pr__nfet_01v8 L=0.5u W=1u
M17130 o7 ibias vss vss sky130_fd_pr__nfet_01v8 L=0.5u W=1u
M17131 o7 ibias vss vss sky130_fd_pr__nfet_01v8 L=0.5u W=1u
M17132 o7 ibias vss vss sky130_fd_pr__nfet_01v8 L=0.5u W=1u
M17133 o7 ibias vss vss sky130_fd_pr__nfet_01v8 L=0.5u W=1u
M17134 o7 ibias vss vss sky130_fd_pr__nfet_01v8 L=0.5u W=1u
M17135 o7 ibias vss vss sky130_fd_pr__nfet_01v8 L=0.5u W=1u
M17136 o7 ibias vss vss sky130_fd_pr__nfet_01v8 L=0.5u W=1u
M17137 o7 ibias vss vss sky130_fd_pr__nfet_01v8 L=0.5u W=1u
M17138 o7 ibias vss vss sky130_fd_pr__nfet_01v8 L=0.5u W=1u
M17139 o7 ibias vss vss sky130_fd_pr__nfet_01v8 L=0.5u W=1u
M17140 o7 ibias vss vss sky130_fd_pr__nfet_01v8 L=0.5u W=1u
M17141 o7 ibias vss vss sky130_fd_pr__nfet_01v8 L=0.5u W=1u
M17142 o7 ibias vss vss sky130_fd_pr__nfet_01v8 L=0.5u W=1u
M17143 o7 ibias vss vss sky130_fd_pr__nfet_01v8 L=0.5u W=1u
M17144 o7 ibias vss vss sky130_fd_pr__nfet_01v8 L=0.5u W=1u
M17145 o7 ibias vss vss sky130_fd_pr__nfet_01v8 L=0.5u W=1u
M17146 o7 ibias vss vss sky130_fd_pr__nfet_01v8 L=0.5u W=1u
M17147 o7 ibias vss vss sky130_fd_pr__nfet_01v8 L=0.5u W=1u
M17148 o7 ibias vss vss sky130_fd_pr__nfet_01v8 L=0.5u W=1u
M17149 o7 ibias vss vss sky130_fd_pr__nfet_01v8 L=0.5u W=1u
M17150 o7 ibias vss vss sky130_fd_pr__nfet_01v8 L=0.5u W=1u
M17151 o7 ibias vss vss sky130_fd_pr__nfet_01v8 L=0.5u W=1u
M17152 o7 ibias vss vss sky130_fd_pr__nfet_01v8 L=0.5u W=1u
M17153 o7 ibias vss vss sky130_fd_pr__nfet_01v8 L=0.5u W=1u
M17154 o7 ibias vss vss sky130_fd_pr__nfet_01v8 L=0.5u W=1u
M17155 o7 ibias vss vss sky130_fd_pr__nfet_01v8 L=0.5u W=1u
M17156 o7 ibias vss vss sky130_fd_pr__nfet_01v8 L=0.5u W=1u
M17157 o7 ibias vss vss sky130_fd_pr__nfet_01v8 L=0.5u W=1u
M17158 o7 ibias vss vss sky130_fd_pr__nfet_01v8 L=0.5u W=1u
M17159 o7 ibias vss vss sky130_fd_pr__nfet_01v8 L=0.5u W=1u
M17160 o7 ibias vss vss sky130_fd_pr__nfet_01v8 L=0.5u W=1u
M17161 o7 ibias vss vss sky130_fd_pr__nfet_01v8 L=0.5u W=1u
M17162 o7 ibias vss vss sky130_fd_pr__nfet_01v8 L=0.5u W=1u
M17163 o7 ibias vss vss sky130_fd_pr__nfet_01v8 L=0.5u W=1u
M17164 o7 ibias vss vss sky130_fd_pr__nfet_01v8 L=0.5u W=1u
M17165 o7 ibias vss vss sky130_fd_pr__nfet_01v8 L=0.5u W=1u
M17166 o7 ibias vss vss sky130_fd_pr__nfet_01v8 L=0.5u W=1u
M17167 o7 ibias vss vss sky130_fd_pr__nfet_01v8 L=0.5u W=1u
M17168 o7 ibias vss vss sky130_fd_pr__nfet_01v8 L=0.5u W=1u
M17169 o7 ibias vss vss sky130_fd_pr__nfet_01v8 L=0.5u W=1u
M17170 o7 ibias vss vss sky130_fd_pr__nfet_01v8 L=0.5u W=1u
M17171 o7 ibias vss vss sky130_fd_pr__nfet_01v8 L=0.5u W=1u
M17172 o7 ibias vss vss sky130_fd_pr__nfet_01v8 L=0.5u W=1u
M17173 o7 ibias vss vss sky130_fd_pr__nfet_01v8 L=0.5u W=1u
M17174 o7 ibias vss vss sky130_fd_pr__nfet_01v8 L=0.5u W=1u
M17175 o7 ibias vss vss sky130_fd_pr__nfet_01v8 L=0.5u W=1u
M17176 o7 ibias vss vss sky130_fd_pr__nfet_01v8 L=0.5u W=1u
M17177 o7 ibias vss vss sky130_fd_pr__nfet_01v8 L=0.5u W=1u
M17178 o7 ibias vss vss sky130_fd_pr__nfet_01v8 L=0.5u W=1u
M17179 o7 ibias vss vss sky130_fd_pr__nfet_01v8 L=0.5u W=1u
M17180 o7 ibias vss vss sky130_fd_pr__nfet_01v8 L=0.5u W=1u
M17181 o7 ibias vss vss sky130_fd_pr__nfet_01v8 L=0.5u W=1u
M17182 o7 ibias vss vss sky130_fd_pr__nfet_01v8 L=0.5u W=1u
M17183 o7 ibias vss vss sky130_fd_pr__nfet_01v8 L=0.5u W=1u
M17184 o7 ibias vss vss sky130_fd_pr__nfet_01v8 L=0.5u W=1u
M17185 o7 ibias vss vss sky130_fd_pr__nfet_01v8 L=0.5u W=1u
M17186 o7 ibias vss vss sky130_fd_pr__nfet_01v8 L=0.5u W=1u
M17187 o7 ibias vss vss sky130_fd_pr__nfet_01v8 L=0.5u W=1u
M17188 o7 ibias vss vss sky130_fd_pr__nfet_01v8 L=0.5u W=1u
M17189 o7 ibias vss vss sky130_fd_pr__nfet_01v8 L=0.5u W=1u
M17190 o7 ibias vss vss sky130_fd_pr__nfet_01v8 L=0.5u W=1u
M17191 o7 ibias vss vss sky130_fd_pr__nfet_01v8 L=0.5u W=1u
M17192 o7 ibias vss vss sky130_fd_pr__nfet_01v8 L=0.5u W=1u
M17193 o7 ibias vss vss sky130_fd_pr__nfet_01v8 L=0.5u W=1u
M17194 o7 ibias vss vss sky130_fd_pr__nfet_01v8 L=0.5u W=1u
M17195 o7 ibias vss vss sky130_fd_pr__nfet_01v8 L=0.5u W=1u
M17196 o7 ibias vss vss sky130_fd_pr__nfet_01v8 L=0.5u W=1u
M17197 o7 ibias vss vss sky130_fd_pr__nfet_01v8 L=0.5u W=1u
M17198 o7 ibias vss vss sky130_fd_pr__nfet_01v8 L=0.5u W=1u
M17199 o7 ibias vss vss sky130_fd_pr__nfet_01v8 L=0.5u W=1u
M17200 o7 ibias vss vss sky130_fd_pr__nfet_01v8 L=0.5u W=1u
M17201 o7 ibias vss vss sky130_fd_pr__nfet_01v8 L=0.5u W=1u
M17202 o7 ibias vss vss sky130_fd_pr__nfet_01v8 L=0.5u W=1u
M17203 o7 ibias vss vss sky130_fd_pr__nfet_01v8 L=0.5u W=1u
M17204 o7 ibias vss vss sky130_fd_pr__nfet_01v8 L=0.5u W=1u
M17205 o7 ibias vss vss sky130_fd_pr__nfet_01v8 L=0.5u W=1u
M17206 o7 ibias vss vss sky130_fd_pr__nfet_01v8 L=0.5u W=1u
M17207 o7 ibias vss vss sky130_fd_pr__nfet_01v8 L=0.5u W=1u
M17208 o7 ibias vss vss sky130_fd_pr__nfet_01v8 L=0.5u W=1u
M17209 o7 ibias vss vss sky130_fd_pr__nfet_01v8 L=0.5u W=1u
M17210 o7 ibias vss vss sky130_fd_pr__nfet_01v8 L=0.5u W=1u
M17211 o7 ibias vss vss sky130_fd_pr__nfet_01v8 L=0.5u W=1u
M17212 o7 ibias vss vss sky130_fd_pr__nfet_01v8 L=0.5u W=1u
M17213 o7 ibias vss vss sky130_fd_pr__nfet_01v8 L=0.5u W=1u
M17214 o7 ibias vss vss sky130_fd_pr__nfet_01v8 L=0.5u W=1u
M17215 o7 ibias vss vss sky130_fd_pr__nfet_01v8 L=0.5u W=1u
M17216 o7 ibias vss vss sky130_fd_pr__nfet_01v8 L=0.5u W=1u
M17217 o7 ibias vss vss sky130_fd_pr__nfet_01v8 L=0.5u W=1u
M17218 o7 ibias vss vss sky130_fd_pr__nfet_01v8 L=0.5u W=1u
M17219 o7 ibias vss vss sky130_fd_pr__nfet_01v8 L=0.5u W=1u
M17220 o7 ibias vss vss sky130_fd_pr__nfet_01v8 L=0.5u W=1u
M17221 o7 ibias vss vss sky130_fd_pr__nfet_01v8 L=0.5u W=1u
M17222 o7 ibias vss vss sky130_fd_pr__nfet_01v8 L=0.5u W=1u
M17223 o7 ibias vss vss sky130_fd_pr__nfet_01v8 L=0.5u W=1u
M17224 o7 ibias vss vss sky130_fd_pr__nfet_01v8 L=0.5u W=1u
M17225 o7 ibias vss vss sky130_fd_pr__nfet_01v8 L=0.5u W=1u
M17226 o7 ibias vss vss sky130_fd_pr__nfet_01v8 L=0.5u W=1u
M17227 o7 ibias vss vss sky130_fd_pr__nfet_01v8 L=0.5u W=1u
M17228 o7 ibias vss vss sky130_fd_pr__nfet_01v8 L=0.5u W=1u
M17229 o7 ibias vss vss sky130_fd_pr__nfet_01v8 L=0.5u W=1u
M17230 o7 ibias vss vss sky130_fd_pr__nfet_01v8 L=0.5u W=1u
M17231 o7 ibias vss vss sky130_fd_pr__nfet_01v8 L=0.5u W=1u
M17232 o7 ibias vss vss sky130_fd_pr__nfet_01v8 L=0.5u W=1u
M17233 o7 ibias vss vss sky130_fd_pr__nfet_01v8 L=0.5u W=1u
M17234 o7 ibias vss vss sky130_fd_pr__nfet_01v8 L=0.5u W=1u
M17235 o7 ibias vss vss sky130_fd_pr__nfet_01v8 L=0.5u W=1u
M17236 o7 ibias vss vss sky130_fd_pr__nfet_01v8 L=0.5u W=1u
M17237 o7 ibias vss vss sky130_fd_pr__nfet_01v8 L=0.5u W=1u
M17238 o7 ibias vss vss sky130_fd_pr__nfet_01v8 L=0.5u W=1u
M17239 o7 ibias vss vss sky130_fd_pr__nfet_01v8 L=0.5u W=1u
M17240 o7 ibias vss vss sky130_fd_pr__nfet_01v8 L=0.5u W=1u
M17241 o7 ibias vss vss sky130_fd_pr__nfet_01v8 L=0.5u W=1u
M17242 o7 ibias vss vss sky130_fd_pr__nfet_01v8 L=0.5u W=1u
M17243 o7 ibias vss vss sky130_fd_pr__nfet_01v8 L=0.5u W=1u
M17244 o7 ibias vss vss sky130_fd_pr__nfet_01v8 L=0.5u W=1u
M17245 o7 ibias vss vss sky130_fd_pr__nfet_01v8 L=0.5u W=1u
M17246 o7 ibias vss vss sky130_fd_pr__nfet_01v8 L=0.5u W=1u
M17247 o7 ibias vss vss sky130_fd_pr__nfet_01v8 L=0.5u W=1u
M17248 o7 ibias vss vss sky130_fd_pr__nfet_01v8 L=0.5u W=1u
M17249 o7 ibias vss vss sky130_fd_pr__nfet_01v8 L=0.5u W=1u
M17250 o7 ibias vss vss sky130_fd_pr__nfet_01v8 L=0.5u W=1u
M17251 o7 ibias vss vss sky130_fd_pr__nfet_01v8 L=0.5u W=1u
M17252 o7 ibias vss vss sky130_fd_pr__nfet_01v8 L=0.5u W=1u
M17253 o7 ibias vss vss sky130_fd_pr__nfet_01v8 L=0.5u W=1u
M17254 o7 ibias vss vss sky130_fd_pr__nfet_01v8 L=0.5u W=1u
M17255 o7 ibias vss vss sky130_fd_pr__nfet_01v8 L=0.5u W=1u
M17256 o7 ibias vss vss sky130_fd_pr__nfet_01v8 L=0.5u W=1u
M17257 o7 ibias vss vss sky130_fd_pr__nfet_01v8 L=0.5u W=1u
M17258 o7 ibias vss vss sky130_fd_pr__nfet_01v8 L=0.5u W=1u
M17259 o7 ibias vss vss sky130_fd_pr__nfet_01v8 L=0.5u W=1u
M17260 o7 ibias vss vss sky130_fd_pr__nfet_01v8 L=0.5u W=1u
M17261 o7 ibias vss vss sky130_fd_pr__nfet_01v8 L=0.5u W=1u
M17262 o7 ibias vss vss sky130_fd_pr__nfet_01v8 L=0.5u W=1u
M17263 o7 ibias vss vss sky130_fd_pr__nfet_01v8 L=0.5u W=1u
M17264 o7 ibias vss vss sky130_fd_pr__nfet_01v8 L=0.5u W=1u
M17265 o7 ibias vss vss sky130_fd_pr__nfet_01v8 L=0.5u W=1u
M17266 o7 ibias vss vss sky130_fd_pr__nfet_01v8 L=0.5u W=1u
M17267 o7 ibias vss vss sky130_fd_pr__nfet_01v8 L=0.5u W=1u
M17268 o7 ibias vss vss sky130_fd_pr__nfet_01v8 L=0.5u W=1u
M17269 o7 ibias vss vss sky130_fd_pr__nfet_01v8 L=0.5u W=1u
M17270 o7 ibias vss vss sky130_fd_pr__nfet_01v8 L=0.5u W=1u
M17271 o7 ibias vss vss sky130_fd_pr__nfet_01v8 L=0.5u W=1u
M17272 o7 ibias vss vss sky130_fd_pr__nfet_01v8 L=0.5u W=1u
M17273 o7 ibias vss vss sky130_fd_pr__nfet_01v8 L=0.5u W=1u
M17274 o7 ibias vss vss sky130_fd_pr__nfet_01v8 L=0.5u W=1u
M17275 o7 ibias vss vss sky130_fd_pr__nfet_01v8 L=0.5u W=1u
M17276 o7 ibias vss vss sky130_fd_pr__nfet_01v8 L=0.5u W=1u
M17277 o7 ibias vss vss sky130_fd_pr__nfet_01v8 L=0.5u W=1u
M17278 o7 ibias vss vss sky130_fd_pr__nfet_01v8 L=0.5u W=1u
M17279 o7 ibias vss vss sky130_fd_pr__nfet_01v8 L=0.5u W=1u
M17280 o7 ibias vss vss sky130_fd_pr__nfet_01v8 L=0.5u W=1u
M17281 o7 ibias vss vss sky130_fd_pr__nfet_01v8 L=0.5u W=1u
M17282 o7 ibias vss vss sky130_fd_pr__nfet_01v8 L=0.5u W=1u
M17283 o7 ibias vss vss sky130_fd_pr__nfet_01v8 L=0.5u W=1u
M17284 o7 ibias vss vss sky130_fd_pr__nfet_01v8 L=0.5u W=1u
M17285 o7 ibias vss vss sky130_fd_pr__nfet_01v8 L=0.5u W=1u
M17286 o7 ibias vss vss sky130_fd_pr__nfet_01v8 L=0.5u W=1u
M17287 o7 ibias vss vss sky130_fd_pr__nfet_01v8 L=0.5u W=1u
M17288 o7 ibias vss vss sky130_fd_pr__nfet_01v8 L=0.5u W=1u
M17289 o7 ibias vss vss sky130_fd_pr__nfet_01v8 L=0.5u W=1u
M17290 o7 ibias vss vss sky130_fd_pr__nfet_01v8 L=0.5u W=1u
M17291 o7 ibias vss vss sky130_fd_pr__nfet_01v8 L=0.5u W=1u
M17292 o7 ibias vss vss sky130_fd_pr__nfet_01v8 L=0.5u W=1u
M17293 o7 ibias vss vss sky130_fd_pr__nfet_01v8 L=0.5u W=1u
M17294 o7 ibias vss vss sky130_fd_pr__nfet_01v8 L=0.5u W=1u
M17295 o7 ibias vss vss sky130_fd_pr__nfet_01v8 L=0.5u W=1u
M17296 o7 ibias vss vss sky130_fd_pr__nfet_01v8 L=0.5u W=1u
M17297 o7 ibias vss vss sky130_fd_pr__nfet_01v8 L=0.5u W=1u
M17298 o7 ibias vss vss sky130_fd_pr__nfet_01v8 L=0.5u W=1u
M17299 o7 ibias vss vss sky130_fd_pr__nfet_01v8 L=0.5u W=1u
M17300 o7 ibias vss vss sky130_fd_pr__nfet_01v8 L=0.5u W=1u
M17301 o7 ibias vss vss sky130_fd_pr__nfet_01v8 L=0.5u W=1u
M17302 o7 ibias vss vss sky130_fd_pr__nfet_01v8 L=0.5u W=1u
M17303 o7 ibias vss vss sky130_fd_pr__nfet_01v8 L=0.5u W=1u
M17304 o7 ibias vss vss sky130_fd_pr__nfet_01v8 L=0.5u W=1u
M17305 o7 ibias vss vss sky130_fd_pr__nfet_01v8 L=0.5u W=1u
M17306 o7 ibias vss vss sky130_fd_pr__nfet_01v8 L=0.5u W=1u
M17307 o7 ibias vss vss sky130_fd_pr__nfet_01v8 L=0.5u W=1u
M17308 o7 ibias vss vss sky130_fd_pr__nfet_01v8 L=0.5u W=1u
M17309 o7 ibias vss vss sky130_fd_pr__nfet_01v8 L=0.5u W=1u
M17310 o7 ibias vss vss sky130_fd_pr__nfet_01v8 L=0.5u W=1u
M17311 o7 ibias vss vss sky130_fd_pr__nfet_01v8 L=0.5u W=1u
M17312 o7 ibias vss vss sky130_fd_pr__nfet_01v8 L=0.5u W=1u
M17313 o7 ibias vss vss sky130_fd_pr__nfet_01v8 L=0.5u W=1u
M17314 o7 ibias vss vss sky130_fd_pr__nfet_01v8 L=0.5u W=1u
M17315 o7 ibias vss vss sky130_fd_pr__nfet_01v8 L=0.5u W=1u
M17316 o7 ibias vss vss sky130_fd_pr__nfet_01v8 L=0.5u W=1u
M17317 o7 ibias vss vss sky130_fd_pr__nfet_01v8 L=0.5u W=1u
M17318 o7 ibias vss vss sky130_fd_pr__nfet_01v8 L=0.5u W=1u
M17319 o7 ibias vss vss sky130_fd_pr__nfet_01v8 L=0.5u W=1u
M17320 o7 ibias vss vss sky130_fd_pr__nfet_01v8 L=0.5u W=1u
M17321 o7 ibias vss vss sky130_fd_pr__nfet_01v8 L=0.5u W=1u
M17322 o7 ibias vss vss sky130_fd_pr__nfet_01v8 L=0.5u W=1u
M17323 o7 ibias vss vss sky130_fd_pr__nfet_01v8 L=0.5u W=1u
M17324 o7 ibias vss vss sky130_fd_pr__nfet_01v8 L=0.5u W=1u
M17325 o7 ibias vss vss sky130_fd_pr__nfet_01v8 L=0.5u W=1u
M17326 o7 ibias vss vss sky130_fd_pr__nfet_01v8 L=0.5u W=1u
M17327 o7 ibias vss vss sky130_fd_pr__nfet_01v8 L=0.5u W=1u
M17328 o7 ibias vss vss sky130_fd_pr__nfet_01v8 L=0.5u W=1u
M17329 o7 ibias vss vss sky130_fd_pr__nfet_01v8 L=0.5u W=1u
M17330 o7 ibias vss vss sky130_fd_pr__nfet_01v8 L=0.5u W=1u
M17331 o7 ibias vss vss sky130_fd_pr__nfet_01v8 L=0.5u W=1u
M17332 o7 ibias vss vss sky130_fd_pr__nfet_01v8 L=0.5u W=1u
M17333 o7 ibias vss vss sky130_fd_pr__nfet_01v8 L=0.5u W=1u
M17334 o7 ibias vss vss sky130_fd_pr__nfet_01v8 L=0.5u W=1u
M17335 o7 ibias vss vss sky130_fd_pr__nfet_01v8 L=0.5u W=1u
M17336 o7 ibias vss vss sky130_fd_pr__nfet_01v8 L=0.5u W=1u
M17337 o7 ibias vss vss sky130_fd_pr__nfet_01v8 L=0.5u W=1u
M17338 o7 ibias vss vss sky130_fd_pr__nfet_01v8 L=0.5u W=1u
M17339 o7 ibias vss vss sky130_fd_pr__nfet_01v8 L=0.5u W=1u
M17340 o7 ibias vss vss sky130_fd_pr__nfet_01v8 L=0.5u W=1u
M17341 o7 ibias vss vss sky130_fd_pr__nfet_01v8 L=0.5u W=1u
M17342 o7 ibias vss vss sky130_fd_pr__nfet_01v8 L=0.5u W=1u
M17343 o7 ibias vss vss sky130_fd_pr__nfet_01v8 L=0.5u W=1u
M17344 o7 ibias vss vss sky130_fd_pr__nfet_01v8 L=0.5u W=1u
M17345 o7 ibias vss vss sky130_fd_pr__nfet_01v8 L=0.5u W=1u
M17346 o7 ibias vss vss sky130_fd_pr__nfet_01v8 L=0.5u W=1u
M17347 o7 ibias vss vss sky130_fd_pr__nfet_01v8 L=0.5u W=1u
M17348 o7 ibias vss vss sky130_fd_pr__nfet_01v8 L=0.5u W=1u
M17349 o7 ibias vss vss sky130_fd_pr__nfet_01v8 L=0.5u W=1u
M17350 o7 ibias vss vss sky130_fd_pr__nfet_01v8 L=0.5u W=1u
M17351 o7 ibias vss vss sky130_fd_pr__nfet_01v8 L=0.5u W=1u
M17352 o7 ibias vss vss sky130_fd_pr__nfet_01v8 L=0.5u W=1u
M17353 o7 ibias vss vss sky130_fd_pr__nfet_01v8 L=0.5u W=1u
M17354 o7 ibias vss vss sky130_fd_pr__nfet_01v8 L=0.5u W=1u
M17355 o7 ibias vss vss sky130_fd_pr__nfet_01v8 L=0.5u W=1u
M17356 o7 ibias vss vss sky130_fd_pr__nfet_01v8 L=0.5u W=1u
M17357 o7 ibias vss vss sky130_fd_pr__nfet_01v8 L=0.5u W=1u
M17358 o7 ibias vss vss sky130_fd_pr__nfet_01v8 L=0.5u W=1u
M17359 o7 ibias vss vss sky130_fd_pr__nfet_01v8 L=0.5u W=1u
M17360 o7 ibias vss vss sky130_fd_pr__nfet_01v8 L=0.5u W=1u
M17361 o7 ibias vss vss sky130_fd_pr__nfet_01v8 L=0.5u W=1u
M17362 o7 ibias vss vss sky130_fd_pr__nfet_01v8 L=0.5u W=1u
M17363 o7 ibias vss vss sky130_fd_pr__nfet_01v8 L=0.5u W=1u
M17364 o7 ibias vss vss sky130_fd_pr__nfet_01v8 L=0.5u W=1u
M17365 o7 ibias vss vss sky130_fd_pr__nfet_01v8 L=0.5u W=1u
M17366 o7 ibias vss vss sky130_fd_pr__nfet_01v8 L=0.5u W=1u
M17367 o7 ibias vss vss sky130_fd_pr__nfet_01v8 L=0.5u W=1u
M17368 o7 ibias vss vss sky130_fd_pr__nfet_01v8 L=0.5u W=1u
M17369 o7 ibias vss vss sky130_fd_pr__nfet_01v8 L=0.5u W=1u
M17370 o7 ibias vss vss sky130_fd_pr__nfet_01v8 L=0.5u W=1u
M17371 o7 ibias vss vss sky130_fd_pr__nfet_01v8 L=0.5u W=1u
M17372 o7 ibias vss vss sky130_fd_pr__nfet_01v8 L=0.5u W=1u
M17373 o7 ibias vss vss sky130_fd_pr__nfet_01v8 L=0.5u W=1u
M17374 o7 ibias vss vss sky130_fd_pr__nfet_01v8 L=0.5u W=1u
M17375 o7 ibias vss vss sky130_fd_pr__nfet_01v8 L=0.5u W=1u
M17376 o7 ibias vss vss sky130_fd_pr__nfet_01v8 L=0.5u W=1u
M17377 o7 ibias vss vss sky130_fd_pr__nfet_01v8 L=0.5u W=1u
M17378 o7 ibias vss vss sky130_fd_pr__nfet_01v8 L=0.5u W=1u
M17379 o7 ibias vss vss sky130_fd_pr__nfet_01v8 L=0.5u W=1u
M17380 o7 ibias vss vss sky130_fd_pr__nfet_01v8 L=0.5u W=1u
M17381 o7 ibias vss vss sky130_fd_pr__nfet_01v8 L=0.5u W=1u
M17382 o7 ibias vss vss sky130_fd_pr__nfet_01v8 L=0.5u W=1u
M17383 o7 ibias vss vss sky130_fd_pr__nfet_01v8 L=0.5u W=1u
M17384 o7 ibias vss vss sky130_fd_pr__nfet_01v8 L=0.5u W=1u
M17385 o7 ibias vss vss sky130_fd_pr__nfet_01v8 L=0.5u W=1u
M17386 o7 ibias vss vss sky130_fd_pr__nfet_01v8 L=0.5u W=1u
M17387 o7 ibias vss vss sky130_fd_pr__nfet_01v8 L=0.5u W=1u
M17388 o7 ibias vss vss sky130_fd_pr__nfet_01v8 L=0.5u W=1u
M17389 o7 ibias vss vss sky130_fd_pr__nfet_01v8 L=0.5u W=1u
M17390 o7 ibias vss vss sky130_fd_pr__nfet_01v8 L=0.5u W=1u
M17391 o7 ibias vss vss sky130_fd_pr__nfet_01v8 L=0.5u W=1u
M17392 o7 ibias vss vss sky130_fd_pr__nfet_01v8 L=0.5u W=1u
M17393 o7 ibias vss vss sky130_fd_pr__nfet_01v8 L=0.5u W=1u
M17394 o7 ibias vss vss sky130_fd_pr__nfet_01v8 L=0.5u W=1u
M17395 o7 ibias vss vss sky130_fd_pr__nfet_01v8 L=0.5u W=1u
M17396 o7 ibias vss vss sky130_fd_pr__nfet_01v8 L=0.5u W=1u
M17397 o7 ibias vss vss sky130_fd_pr__nfet_01v8 L=0.5u W=1u
M17398 o7 ibias vss vss sky130_fd_pr__nfet_01v8 L=0.5u W=1u
M17399 o7 ibias vss vss sky130_fd_pr__nfet_01v8 L=0.5u W=1u
M17400 o7 ibias vss vss sky130_fd_pr__nfet_01v8 L=0.5u W=1u
M17401 o7 ibias vss vss sky130_fd_pr__nfet_01v8 L=0.5u W=1u
M17402 o7 ibias vss vss sky130_fd_pr__nfet_01v8 L=0.5u W=1u
M17403 o7 ibias vss vss sky130_fd_pr__nfet_01v8 L=0.5u W=1u
M17404 o7 ibias vss vss sky130_fd_pr__nfet_01v8 L=0.5u W=1u
M17405 o7 ibias vss vss sky130_fd_pr__nfet_01v8 L=0.5u W=1u
M17406 o7 ibias vss vss sky130_fd_pr__nfet_01v8 L=0.5u W=1u
M17407 o7 ibias vss vss sky130_fd_pr__nfet_01v8 L=0.5u W=1u
M17408 o7 ibias vss vss sky130_fd_pr__nfet_01v8 L=0.5u W=1u
M17409 o7 ibias vss vss sky130_fd_pr__nfet_01v8 L=0.5u W=1u
M17410 o7 ibias vss vss sky130_fd_pr__nfet_01v8 L=0.5u W=1u
M17411 o7 ibias vss vss sky130_fd_pr__nfet_01v8 L=0.5u W=1u
M17412 o7 ibias vss vss sky130_fd_pr__nfet_01v8 L=0.5u W=1u
M17413 o7 ibias vss vss sky130_fd_pr__nfet_01v8 L=0.5u W=1u
M17414 o7 ibias vss vss sky130_fd_pr__nfet_01v8 L=0.5u W=1u
M17415 o7 ibias vss vss sky130_fd_pr__nfet_01v8 L=0.5u W=1u
M17416 o7 ibias vss vss sky130_fd_pr__nfet_01v8 L=0.5u W=1u
M17417 o7 ibias vss vss sky130_fd_pr__nfet_01v8 L=0.5u W=1u
M17418 o7 ibias vss vss sky130_fd_pr__nfet_01v8 L=0.5u W=1u
M17419 o7 ibias vss vss sky130_fd_pr__nfet_01v8 L=0.5u W=1u
M17420 o7 ibias vss vss sky130_fd_pr__nfet_01v8 L=0.5u W=1u
M17421 o7 ibias vss vss sky130_fd_pr__nfet_01v8 L=0.5u W=1u
M17422 o7 ibias vss vss sky130_fd_pr__nfet_01v8 L=0.5u W=1u
M17423 o7 ibias vss vss sky130_fd_pr__nfet_01v8 L=0.5u W=1u
M17424 o7 ibias vss vss sky130_fd_pr__nfet_01v8 L=0.5u W=1u
M17425 o7 ibias vss vss sky130_fd_pr__nfet_01v8 L=0.5u W=1u
M17426 o7 ibias vss vss sky130_fd_pr__nfet_01v8 L=0.5u W=1u
M17427 o7 ibias vss vss sky130_fd_pr__nfet_01v8 L=0.5u W=1u
M17428 o7 ibias vss vss sky130_fd_pr__nfet_01v8 L=0.5u W=1u
M17429 o7 ibias vss vss sky130_fd_pr__nfet_01v8 L=0.5u W=1u
M17430 o7 ibias vss vss sky130_fd_pr__nfet_01v8 L=0.5u W=1u
M17431 o7 ibias vss vss sky130_fd_pr__nfet_01v8 L=0.5u W=1u
M17432 o7 ibias vss vss sky130_fd_pr__nfet_01v8 L=0.5u W=1u
M17433 o7 ibias vss vss sky130_fd_pr__nfet_01v8 L=0.5u W=1u
M17434 o7 ibias vss vss sky130_fd_pr__nfet_01v8 L=0.5u W=1u
M17435 o7 ibias vss vss sky130_fd_pr__nfet_01v8 L=0.5u W=1u
M17436 o7 ibias vss vss sky130_fd_pr__nfet_01v8 L=0.5u W=1u
M17437 o7 ibias vss vss sky130_fd_pr__nfet_01v8 L=0.5u W=1u
M17438 o7 ibias vss vss sky130_fd_pr__nfet_01v8 L=0.5u W=1u
M17439 o7 ibias vss vss sky130_fd_pr__nfet_01v8 L=0.5u W=1u
M17440 o7 ibias vss vss sky130_fd_pr__nfet_01v8 L=0.5u W=1u
M17441 o7 ibias vss vss sky130_fd_pr__nfet_01v8 L=0.5u W=1u
M17442 o7 ibias vss vss sky130_fd_pr__nfet_01v8 L=0.5u W=1u
M17443 o7 ibias vss vss sky130_fd_pr__nfet_01v8 L=0.5u W=1u
M17444 o7 ibias vss vss sky130_fd_pr__nfet_01v8 L=0.5u W=1u
M17445 o7 ibias vss vss sky130_fd_pr__nfet_01v8 L=0.5u W=1u
M17446 o7 ibias vss vss sky130_fd_pr__nfet_01v8 L=0.5u W=1u
M17447 o7 ibias vss vss sky130_fd_pr__nfet_01v8 L=0.5u W=1u
M17448 o7 ibias vss vss sky130_fd_pr__nfet_01v8 L=0.5u W=1u
M17449 o7 ibias vss vss sky130_fd_pr__nfet_01v8 L=0.5u W=1u
M17450 o7 ibias vss vss sky130_fd_pr__nfet_01v8 L=0.5u W=1u
M17451 o7 ibias vss vss sky130_fd_pr__nfet_01v8 L=0.5u W=1u
M17452 o7 ibias vss vss sky130_fd_pr__nfet_01v8 L=0.5u W=1u
M17453 o7 ibias vss vss sky130_fd_pr__nfet_01v8 L=0.5u W=1u
M17454 o7 ibias vss vss sky130_fd_pr__nfet_01v8 L=0.5u W=1u
M17455 o7 ibias vss vss sky130_fd_pr__nfet_01v8 L=0.5u W=1u
M17456 o7 ibias vss vss sky130_fd_pr__nfet_01v8 L=0.5u W=1u
M17457 o7 ibias vss vss sky130_fd_pr__nfet_01v8 L=0.5u W=1u
M17458 o7 ibias vss vss sky130_fd_pr__nfet_01v8 L=0.5u W=1u
M17459 o7 ibias vss vss sky130_fd_pr__nfet_01v8 L=0.5u W=1u
M17460 o7 ibias vss vss sky130_fd_pr__nfet_01v8 L=0.5u W=1u
M17461 o7 ibias vss vss sky130_fd_pr__nfet_01v8 L=0.5u W=1u
M17462 o7 ibias vss vss sky130_fd_pr__nfet_01v8 L=0.5u W=1u
M17463 o7 ibias vss vss sky130_fd_pr__nfet_01v8 L=0.5u W=1u
M17464 o7 ibias vss vss sky130_fd_pr__nfet_01v8 L=0.5u W=1u
M17465 o7 ibias vss vss sky130_fd_pr__nfet_01v8 L=0.5u W=1u
M17466 o7 ibias vss vss sky130_fd_pr__nfet_01v8 L=0.5u W=1u
M17467 o7 ibias vss vss sky130_fd_pr__nfet_01v8 L=0.5u W=1u
M17468 o7 ibias vss vss sky130_fd_pr__nfet_01v8 L=0.5u W=1u
M17469 o7 ibias vss vss sky130_fd_pr__nfet_01v8 L=0.5u W=1u
M17470 o7 ibias vss vss sky130_fd_pr__nfet_01v8 L=0.5u W=1u
M17471 o7 ibias vss vss sky130_fd_pr__nfet_01v8 L=0.5u W=1u
M17472 o7 ibias vss vss sky130_fd_pr__nfet_01v8 L=0.5u W=1u
M17473 o7 ibias vss vss sky130_fd_pr__nfet_01v8 L=0.5u W=1u
M17474 o7 ibias vss vss sky130_fd_pr__nfet_01v8 L=0.5u W=1u
M17475 o7 ibias vss vss sky130_fd_pr__nfet_01v8 L=0.5u W=1u
M17476 o7 ibias vss vss sky130_fd_pr__nfet_01v8 L=0.5u W=1u
M17477 o7 ibias vss vss sky130_fd_pr__nfet_01v8 L=0.5u W=1u
M17478 o7 ibias vss vss sky130_fd_pr__nfet_01v8 L=0.5u W=1u
M17479 o7 ibias vss vss sky130_fd_pr__nfet_01v8 L=0.5u W=1u
M17480 o7 ibias vss vss sky130_fd_pr__nfet_01v8 L=0.5u W=1u
M17481 o7 ibias vss vss sky130_fd_pr__nfet_01v8 L=0.5u W=1u
M17482 o7 ibias vss vss sky130_fd_pr__nfet_01v8 L=0.5u W=1u
M17483 o7 ibias vss vss sky130_fd_pr__nfet_01v8 L=0.5u W=1u
M17484 o7 ibias vss vss sky130_fd_pr__nfet_01v8 L=0.5u W=1u
M17485 o7 ibias vss vss sky130_fd_pr__nfet_01v8 L=0.5u W=1u
M17486 o7 ibias vss vss sky130_fd_pr__nfet_01v8 L=0.5u W=1u
M17487 o7 ibias vss vss sky130_fd_pr__nfet_01v8 L=0.5u W=1u
M17488 o7 ibias vss vss sky130_fd_pr__nfet_01v8 L=0.5u W=1u
M17489 o7 ibias vss vss sky130_fd_pr__nfet_01v8 L=0.5u W=1u
M17490 o7 ibias vss vss sky130_fd_pr__nfet_01v8 L=0.5u W=1u
M17491 o7 ibias vss vss sky130_fd_pr__nfet_01v8 L=0.5u W=1u
M17492 o7 ibias vss vss sky130_fd_pr__nfet_01v8 L=0.5u W=1u
M17493 o7 ibias vss vss sky130_fd_pr__nfet_01v8 L=0.5u W=1u
M17494 o7 ibias vss vss sky130_fd_pr__nfet_01v8 L=0.5u W=1u
M17495 o7 ibias vss vss sky130_fd_pr__nfet_01v8 L=0.5u W=1u
M17496 o7 ibias vss vss sky130_fd_pr__nfet_01v8 L=0.5u W=1u
M17497 o7 ibias vss vss sky130_fd_pr__nfet_01v8 L=0.5u W=1u
M17498 o7 ibias vss vss sky130_fd_pr__nfet_01v8 L=0.5u W=1u
M17499 o7 ibias vss vss sky130_fd_pr__nfet_01v8 L=0.5u W=1u
M17500 o7 ibias vss vss sky130_fd_pr__nfet_01v8 L=0.5u W=1u
M17501 o7 ibias vss vss sky130_fd_pr__nfet_01v8 L=0.5u W=1u
M17502 o7 ibias vss vss sky130_fd_pr__nfet_01v8 L=0.5u W=1u
M17503 o7 ibias vss vss sky130_fd_pr__nfet_01v8 L=0.5u W=1u
M17504 o7 ibias vss vss sky130_fd_pr__nfet_01v8 L=0.5u W=1u
M17505 o7 ibias vss vss sky130_fd_pr__nfet_01v8 L=0.5u W=1u
M17506 o7 ibias vss vss sky130_fd_pr__nfet_01v8 L=0.5u W=1u
M17507 o7 ibias vss vss sky130_fd_pr__nfet_01v8 L=0.5u W=1u
M17508 o7 ibias vss vss sky130_fd_pr__nfet_01v8 L=0.5u W=1u
M17509 o7 ibias vss vss sky130_fd_pr__nfet_01v8 L=0.5u W=1u
M17510 o7 ibias vss vss sky130_fd_pr__nfet_01v8 L=0.5u W=1u
M17511 o7 ibias vss vss sky130_fd_pr__nfet_01v8 L=0.5u W=1u
M17512 o7 ibias vss vss sky130_fd_pr__nfet_01v8 L=0.5u W=1u
M17513 o7 ibias vss vss sky130_fd_pr__nfet_01v8 L=0.5u W=1u
M17514 o7 ibias vss vss sky130_fd_pr__nfet_01v8 L=0.5u W=1u
M17515 o7 ibias vss vss sky130_fd_pr__nfet_01v8 L=0.5u W=1u
M17516 o7 ibias vss vss sky130_fd_pr__nfet_01v8 L=0.5u W=1u
M17517 o7 ibias vss vss sky130_fd_pr__nfet_01v8 L=0.5u W=1u
M17518 o7 ibias vss vss sky130_fd_pr__nfet_01v8 L=0.5u W=1u
M17519 o7 ibias vss vss sky130_fd_pr__nfet_01v8 L=0.5u W=1u
M17520 o7 ibias vss vss sky130_fd_pr__nfet_01v8 L=0.5u W=1u
M17521 o7 ibias vss vss sky130_fd_pr__nfet_01v8 L=0.5u W=1u
M17522 o7 ibias vss vss sky130_fd_pr__nfet_01v8 L=0.5u W=1u
M17523 o7 ibias vss vss sky130_fd_pr__nfet_01v8 L=0.5u W=1u
M17524 o7 ibias vss vss sky130_fd_pr__nfet_01v8 L=0.5u W=1u
M17525 o7 ibias vss vss sky130_fd_pr__nfet_01v8 L=0.5u W=1u
M17526 o7 ibias vss vss sky130_fd_pr__nfet_01v8 L=0.5u W=1u
M17527 o7 ibias vss vss sky130_fd_pr__nfet_01v8 L=0.5u W=1u
M17528 o7 ibias vss vss sky130_fd_pr__nfet_01v8 L=0.5u W=1u
M17529 o7 ibias vss vss sky130_fd_pr__nfet_01v8 L=0.5u W=1u
M17530 o7 ibias vss vss sky130_fd_pr__nfet_01v8 L=0.5u W=1u
M17531 o7 ibias vss vss sky130_fd_pr__nfet_01v8 L=0.5u W=1u
M17532 o7 ibias vss vss sky130_fd_pr__nfet_01v8 L=0.5u W=1u
M17533 o7 ibias vss vss sky130_fd_pr__nfet_01v8 L=0.5u W=1u
M17534 o7 ibias vss vss sky130_fd_pr__nfet_01v8 L=0.5u W=1u
M17535 o7 ibias vss vss sky130_fd_pr__nfet_01v8 L=0.5u W=1u
M17536 o7 ibias vss vss sky130_fd_pr__nfet_01v8 L=0.5u W=1u
M17537 o7 ibias vss vss sky130_fd_pr__nfet_01v8 L=0.5u W=1u
M17538 o7 ibias vss vss sky130_fd_pr__nfet_01v8 L=0.5u W=1u
M17539 o7 ibias vss vss sky130_fd_pr__nfet_01v8 L=0.5u W=1u
M17540 o7 ibias vss vss sky130_fd_pr__nfet_01v8 L=0.5u W=1u
M17541 o7 ibias vss vss sky130_fd_pr__nfet_01v8 L=0.5u W=1u
M17542 o7 ibias vss vss sky130_fd_pr__nfet_01v8 L=0.5u W=1u
M17543 o7 ibias vss vss sky130_fd_pr__nfet_01v8 L=0.5u W=1u
M17544 o7 ibias vss vss sky130_fd_pr__nfet_01v8 L=0.5u W=1u
M17545 o7 ibias vss vss sky130_fd_pr__nfet_01v8 L=0.5u W=1u
M17546 o7 ibias vss vss sky130_fd_pr__nfet_01v8 L=0.5u W=1u
M17547 o7 ibias vss vss sky130_fd_pr__nfet_01v8 L=0.5u W=1u
M17548 o7 ibias vss vss sky130_fd_pr__nfet_01v8 L=0.5u W=1u
M17549 o7 ibias vss vss sky130_fd_pr__nfet_01v8 L=0.5u W=1u
M17550 o7 ibias vss vss sky130_fd_pr__nfet_01v8 L=0.5u W=1u
M17551 o7 ibias vss vss sky130_fd_pr__nfet_01v8 L=0.5u W=1u
M17552 o7 ibias vss vss sky130_fd_pr__nfet_01v8 L=0.5u W=1u
M17553 o7 ibias vss vss sky130_fd_pr__nfet_01v8 L=0.5u W=1u
M17554 o7 ibias vss vss sky130_fd_pr__nfet_01v8 L=0.5u W=1u
M17555 o7 ibias vss vss sky130_fd_pr__nfet_01v8 L=0.5u W=1u
M17556 o7 ibias vss vss sky130_fd_pr__nfet_01v8 L=0.5u W=1u
M17557 o7 ibias vss vss sky130_fd_pr__nfet_01v8 L=0.5u W=1u
M17558 o7 ibias vss vss sky130_fd_pr__nfet_01v8 L=0.5u W=1u
M17559 o7 ibias vss vss sky130_fd_pr__nfet_01v8 L=0.5u W=1u
M17560 o7 ibias vss vss sky130_fd_pr__nfet_01v8 L=0.5u W=1u
M17561 o7 ibias vss vss sky130_fd_pr__nfet_01v8 L=0.5u W=1u
M17562 o7 ibias vss vss sky130_fd_pr__nfet_01v8 L=0.5u W=1u
M17563 o7 ibias vss vss sky130_fd_pr__nfet_01v8 L=0.5u W=1u
M17564 o7 ibias vss vss sky130_fd_pr__nfet_01v8 L=0.5u W=1u
M17565 o7 ibias vss vss sky130_fd_pr__nfet_01v8 L=0.5u W=1u
M17566 o7 ibias vss vss sky130_fd_pr__nfet_01v8 L=0.5u W=1u
M17567 o7 ibias vss vss sky130_fd_pr__nfet_01v8 L=0.5u W=1u
M17568 o7 ibias vss vss sky130_fd_pr__nfet_01v8 L=0.5u W=1u
M17569 o7 ibias vss vss sky130_fd_pr__nfet_01v8 L=0.5u W=1u
M17570 o7 ibias vss vss sky130_fd_pr__nfet_01v8 L=0.5u W=1u
M17571 o7 ibias vss vss sky130_fd_pr__nfet_01v8 L=0.5u W=1u
M17572 o7 ibias vss vss sky130_fd_pr__nfet_01v8 L=0.5u W=1u
M17573 o7 ibias vss vss sky130_fd_pr__nfet_01v8 L=0.5u W=1u
M17574 o7 ibias vss vss sky130_fd_pr__nfet_01v8 L=0.5u W=1u
M17575 o7 ibias vss vss sky130_fd_pr__nfet_01v8 L=0.5u W=1u
M17576 o7 ibias vss vss sky130_fd_pr__nfet_01v8 L=0.5u W=1u
M17577 o7 ibias vss vss sky130_fd_pr__nfet_01v8 L=0.5u W=1u
M17578 o7 ibias vss vss sky130_fd_pr__nfet_01v8 L=0.5u W=1u
M17579 o7 ibias vss vss sky130_fd_pr__nfet_01v8 L=0.5u W=1u
M17580 o7 ibias vss vss sky130_fd_pr__nfet_01v8 L=0.5u W=1u
M17581 o7 ibias vss vss sky130_fd_pr__nfet_01v8 L=0.5u W=1u
M17582 o7 ibias vss vss sky130_fd_pr__nfet_01v8 L=0.5u W=1u
M17583 o7 ibias vss vss sky130_fd_pr__nfet_01v8 L=0.5u W=1u
M17584 o7 ibias vss vss sky130_fd_pr__nfet_01v8 L=0.5u W=1u
M17585 o7 ibias vss vss sky130_fd_pr__nfet_01v8 L=0.5u W=1u
M17586 o7 ibias vss vss sky130_fd_pr__nfet_01v8 L=0.5u W=1u
M17587 o7 ibias vss vss sky130_fd_pr__nfet_01v8 L=0.5u W=1u
M17588 o7 ibias vss vss sky130_fd_pr__nfet_01v8 L=0.5u W=1u
M17589 o7 ibias vss vss sky130_fd_pr__nfet_01v8 L=0.5u W=1u
M17590 o7 ibias vss vss sky130_fd_pr__nfet_01v8 L=0.5u W=1u
M17591 o7 ibias vss vss sky130_fd_pr__nfet_01v8 L=0.5u W=1u
M17592 o7 ibias vss vss sky130_fd_pr__nfet_01v8 L=0.5u W=1u
M17593 o7 ibias vss vss sky130_fd_pr__nfet_01v8 L=0.5u W=1u
M17594 o7 ibias vss vss sky130_fd_pr__nfet_01v8 L=0.5u W=1u
M17595 o7 ibias vss vss sky130_fd_pr__nfet_01v8 L=0.5u W=1u
M17596 o7 ibias vss vss sky130_fd_pr__nfet_01v8 L=0.5u W=1u
M17597 o7 ibias vss vss sky130_fd_pr__nfet_01v8 L=0.5u W=1u
M17598 o7 ibias vss vss sky130_fd_pr__nfet_01v8 L=0.5u W=1u
M17599 o7 ibias vss vss sky130_fd_pr__nfet_01v8 L=0.5u W=1u
M17600 o7 ibias vss vss sky130_fd_pr__nfet_01v8 L=0.5u W=1u
M17601 o7 ibias vss vss sky130_fd_pr__nfet_01v8 L=0.5u W=1u
M17602 o7 ibias vss vss sky130_fd_pr__nfet_01v8 L=0.5u W=1u
M17603 o7 ibias vss vss sky130_fd_pr__nfet_01v8 L=0.5u W=1u
M17604 o7 ibias vss vss sky130_fd_pr__nfet_01v8 L=0.5u W=1u
M17605 o7 ibias vss vss sky130_fd_pr__nfet_01v8 L=0.5u W=1u
M17606 o7 ibias vss vss sky130_fd_pr__nfet_01v8 L=0.5u W=1u
M17607 o7 ibias vss vss sky130_fd_pr__nfet_01v8 L=0.5u W=1u
M17608 o7 ibias vss vss sky130_fd_pr__nfet_01v8 L=0.5u W=1u
M17609 o7 ibias vss vss sky130_fd_pr__nfet_01v8 L=0.5u W=1u
M17610 o7 ibias vss vss sky130_fd_pr__nfet_01v8 L=0.5u W=1u
M17611 o7 ibias vss vss sky130_fd_pr__nfet_01v8 L=0.5u W=1u
M17612 o7 ibias vss vss sky130_fd_pr__nfet_01v8 L=0.5u W=1u
M17613 o7 ibias vss vss sky130_fd_pr__nfet_01v8 L=0.5u W=1u
M17614 o7 ibias vss vss sky130_fd_pr__nfet_01v8 L=0.5u W=1u
M17615 o7 ibias vss vss sky130_fd_pr__nfet_01v8 L=0.5u W=1u
M17616 o7 ibias vss vss sky130_fd_pr__nfet_01v8 L=0.5u W=1u
M17617 o7 ibias vss vss sky130_fd_pr__nfet_01v8 L=0.5u W=1u
M17618 o7 ibias vss vss sky130_fd_pr__nfet_01v8 L=0.5u W=1u
M17619 o7 ibias vss vss sky130_fd_pr__nfet_01v8 L=0.5u W=1u
M17620 o7 ibias vss vss sky130_fd_pr__nfet_01v8 L=0.5u W=1u
M17621 o7 ibias vss vss sky130_fd_pr__nfet_01v8 L=0.5u W=1u
M17622 o7 ibias vss vss sky130_fd_pr__nfet_01v8 L=0.5u W=1u
M17623 o7 ibias vss vss sky130_fd_pr__nfet_01v8 L=0.5u W=1u
M17624 o7 ibias vss vss sky130_fd_pr__nfet_01v8 L=0.5u W=1u
M17625 o7 ibias vss vss sky130_fd_pr__nfet_01v8 L=0.5u W=1u
M17626 o7 ibias vss vss sky130_fd_pr__nfet_01v8 L=0.5u W=1u
M17627 o7 ibias vss vss sky130_fd_pr__nfet_01v8 L=0.5u W=1u
M17628 o7 ibias vss vss sky130_fd_pr__nfet_01v8 L=0.5u W=1u
M17629 o7 ibias vss vss sky130_fd_pr__nfet_01v8 L=0.5u W=1u
M17630 o7 ibias vss vss sky130_fd_pr__nfet_01v8 L=0.5u W=1u
M17631 o7 ibias vss vss sky130_fd_pr__nfet_01v8 L=0.5u W=1u
M17632 o7 ibias vss vss sky130_fd_pr__nfet_01v8 L=0.5u W=1u
M17633 o7 ibias vss vss sky130_fd_pr__nfet_01v8 L=0.5u W=1u
M17634 o7 ibias vss vss sky130_fd_pr__nfet_01v8 L=0.5u W=1u
M17635 o7 ibias vss vss sky130_fd_pr__nfet_01v8 L=0.5u W=1u
M17636 o7 ibias vss vss sky130_fd_pr__nfet_01v8 L=0.5u W=1u
M17637 o7 ibias vss vss sky130_fd_pr__nfet_01v8 L=0.5u W=1u
M17638 o7 ibias vss vss sky130_fd_pr__nfet_01v8 L=0.5u W=1u
M17639 o7 ibias vss vss sky130_fd_pr__nfet_01v8 L=0.5u W=1u
M17640 o7 ibias vss vss sky130_fd_pr__nfet_01v8 L=0.5u W=1u
M17641 o7 ibias vss vss sky130_fd_pr__nfet_01v8 L=0.5u W=1u
M17642 o7 ibias vss vss sky130_fd_pr__nfet_01v8 L=0.5u W=1u
M17643 o7 ibias vss vss sky130_fd_pr__nfet_01v8 L=0.5u W=1u
M17644 o7 ibias vss vss sky130_fd_pr__nfet_01v8 L=0.5u W=1u
M17645 o7 ibias vss vss sky130_fd_pr__nfet_01v8 L=0.5u W=1u
M17646 o7 ibias vss vss sky130_fd_pr__nfet_01v8 L=0.5u W=1u
M17647 o7 ibias vss vss sky130_fd_pr__nfet_01v8 L=0.5u W=1u
M17648 o7 ibias vss vss sky130_fd_pr__nfet_01v8 L=0.5u W=1u
M17649 o7 ibias vss vss sky130_fd_pr__nfet_01v8 L=0.5u W=1u
M17650 o7 ibias vss vss sky130_fd_pr__nfet_01v8 L=0.5u W=1u
M17651 o7 ibias vss vss sky130_fd_pr__nfet_01v8 L=0.5u W=1u
M17652 o7 ibias vss vss sky130_fd_pr__nfet_01v8 L=0.5u W=1u
M17653 o7 ibias vss vss sky130_fd_pr__nfet_01v8 L=0.5u W=1u
M17654 o7 ibias vss vss sky130_fd_pr__nfet_01v8 L=0.5u W=1u
M17655 o7 ibias vss vss sky130_fd_pr__nfet_01v8 L=0.5u W=1u
M17656 o7 ibias vss vss sky130_fd_pr__nfet_01v8 L=0.5u W=1u
M17657 o7 ibias vss vss sky130_fd_pr__nfet_01v8 L=0.5u W=1u
M17658 o7 ibias vss vss sky130_fd_pr__nfet_01v8 L=0.5u W=1u
M17659 o7 ibias vss vss sky130_fd_pr__nfet_01v8 L=0.5u W=1u
M17660 o7 ibias vss vss sky130_fd_pr__nfet_01v8 L=0.5u W=1u
M17661 o7 ibias vss vss sky130_fd_pr__nfet_01v8 L=0.5u W=1u
M17662 o7 ibias vss vss sky130_fd_pr__nfet_01v8 L=0.5u W=1u
M17663 o7 ibias vss vss sky130_fd_pr__nfet_01v8 L=0.5u W=1u
M17664 o7 ibias vss vss sky130_fd_pr__nfet_01v8 L=0.5u W=1u
M17665 o7 ibias vss vss sky130_fd_pr__nfet_01v8 L=0.5u W=1u
M17666 o7 ibias vss vss sky130_fd_pr__nfet_01v8 L=0.5u W=1u
M17667 o7 ibias vss vss sky130_fd_pr__nfet_01v8 L=0.5u W=1u
M17668 o7 ibias vss vss sky130_fd_pr__nfet_01v8 L=0.5u W=1u
M17669 o7 ibias vss vss sky130_fd_pr__nfet_01v8 L=0.5u W=1u
M17670 o7 ibias vss vss sky130_fd_pr__nfet_01v8 L=0.5u W=1u
M17671 o7 ibias vss vss sky130_fd_pr__nfet_01v8 L=0.5u W=1u
M17672 o7 ibias vss vss sky130_fd_pr__nfet_01v8 L=0.5u W=1u
M17673 o7 ibias vss vss sky130_fd_pr__nfet_01v8 L=0.5u W=1u
M17674 o7 ibias vss vss sky130_fd_pr__nfet_01v8 L=0.5u W=1u
M17675 o7 ibias vss vss sky130_fd_pr__nfet_01v8 L=0.5u W=1u
M17676 o7 ibias vss vss sky130_fd_pr__nfet_01v8 L=0.5u W=1u
M17677 o7 ibias vss vss sky130_fd_pr__nfet_01v8 L=0.5u W=1u
M17678 o7 ibias vss vss sky130_fd_pr__nfet_01v8 L=0.5u W=1u
M17679 o7 ibias vss vss sky130_fd_pr__nfet_01v8 L=0.5u W=1u
M17680 o7 ibias vss vss sky130_fd_pr__nfet_01v8 L=0.5u W=1u
M17681 o7 ibias vss vss sky130_fd_pr__nfet_01v8 L=0.5u W=1u
M17682 o7 ibias vss vss sky130_fd_pr__nfet_01v8 L=0.5u W=1u
M17683 o7 ibias vss vss sky130_fd_pr__nfet_01v8 L=0.5u W=1u
M17684 o7 ibias vss vss sky130_fd_pr__nfet_01v8 L=0.5u W=1u
M17685 o7 ibias vss vss sky130_fd_pr__nfet_01v8 L=0.5u W=1u
M17686 o7 ibias vss vss sky130_fd_pr__nfet_01v8 L=0.5u W=1u
M17687 o7 ibias vss vss sky130_fd_pr__nfet_01v8 L=0.5u W=1u
M17688 o7 ibias vss vss sky130_fd_pr__nfet_01v8 L=0.5u W=1u
M17689 o7 ibias vss vss sky130_fd_pr__nfet_01v8 L=0.5u W=1u
M17690 o7 ibias vss vss sky130_fd_pr__nfet_01v8 L=0.5u W=1u
M17691 o7 ibias vss vss sky130_fd_pr__nfet_01v8 L=0.5u W=1u
M17692 o7 ibias vss vss sky130_fd_pr__nfet_01v8 L=0.5u W=1u
M17693 o7 ibias vss vss sky130_fd_pr__nfet_01v8 L=0.5u W=1u
M17694 o7 ibias vss vss sky130_fd_pr__nfet_01v8 L=0.5u W=1u
M17695 o7 ibias vss vss sky130_fd_pr__nfet_01v8 L=0.5u W=1u
M17696 o7 ibias vss vss sky130_fd_pr__nfet_01v8 L=0.5u W=1u
M17697 o7 ibias vss vss sky130_fd_pr__nfet_01v8 L=0.5u W=1u
M17698 o7 ibias vss vss sky130_fd_pr__nfet_01v8 L=0.5u W=1u
M17699 o7 ibias vss vss sky130_fd_pr__nfet_01v8 L=0.5u W=1u
M17700 o7 ibias vss vss sky130_fd_pr__nfet_01v8 L=0.5u W=1u
M17701 o7 ibias vss vss sky130_fd_pr__nfet_01v8 L=0.5u W=1u
M17702 o7 ibias vss vss sky130_fd_pr__nfet_01v8 L=0.5u W=1u
M17703 o7 ibias vss vss sky130_fd_pr__nfet_01v8 L=0.5u W=1u
M17704 o7 ibias vss vss sky130_fd_pr__nfet_01v8 L=0.5u W=1u
M17705 o7 ibias vss vss sky130_fd_pr__nfet_01v8 L=0.5u W=1u
M17706 o7 ibias vss vss sky130_fd_pr__nfet_01v8 L=0.5u W=1u
M17707 o7 ibias vss vss sky130_fd_pr__nfet_01v8 L=0.5u W=1u
M17708 o7 ibias vss vss sky130_fd_pr__nfet_01v8 L=0.5u W=1u
M17709 o7 ibias vss vss sky130_fd_pr__nfet_01v8 L=0.5u W=1u
M17710 o7 ibias vss vss sky130_fd_pr__nfet_01v8 L=0.5u W=1u
M17711 o7 ibias vss vss sky130_fd_pr__nfet_01v8 L=0.5u W=1u
M17712 o7 ibias vss vss sky130_fd_pr__nfet_01v8 L=0.5u W=1u
M17713 o7 ibias vss vss sky130_fd_pr__nfet_01v8 L=0.5u W=1u
M17714 o7 ibias vss vss sky130_fd_pr__nfet_01v8 L=0.5u W=1u
M17715 o7 ibias vss vss sky130_fd_pr__nfet_01v8 L=0.5u W=1u
M17716 o7 ibias vss vss sky130_fd_pr__nfet_01v8 L=0.5u W=1u
M17717 o7 ibias vss vss sky130_fd_pr__nfet_01v8 L=0.5u W=1u
M17718 o7 ibias vss vss sky130_fd_pr__nfet_01v8 L=0.5u W=1u
M17719 o7 ibias vss vss sky130_fd_pr__nfet_01v8 L=0.5u W=1u
M17720 o7 ibias vss vss sky130_fd_pr__nfet_01v8 L=0.5u W=1u
M17721 o7 ibias vss vss sky130_fd_pr__nfet_01v8 L=0.5u W=1u
M17722 o7 ibias vss vss sky130_fd_pr__nfet_01v8 L=0.5u W=1u
M17723 o7 ibias vss vss sky130_fd_pr__nfet_01v8 L=0.5u W=1u
M17724 o7 ibias vss vss sky130_fd_pr__nfet_01v8 L=0.5u W=1u
M17725 o7 ibias vss vss sky130_fd_pr__nfet_01v8 L=0.5u W=1u
M17726 o7 ibias vss vss sky130_fd_pr__nfet_01v8 L=0.5u W=1u
M17727 o7 ibias vss vss sky130_fd_pr__nfet_01v8 L=0.5u W=1u
M17728 o7 ibias vss vss sky130_fd_pr__nfet_01v8 L=0.5u W=1u
M17729 o7 ibias vss vss sky130_fd_pr__nfet_01v8 L=0.5u W=1u
M17730 o7 ibias vss vss sky130_fd_pr__nfet_01v8 L=0.5u W=1u
M17731 o7 ibias vss vss sky130_fd_pr__nfet_01v8 L=0.5u W=1u
M17732 o7 ibias vss vss sky130_fd_pr__nfet_01v8 L=0.5u W=1u
M17733 o7 ibias vss vss sky130_fd_pr__nfet_01v8 L=0.5u W=1u
M17734 o7 ibias vss vss sky130_fd_pr__nfet_01v8 L=0.5u W=1u
M17735 o7 ibias vss vss sky130_fd_pr__nfet_01v8 L=0.5u W=1u
M17736 o7 ibias vss vss sky130_fd_pr__nfet_01v8 L=0.5u W=1u
M17737 o7 ibias vss vss sky130_fd_pr__nfet_01v8 L=0.5u W=1u
M17738 o7 ibias vss vss sky130_fd_pr__nfet_01v8 L=0.5u W=1u
M17739 o7 ibias vss vss sky130_fd_pr__nfet_01v8 L=0.5u W=1u
M17740 o7 ibias vss vss sky130_fd_pr__nfet_01v8 L=0.5u W=1u
M17741 o7 ibias vss vss sky130_fd_pr__nfet_01v8 L=0.5u W=1u
M17742 o7 ibias vss vss sky130_fd_pr__nfet_01v8 L=0.5u W=1u
M17743 o7 ibias vss vss sky130_fd_pr__nfet_01v8 L=0.5u W=1u
M17744 o7 ibias vss vss sky130_fd_pr__nfet_01v8 L=0.5u W=1u
M17745 o7 ibias vss vss sky130_fd_pr__nfet_01v8 L=0.5u W=1u
M17746 o7 ibias vss vss sky130_fd_pr__nfet_01v8 L=0.5u W=1u
M17747 o7 ibias vss vss sky130_fd_pr__nfet_01v8 L=0.5u W=1u
M17748 o7 ibias vss vss sky130_fd_pr__nfet_01v8 L=0.5u W=1u
M17749 o7 ibias vss vss sky130_fd_pr__nfet_01v8 L=0.5u W=1u
M17750 o7 ibias vss vss sky130_fd_pr__nfet_01v8 L=0.5u W=1u
M17751 o7 ibias vss vss sky130_fd_pr__nfet_01v8 L=0.5u W=1u
M17752 o7 ibias vss vss sky130_fd_pr__nfet_01v8 L=0.5u W=1u
M17753 o7 ibias vss vss sky130_fd_pr__nfet_01v8 L=0.5u W=1u
M17754 o7 ibias vss vss sky130_fd_pr__nfet_01v8 L=0.5u W=1u
M17755 o7 ibias vss vss sky130_fd_pr__nfet_01v8 L=0.5u W=1u
M17756 o7 ibias vss vss sky130_fd_pr__nfet_01v8 L=0.5u W=1u
M17757 o7 ibias vss vss sky130_fd_pr__nfet_01v8 L=0.5u W=1u
M17758 o7 ibias vss vss sky130_fd_pr__nfet_01v8 L=0.5u W=1u
M17759 o7 ibias vss vss sky130_fd_pr__nfet_01v8 L=0.5u W=1u
M17760 o7 ibias vss vss sky130_fd_pr__nfet_01v8 L=0.5u W=1u
M17761 o7 ibias vss vss sky130_fd_pr__nfet_01v8 L=0.5u W=1u
M17762 o7 ibias vss vss sky130_fd_pr__nfet_01v8 L=0.5u W=1u
M17763 o7 ibias vss vss sky130_fd_pr__nfet_01v8 L=0.5u W=1u
M17764 o7 ibias vss vss sky130_fd_pr__nfet_01v8 L=0.5u W=1u
M17765 o7 ibias vss vss sky130_fd_pr__nfet_01v8 L=0.5u W=1u
M17766 o7 ibias vss vss sky130_fd_pr__nfet_01v8 L=0.5u W=1u
M17767 o7 ibias vss vss sky130_fd_pr__nfet_01v8 L=0.5u W=1u
M17768 o7 ibias vss vss sky130_fd_pr__nfet_01v8 L=0.5u W=1u
M17769 o7 ibias vss vss sky130_fd_pr__nfet_01v8 L=0.5u W=1u
M17770 o7 ibias vss vss sky130_fd_pr__nfet_01v8 L=0.5u W=1u
M17771 o7 ibias vss vss sky130_fd_pr__nfet_01v8 L=0.5u W=1u
M17772 o7 ibias vss vss sky130_fd_pr__nfet_01v8 L=0.5u W=1u
M17773 o7 ibias vss vss sky130_fd_pr__nfet_01v8 L=0.5u W=1u
M17774 o7 ibias vss vss sky130_fd_pr__nfet_01v8 L=0.5u W=1u
M17775 o7 ibias vss vss sky130_fd_pr__nfet_01v8 L=0.5u W=1u
M17776 o7 ibias vss vss sky130_fd_pr__nfet_01v8 L=0.5u W=1u
M17777 o7 ibias vss vss sky130_fd_pr__nfet_01v8 L=0.5u W=1u
M17778 o7 ibias vss vss sky130_fd_pr__nfet_01v8 L=0.5u W=1u
M17779 o7 ibias vss vss sky130_fd_pr__nfet_01v8 L=0.5u W=1u
M17780 o7 ibias vss vss sky130_fd_pr__nfet_01v8 L=0.5u W=1u
M17781 o7 ibias vss vss sky130_fd_pr__nfet_01v8 L=0.5u W=1u
M17782 o7 ibias vss vss sky130_fd_pr__nfet_01v8 L=0.5u W=1u
M17783 o7 ibias vss vss sky130_fd_pr__nfet_01v8 L=0.5u W=1u
M17784 o7 ibias vss vss sky130_fd_pr__nfet_01v8 L=0.5u W=1u
M17785 o7 ibias vss vss sky130_fd_pr__nfet_01v8 L=0.5u W=1u
M17786 o7 ibias vss vss sky130_fd_pr__nfet_01v8 L=0.5u W=1u
M17787 o7 ibias vss vss sky130_fd_pr__nfet_01v8 L=0.5u W=1u
M17788 o7 ibias vss vss sky130_fd_pr__nfet_01v8 L=0.5u W=1u
M17789 o7 ibias vss vss sky130_fd_pr__nfet_01v8 L=0.5u W=1u
M17790 o7 ibias vss vss sky130_fd_pr__nfet_01v8 L=0.5u W=1u
M17791 o7 ibias vss vss sky130_fd_pr__nfet_01v8 L=0.5u W=1u
M17792 o7 ibias vss vss sky130_fd_pr__nfet_01v8 L=0.5u W=1u
M17793 o7 ibias vss vss sky130_fd_pr__nfet_01v8 L=0.5u W=1u
M17794 o7 ibias vss vss sky130_fd_pr__nfet_01v8 L=0.5u W=1u
M17795 o7 ibias vss vss sky130_fd_pr__nfet_01v8 L=0.5u W=1u
M17796 o7 ibias vss vss sky130_fd_pr__nfet_01v8 L=0.5u W=1u
M17797 o7 ibias vss vss sky130_fd_pr__nfet_01v8 L=0.5u W=1u
M17798 o7 ibias vss vss sky130_fd_pr__nfet_01v8 L=0.5u W=1u
M17799 o7 ibias vss vss sky130_fd_pr__nfet_01v8 L=0.5u W=1u
M17800 o7 ibias vss vss sky130_fd_pr__nfet_01v8 L=0.5u W=1u
M17801 o7 ibias vss vss sky130_fd_pr__nfet_01v8 L=0.5u W=1u
M17802 o7 ibias vss vss sky130_fd_pr__nfet_01v8 L=0.5u W=1u
M17803 o7 ibias vss vss sky130_fd_pr__nfet_01v8 L=0.5u W=1u
M17804 o7 ibias vss vss sky130_fd_pr__nfet_01v8 L=0.5u W=1u
M17805 o7 ibias vss vss sky130_fd_pr__nfet_01v8 L=0.5u W=1u
M17806 o7 ibias vss vss sky130_fd_pr__nfet_01v8 L=0.5u W=1u
M17807 o7 ibias vss vss sky130_fd_pr__nfet_01v8 L=0.5u W=1u
M17808 o7 ibias vss vss sky130_fd_pr__nfet_01v8 L=0.5u W=1u
M17809 o7 ibias vss vss sky130_fd_pr__nfet_01v8 L=0.5u W=1u
M17810 o7 ibias vss vss sky130_fd_pr__nfet_01v8 L=0.5u W=1u
M17811 o7 ibias vss vss sky130_fd_pr__nfet_01v8 L=0.5u W=1u
M17812 o7 ibias vss vss sky130_fd_pr__nfet_01v8 L=0.5u W=1u
M17813 o7 ibias vss vss sky130_fd_pr__nfet_01v8 L=0.5u W=1u
M17814 o7 ibias vss vss sky130_fd_pr__nfet_01v8 L=0.5u W=1u
M17815 o7 ibias vss vss sky130_fd_pr__nfet_01v8 L=0.5u W=1u
M17816 o7 ibias vss vss sky130_fd_pr__nfet_01v8 L=0.5u W=1u
M17817 o7 ibias vss vss sky130_fd_pr__nfet_01v8 L=0.5u W=1u
M17818 o7 ibias vss vss sky130_fd_pr__nfet_01v8 L=0.5u W=1u
M17819 o7 ibias vss vss sky130_fd_pr__nfet_01v8 L=0.5u W=1u
M17820 o7 ibias vss vss sky130_fd_pr__nfet_01v8 L=0.5u W=1u
M17821 o7 ibias vss vss sky130_fd_pr__nfet_01v8 L=0.5u W=1u
M17822 o7 ibias vss vss sky130_fd_pr__nfet_01v8 L=0.5u W=1u
M17823 o7 ibias vss vss sky130_fd_pr__nfet_01v8 L=0.5u W=1u
M17824 o7 ibias vss vss sky130_fd_pr__nfet_01v8 L=0.5u W=1u
M17825 o7 ibias vss vss sky130_fd_pr__nfet_01v8 L=0.5u W=1u
M17826 o7 ibias vss vss sky130_fd_pr__nfet_01v8 L=0.5u W=1u
M17827 o7 ibias vss vss sky130_fd_pr__nfet_01v8 L=0.5u W=1u
M17828 o7 ibias vss vss sky130_fd_pr__nfet_01v8 L=0.5u W=1u
M17829 o7 ibias vss vss sky130_fd_pr__nfet_01v8 L=0.5u W=1u
M17830 o7 ibias vss vss sky130_fd_pr__nfet_01v8 L=0.5u W=1u
M17831 o7 ibias vss vss sky130_fd_pr__nfet_01v8 L=0.5u W=1u
M17832 o7 ibias vss vss sky130_fd_pr__nfet_01v8 L=0.5u W=1u
M17833 o7 ibias vss vss sky130_fd_pr__nfet_01v8 L=0.5u W=1u
M17834 o7 ibias vss vss sky130_fd_pr__nfet_01v8 L=0.5u W=1u
M17835 o7 ibias vss vss sky130_fd_pr__nfet_01v8 L=0.5u W=1u
M17836 o7 ibias vss vss sky130_fd_pr__nfet_01v8 L=0.5u W=1u
M17837 o7 ibias vss vss sky130_fd_pr__nfet_01v8 L=0.5u W=1u
M17838 o7 ibias vss vss sky130_fd_pr__nfet_01v8 L=0.5u W=1u
M17839 o7 ibias vss vss sky130_fd_pr__nfet_01v8 L=0.5u W=1u
M17840 o7 ibias vss vss sky130_fd_pr__nfet_01v8 L=0.5u W=1u
M17841 o7 ibias vss vss sky130_fd_pr__nfet_01v8 L=0.5u W=1u
M17842 o7 ibias vss vss sky130_fd_pr__nfet_01v8 L=0.5u W=1u
M17843 o7 ibias vss vss sky130_fd_pr__nfet_01v8 L=0.5u W=1u
M17844 o7 ibias vss vss sky130_fd_pr__nfet_01v8 L=0.5u W=1u
M17845 o7 ibias vss vss sky130_fd_pr__nfet_01v8 L=0.5u W=1u
M17846 o7 ibias vss vss sky130_fd_pr__nfet_01v8 L=0.5u W=1u
M17847 o7 ibias vss vss sky130_fd_pr__nfet_01v8 L=0.5u W=1u
M17848 o7 ibias vss vss sky130_fd_pr__nfet_01v8 L=0.5u W=1u
M17849 o7 ibias vss vss sky130_fd_pr__nfet_01v8 L=0.5u W=1u
M17850 o7 ibias vss vss sky130_fd_pr__nfet_01v8 L=0.5u W=1u
M17851 o7 ibias vss vss sky130_fd_pr__nfet_01v8 L=0.5u W=1u
M17852 o7 ibias vss vss sky130_fd_pr__nfet_01v8 L=0.5u W=1u
M17853 o7 ibias vss vss sky130_fd_pr__nfet_01v8 L=0.5u W=1u
M17854 o7 ibias vss vss sky130_fd_pr__nfet_01v8 L=0.5u W=1u
M17855 o7 ibias vss vss sky130_fd_pr__nfet_01v8 L=0.5u W=1u
M17856 o7 ibias vss vss sky130_fd_pr__nfet_01v8 L=0.5u W=1u
M17857 o7 ibias vss vss sky130_fd_pr__nfet_01v8 L=0.5u W=1u
M17858 o7 ibias vss vss sky130_fd_pr__nfet_01v8 L=0.5u W=1u
M17859 o7 ibias vss vss sky130_fd_pr__nfet_01v8 L=0.5u W=1u
M17860 o7 ibias vss vss sky130_fd_pr__nfet_01v8 L=0.5u W=1u
M17861 o7 ibias vss vss sky130_fd_pr__nfet_01v8 L=0.5u W=1u
M17862 o7 ibias vss vss sky130_fd_pr__nfet_01v8 L=0.5u W=1u
M17863 o7 ibias vss vss sky130_fd_pr__nfet_01v8 L=0.5u W=1u
M17864 o7 ibias vss vss sky130_fd_pr__nfet_01v8 L=0.5u W=1u
M17865 o7 ibias vss vss sky130_fd_pr__nfet_01v8 L=0.5u W=1u
M17866 o7 ibias vss vss sky130_fd_pr__nfet_01v8 L=0.5u W=1u
M17867 o7 ibias vss vss sky130_fd_pr__nfet_01v8 L=0.5u W=1u
M17868 o7 ibias vss vss sky130_fd_pr__nfet_01v8 L=0.5u W=1u
M17869 o7 ibias vss vss sky130_fd_pr__nfet_01v8 L=0.5u W=1u
M17870 o7 ibias vss vss sky130_fd_pr__nfet_01v8 L=0.5u W=1u
M17871 o7 ibias vss vss sky130_fd_pr__nfet_01v8 L=0.5u W=1u
M17872 o7 ibias vss vss sky130_fd_pr__nfet_01v8 L=0.5u W=1u
M17873 o7 ibias vss vss sky130_fd_pr__nfet_01v8 L=0.5u W=1u
M17874 o7 ibias vss vss sky130_fd_pr__nfet_01v8 L=0.5u W=1u
M17875 o7 ibias vss vss sky130_fd_pr__nfet_01v8 L=0.5u W=1u
M17876 o7 ibias vss vss sky130_fd_pr__nfet_01v8 L=0.5u W=1u
M17877 o7 ibias vss vss sky130_fd_pr__nfet_01v8 L=0.5u W=1u
M17878 o7 ibias vss vss sky130_fd_pr__nfet_01v8 L=0.5u W=1u
M17879 o7 ibias vss vss sky130_fd_pr__nfet_01v8 L=0.5u W=1u
M17880 o7 ibias vss vss sky130_fd_pr__nfet_01v8 L=0.5u W=1u
M17881 o7 ibias vss vss sky130_fd_pr__nfet_01v8 L=0.5u W=1u
M17882 o7 ibias vss vss sky130_fd_pr__nfet_01v8 L=0.5u W=1u
M17883 o7 ibias vss vss sky130_fd_pr__nfet_01v8 L=0.5u W=1u
M17884 o7 ibias vss vss sky130_fd_pr__nfet_01v8 L=0.5u W=1u
M17885 o7 ibias vss vss sky130_fd_pr__nfet_01v8 L=0.5u W=1u
M17886 o7 ibias vss vss sky130_fd_pr__nfet_01v8 L=0.5u W=1u
M17887 o7 ibias vss vss sky130_fd_pr__nfet_01v8 L=0.5u W=1u
M17888 o7 ibias vss vss sky130_fd_pr__nfet_01v8 L=0.5u W=1u
M17889 o7 ibias vss vss sky130_fd_pr__nfet_01v8 L=0.5u W=1u
M17890 o7 ibias vss vss sky130_fd_pr__nfet_01v8 L=0.5u W=1u
M17891 o7 ibias vss vss sky130_fd_pr__nfet_01v8 L=0.5u W=1u
M17892 o7 ibias vss vss sky130_fd_pr__nfet_01v8 L=0.5u W=1u
M17893 o7 ibias vss vss sky130_fd_pr__nfet_01v8 L=0.5u W=1u
M17894 o7 ibias vss vss sky130_fd_pr__nfet_01v8 L=0.5u W=1u
M17895 o7 ibias vss vss sky130_fd_pr__nfet_01v8 L=0.5u W=1u
M17896 o7 ibias vss vss sky130_fd_pr__nfet_01v8 L=0.5u W=1u
M17897 o7 ibias vss vss sky130_fd_pr__nfet_01v8 L=0.5u W=1u
M17898 o7 ibias vss vss sky130_fd_pr__nfet_01v8 L=0.5u W=1u
M17899 o7 ibias vss vss sky130_fd_pr__nfet_01v8 L=0.5u W=1u
M17900 o7 ibias vss vss sky130_fd_pr__nfet_01v8 L=0.5u W=1u
M17901 o7 ibias vss vss sky130_fd_pr__nfet_01v8 L=0.5u W=1u
M17902 o7 ibias vss vss sky130_fd_pr__nfet_01v8 L=0.5u W=1u
M17903 o7 ibias vss vss sky130_fd_pr__nfet_01v8 L=0.5u W=1u
M17904 o7 ibias vss vss sky130_fd_pr__nfet_01v8 L=0.5u W=1u
M17905 o7 ibias vss vss sky130_fd_pr__nfet_01v8 L=0.5u W=1u
M17906 o7 ibias vss vss sky130_fd_pr__nfet_01v8 L=0.5u W=1u
M17907 o7 ibias vss vss sky130_fd_pr__nfet_01v8 L=0.5u W=1u
M17908 o7 ibias vss vss sky130_fd_pr__nfet_01v8 L=0.5u W=1u
M17909 o7 ibias vss vss sky130_fd_pr__nfet_01v8 L=0.5u W=1u
M17910 o7 ibias vss vss sky130_fd_pr__nfet_01v8 L=0.5u W=1u
M17911 o7 ibias vss vss sky130_fd_pr__nfet_01v8 L=0.5u W=1u
M17912 o7 ibias vss vss sky130_fd_pr__nfet_01v8 L=0.5u W=1u
M17913 o7 ibias vss vss sky130_fd_pr__nfet_01v8 L=0.5u W=1u
M17914 o7 ibias vss vss sky130_fd_pr__nfet_01v8 L=0.5u W=1u
M17915 o7 ibias vss vss sky130_fd_pr__nfet_01v8 L=0.5u W=1u
M17916 o7 ibias vss vss sky130_fd_pr__nfet_01v8 L=0.5u W=1u
M17917 o7 ibias vss vss sky130_fd_pr__nfet_01v8 L=0.5u W=1u
M17918 o7 ibias vss vss sky130_fd_pr__nfet_01v8 L=0.5u W=1u
M17919 o7 ibias vss vss sky130_fd_pr__nfet_01v8 L=0.5u W=1u
M17920 o7 ibias vss vss sky130_fd_pr__nfet_01v8 L=0.5u W=1u
M17921 o7 ibias vss vss sky130_fd_pr__nfet_01v8 L=0.5u W=1u
M17922 o7 ibias vss vss sky130_fd_pr__nfet_01v8 L=0.5u W=1u
M17923 o7 ibias vss vss sky130_fd_pr__nfet_01v8 L=0.5u W=1u
M17924 o7 ibias vss vss sky130_fd_pr__nfet_01v8 L=0.5u W=1u
M17925 o7 ibias vss vss sky130_fd_pr__nfet_01v8 L=0.5u W=1u
M17926 o7 ibias vss vss sky130_fd_pr__nfet_01v8 L=0.5u W=1u
M17927 o7 ibias vss vss sky130_fd_pr__nfet_01v8 L=0.5u W=1u
M17928 o7 ibias vss vss sky130_fd_pr__nfet_01v8 L=0.5u W=1u
M17929 o7 ibias vss vss sky130_fd_pr__nfet_01v8 L=0.5u W=1u
M17930 o7 ibias vss vss sky130_fd_pr__nfet_01v8 L=0.5u W=1u
M17931 o7 ibias vss vss sky130_fd_pr__nfet_01v8 L=0.5u W=1u
M17932 o7 ibias vss vss sky130_fd_pr__nfet_01v8 L=0.5u W=1u
M17933 o7 ibias vss vss sky130_fd_pr__nfet_01v8 L=0.5u W=1u
M17934 o7 ibias vss vss sky130_fd_pr__nfet_01v8 L=0.5u W=1u
M17935 o7 ibias vss vss sky130_fd_pr__nfet_01v8 L=0.5u W=1u
M17936 o7 ibias vss vss sky130_fd_pr__nfet_01v8 L=0.5u W=1u
M17937 o7 ibias vss vss sky130_fd_pr__nfet_01v8 L=0.5u W=1u
M17938 o7 ibias vss vss sky130_fd_pr__nfet_01v8 L=0.5u W=1u
M17939 o7 ibias vss vss sky130_fd_pr__nfet_01v8 L=0.5u W=1u
M17940 o7 ibias vss vss sky130_fd_pr__nfet_01v8 L=0.5u W=1u
M17941 o7 ibias vss vss sky130_fd_pr__nfet_01v8 L=0.5u W=1u
M17942 o7 ibias vss vss sky130_fd_pr__nfet_01v8 L=0.5u W=1u
M17943 o7 ibias vss vss sky130_fd_pr__nfet_01v8 L=0.5u W=1u
M17944 o7 ibias vss vss sky130_fd_pr__nfet_01v8 L=0.5u W=1u
M17945 o7 ibias vss vss sky130_fd_pr__nfet_01v8 L=0.5u W=1u
M17946 o7 ibias vss vss sky130_fd_pr__nfet_01v8 L=0.5u W=1u
M17947 o7 ibias vss vss sky130_fd_pr__nfet_01v8 L=0.5u W=1u
M17948 o7 ibias vss vss sky130_fd_pr__nfet_01v8 L=0.5u W=1u
M17949 o7 ibias vss vss sky130_fd_pr__nfet_01v8 L=0.5u W=1u
M17950 o7 ibias vss vss sky130_fd_pr__nfet_01v8 L=0.5u W=1u
M17951 o7 ibias vss vss sky130_fd_pr__nfet_01v8 L=0.5u W=1u
M17952 o7 ibias vss vss sky130_fd_pr__nfet_01v8 L=0.5u W=1u
M17953 o7 ibias vss vss sky130_fd_pr__nfet_01v8 L=0.5u W=1u
M17954 o7 ibias vss vss sky130_fd_pr__nfet_01v8 L=0.5u W=1u
M17955 o7 ibias vss vss sky130_fd_pr__nfet_01v8 L=0.5u W=1u
M17956 o7 ibias vss vss sky130_fd_pr__nfet_01v8 L=0.5u W=1u
M17957 o7 ibias vss vss sky130_fd_pr__nfet_01v8 L=0.5u W=1u
M17958 o7 ibias vss vss sky130_fd_pr__nfet_01v8 L=0.5u W=1u
M17959 o7 ibias vss vss sky130_fd_pr__nfet_01v8 L=0.5u W=1u
M17960 o7 ibias vss vss sky130_fd_pr__nfet_01v8 L=0.5u W=1u
M17961 o7 ibias vss vss sky130_fd_pr__nfet_01v8 L=0.5u W=1u
M17962 o7 ibias vss vss sky130_fd_pr__nfet_01v8 L=0.5u W=1u
M17963 o7 ibias vss vss sky130_fd_pr__nfet_01v8 L=0.5u W=1u
M17964 o7 ibias vss vss sky130_fd_pr__nfet_01v8 L=0.5u W=1u
M17965 o7 ibias vss vss sky130_fd_pr__nfet_01v8 L=0.5u W=1u
M17966 o7 ibias vss vss sky130_fd_pr__nfet_01v8 L=0.5u W=1u
M17967 o7 ibias vss vss sky130_fd_pr__nfet_01v8 L=0.5u W=1u
M17968 o7 ibias vss vss sky130_fd_pr__nfet_01v8 L=0.5u W=1u
M17969 o7 ibias vss vss sky130_fd_pr__nfet_01v8 L=0.5u W=1u
M17970 o7 ibias vss vss sky130_fd_pr__nfet_01v8 L=0.5u W=1u
M17971 o7 ibias vss vss sky130_fd_pr__nfet_01v8 L=0.5u W=1u
M17972 o7 ibias vss vss sky130_fd_pr__nfet_01v8 L=0.5u W=1u
M17973 o7 ibias vss vss sky130_fd_pr__nfet_01v8 L=0.5u W=1u
M17974 o7 ibias vss vss sky130_fd_pr__nfet_01v8 L=0.5u W=1u
M17975 o7 ibias vss vss sky130_fd_pr__nfet_01v8 L=0.5u W=1u
M17976 o7 ibias vss vss sky130_fd_pr__nfet_01v8 L=0.5u W=1u
M17977 o7 ibias vss vss sky130_fd_pr__nfet_01v8 L=0.5u W=1u
M17978 o7 ibias vss vss sky130_fd_pr__nfet_01v8 L=0.5u W=1u
M17979 o7 ibias vss vss sky130_fd_pr__nfet_01v8 L=0.5u W=1u
M17980 o7 ibias vss vss sky130_fd_pr__nfet_01v8 L=0.5u W=1u
M17981 o7 ibias vss vss sky130_fd_pr__nfet_01v8 L=0.5u W=1u
M17982 o7 ibias vss vss sky130_fd_pr__nfet_01v8 L=0.5u W=1u
M17983 o7 ibias vss vss sky130_fd_pr__nfet_01v8 L=0.5u W=1u
M17984 o7 ibias vss vss sky130_fd_pr__nfet_01v8 L=0.5u W=1u
M17985 o7 ibias vss vss sky130_fd_pr__nfet_01v8 L=0.5u W=1u
M17986 o7 ibias vss vss sky130_fd_pr__nfet_01v8 L=0.5u W=1u
M17987 o7 ibias vss vss sky130_fd_pr__nfet_01v8 L=0.5u W=1u
M17988 o7 ibias vss vss sky130_fd_pr__nfet_01v8 L=0.5u W=1u
M17989 o7 ibias vss vss sky130_fd_pr__nfet_01v8 L=0.5u W=1u
M17990 o7 ibias vss vss sky130_fd_pr__nfet_01v8 L=0.5u W=1u
M17991 o7 ibias vss vss sky130_fd_pr__nfet_01v8 L=0.5u W=1u
M17992 o7 ibias vss vss sky130_fd_pr__nfet_01v8 L=0.5u W=1u
M17993 o7 ibias vss vss sky130_fd_pr__nfet_01v8 L=0.5u W=1u
M17994 o7 ibias vss vss sky130_fd_pr__nfet_01v8 L=0.5u W=1u
M17995 o7 ibias vss vss sky130_fd_pr__nfet_01v8 L=0.5u W=1u
M17996 o7 ibias vss vss sky130_fd_pr__nfet_01v8 L=0.5u W=1u
M17997 o7 ibias vss vss sky130_fd_pr__nfet_01v8 L=0.5u W=1u
M17998 o7 ibias vss vss sky130_fd_pr__nfet_01v8 L=0.5u W=1u
M17999 o7 ibias vss vss sky130_fd_pr__nfet_01v8 L=0.5u W=1u
M18000 o7 ibias vss vss sky130_fd_pr__nfet_01v8 L=0.5u W=1u
M18001 o7 ibias vss vss sky130_fd_pr__nfet_01v8 L=0.5u W=1u
M18002 o7 ibias vss vss sky130_fd_pr__nfet_01v8 L=0.5u W=1u
M18003 o7 ibias vss vss sky130_fd_pr__nfet_01v8 L=0.5u W=1u
M18004 o7 ibias vss vss sky130_fd_pr__nfet_01v8 L=0.5u W=1u
M18005 o7 ibias vss vss sky130_fd_pr__nfet_01v8 L=0.5u W=1u
M18006 o7 ibias vss vss sky130_fd_pr__nfet_01v8 L=0.5u W=1u
M18007 o7 ibias vss vss sky130_fd_pr__nfet_01v8 L=0.5u W=1u
M18008 o7 ibias vss vss sky130_fd_pr__nfet_01v8 L=0.5u W=1u
M18009 o7 ibias vss vss sky130_fd_pr__nfet_01v8 L=0.5u W=1u
M18010 o7 ibias vss vss sky130_fd_pr__nfet_01v8 L=0.5u W=1u
M18011 o7 ibias vss vss sky130_fd_pr__nfet_01v8 L=0.5u W=1u
M18012 o7 ibias vss vss sky130_fd_pr__nfet_01v8 L=0.5u W=1u
M18013 o7 ibias vss vss sky130_fd_pr__nfet_01v8 L=0.5u W=1u
M18014 o7 ibias vss vss sky130_fd_pr__nfet_01v8 L=0.5u W=1u
M18015 o7 ibias vss vss sky130_fd_pr__nfet_01v8 L=0.5u W=1u
M18016 o7 ibias vss vss sky130_fd_pr__nfet_01v8 L=0.5u W=1u
M18017 o7 ibias vss vss sky130_fd_pr__nfet_01v8 L=0.5u W=1u
M18018 o7 ibias vss vss sky130_fd_pr__nfet_01v8 L=0.5u W=1u
M18019 o7 ibias vss vss sky130_fd_pr__nfet_01v8 L=0.5u W=1u
M18020 o7 ibias vss vss sky130_fd_pr__nfet_01v8 L=0.5u W=1u
M18021 o7 ibias vss vss sky130_fd_pr__nfet_01v8 L=0.5u W=1u
M18022 o7 ibias vss vss sky130_fd_pr__nfet_01v8 L=0.5u W=1u
M18023 o7 ibias vss vss sky130_fd_pr__nfet_01v8 L=0.5u W=1u
M18024 o7 ibias vss vss sky130_fd_pr__nfet_01v8 L=0.5u W=1u
M18025 o7 ibias vss vss sky130_fd_pr__nfet_01v8 L=0.5u W=1u
M18026 o7 ibias vss vss sky130_fd_pr__nfet_01v8 L=0.5u W=1u
M18027 o7 ibias vss vss sky130_fd_pr__nfet_01v8 L=0.5u W=1u
M18028 o7 ibias vss vss sky130_fd_pr__nfet_01v8 L=0.5u W=1u
M18029 o7 ibias vss vss sky130_fd_pr__nfet_01v8 L=0.5u W=1u
M18030 o7 ibias vss vss sky130_fd_pr__nfet_01v8 L=0.5u W=1u
M18031 o7 ibias vss vss sky130_fd_pr__nfet_01v8 L=0.5u W=1u
M18032 o7 ibias vss vss sky130_fd_pr__nfet_01v8 L=0.5u W=1u
M18033 o7 ibias vss vss sky130_fd_pr__nfet_01v8 L=0.5u W=1u
M18034 o7 ibias vss vss sky130_fd_pr__nfet_01v8 L=0.5u W=1u
M18035 o7 ibias vss vss sky130_fd_pr__nfet_01v8 L=0.5u W=1u
M18036 o7 ibias vss vss sky130_fd_pr__nfet_01v8 L=0.5u W=1u
M18037 o7 ibias vss vss sky130_fd_pr__nfet_01v8 L=0.5u W=1u
M18038 o7 ibias vss vss sky130_fd_pr__nfet_01v8 L=0.5u W=1u
M18039 o7 ibias vss vss sky130_fd_pr__nfet_01v8 L=0.5u W=1u
M18040 o7 ibias vss vss sky130_fd_pr__nfet_01v8 L=0.5u W=1u
M18041 o7 ibias vss vss sky130_fd_pr__nfet_01v8 L=0.5u W=1u
M18042 o7 ibias vss vss sky130_fd_pr__nfet_01v8 L=0.5u W=1u
M18043 o7 ibias vss vss sky130_fd_pr__nfet_01v8 L=0.5u W=1u
M18044 o7 ibias vss vss sky130_fd_pr__nfet_01v8 L=0.5u W=1u
M18045 o7 ibias vss vss sky130_fd_pr__nfet_01v8 L=0.5u W=1u
M18046 o7 ibias vss vss sky130_fd_pr__nfet_01v8 L=0.5u W=1u
M18047 o7 ibias vss vss sky130_fd_pr__nfet_01v8 L=0.5u W=1u
M18048 o7 ibias vss vss sky130_fd_pr__nfet_01v8 L=0.5u W=1u
M18049 o7 ibias vss vss sky130_fd_pr__nfet_01v8 L=0.5u W=1u
M18050 o7 ibias vss vss sky130_fd_pr__nfet_01v8 L=0.5u W=1u
M18051 o7 ibias vss vss sky130_fd_pr__nfet_01v8 L=0.5u W=1u
M18052 o7 ibias vss vss sky130_fd_pr__nfet_01v8 L=0.5u W=1u
M18053 o7 ibias vss vss sky130_fd_pr__nfet_01v8 L=0.5u W=1u
M18054 o7 ibias vss vss sky130_fd_pr__nfet_01v8 L=0.5u W=1u
M18055 o7 ibias vss vss sky130_fd_pr__nfet_01v8 L=0.5u W=1u
M18056 o7 ibias vss vss sky130_fd_pr__nfet_01v8 L=0.5u W=1u
M18057 o7 ibias vss vss sky130_fd_pr__nfet_01v8 L=0.5u W=1u
M18058 o7 ibias vss vss sky130_fd_pr__nfet_01v8 L=0.5u W=1u
M18059 o7 ibias vss vss sky130_fd_pr__nfet_01v8 L=0.5u W=1u
M18060 o7 ibias vss vss sky130_fd_pr__nfet_01v8 L=0.5u W=1u
M18061 o7 ibias vss vss sky130_fd_pr__nfet_01v8 L=0.5u W=1u
M18062 o7 ibias vss vss sky130_fd_pr__nfet_01v8 L=0.5u W=1u
M18063 o7 ibias vss vss sky130_fd_pr__nfet_01v8 L=0.5u W=1u
M18064 o7 ibias vss vss sky130_fd_pr__nfet_01v8 L=0.5u W=1u
M18065 o7 ibias vss vss sky130_fd_pr__nfet_01v8 L=0.5u W=1u
M18066 o7 ibias vss vss sky130_fd_pr__nfet_01v8 L=0.5u W=1u
M18067 o7 ibias vss vss sky130_fd_pr__nfet_01v8 L=0.5u W=1u
M18068 o7 ibias vss vss sky130_fd_pr__nfet_01v8 L=0.5u W=1u
M18069 o7 ibias vss vss sky130_fd_pr__nfet_01v8 L=0.5u W=1u
M18070 o7 ibias vss vss sky130_fd_pr__nfet_01v8 L=0.5u W=1u
M18071 o7 ibias vss vss sky130_fd_pr__nfet_01v8 L=0.5u W=1u
M18072 o7 ibias vss vss sky130_fd_pr__nfet_01v8 L=0.5u W=1u
M18073 o7 ibias vss vss sky130_fd_pr__nfet_01v8 L=0.5u W=1u
M18074 o7 ibias vss vss sky130_fd_pr__nfet_01v8 L=0.5u W=1u
M18075 o7 ibias vss vss sky130_fd_pr__nfet_01v8 L=0.5u W=1u
M18076 o7 ibias vss vss sky130_fd_pr__nfet_01v8 L=0.5u W=1u
M18077 o7 ibias vss vss sky130_fd_pr__nfet_01v8 L=0.5u W=1u
M18078 o7 ibias vss vss sky130_fd_pr__nfet_01v8 L=0.5u W=1u
M18079 o7 ibias vss vss sky130_fd_pr__nfet_01v8 L=0.5u W=1u
M18080 o7 ibias vss vss sky130_fd_pr__nfet_01v8 L=0.5u W=1u
M18081 o7 ibias vss vss sky130_fd_pr__nfet_01v8 L=0.5u W=1u
M18082 o7 ibias vss vss sky130_fd_pr__nfet_01v8 L=0.5u W=1u
M18083 o7 ibias vss vss sky130_fd_pr__nfet_01v8 L=0.5u W=1u
M18084 o7 ibias vss vss sky130_fd_pr__nfet_01v8 L=0.5u W=1u
M18085 o7 ibias vss vss sky130_fd_pr__nfet_01v8 L=0.5u W=1u
M18086 o7 ibias vss vss sky130_fd_pr__nfet_01v8 L=0.5u W=1u
M18087 o7 ibias vss vss sky130_fd_pr__nfet_01v8 L=0.5u W=1u
M18088 o7 ibias vss vss sky130_fd_pr__nfet_01v8 L=0.5u W=1u
M18089 o7 ibias vss vss sky130_fd_pr__nfet_01v8 L=0.5u W=1u
M18090 o7 ibias vss vss sky130_fd_pr__nfet_01v8 L=0.5u W=1u
M18091 o7 ibias vss vss sky130_fd_pr__nfet_01v8 L=0.5u W=1u
M18092 o7 ibias vss vss sky130_fd_pr__nfet_01v8 L=0.5u W=1u
M18093 o7 ibias vss vss sky130_fd_pr__nfet_01v8 L=0.5u W=1u
M18094 o7 ibias vss vss sky130_fd_pr__nfet_01v8 L=0.5u W=1u
M18095 o7 ibias vss vss sky130_fd_pr__nfet_01v8 L=0.5u W=1u
M18096 o7 ibias vss vss sky130_fd_pr__nfet_01v8 L=0.5u W=1u
M18097 o7 ibias vss vss sky130_fd_pr__nfet_01v8 L=0.5u W=1u
M18098 o7 ibias vss vss sky130_fd_pr__nfet_01v8 L=0.5u W=1u
M18099 o7 ibias vss vss sky130_fd_pr__nfet_01v8 L=0.5u W=1u
M18100 o7 ibias vss vss sky130_fd_pr__nfet_01v8 L=0.5u W=1u
M18101 o7 ibias vss vss sky130_fd_pr__nfet_01v8 L=0.5u W=1u
M18102 o7 ibias vss vss sky130_fd_pr__nfet_01v8 L=0.5u W=1u
M18103 o7 ibias vss vss sky130_fd_pr__nfet_01v8 L=0.5u W=1u
M18104 o7 ibias vss vss sky130_fd_pr__nfet_01v8 L=0.5u W=1u
M18105 o7 ibias vss vss sky130_fd_pr__nfet_01v8 L=0.5u W=1u
M18106 o7 ibias vss vss sky130_fd_pr__nfet_01v8 L=0.5u W=1u
M18107 o7 ibias vss vss sky130_fd_pr__nfet_01v8 L=0.5u W=1u
M18108 o7 ibias vss vss sky130_fd_pr__nfet_01v8 L=0.5u W=1u
M18109 o7 ibias vss vss sky130_fd_pr__nfet_01v8 L=0.5u W=1u
M18110 o7 ibias vss vss sky130_fd_pr__nfet_01v8 L=0.5u W=1u
M18111 o7 ibias vss vss sky130_fd_pr__nfet_01v8 L=0.5u W=1u
M18112 o7 ibias vss vss sky130_fd_pr__nfet_01v8 L=0.5u W=1u
M18113 o7 ibias vss vss sky130_fd_pr__nfet_01v8 L=0.5u W=1u
M18114 o7 ibias vss vss sky130_fd_pr__nfet_01v8 L=0.5u W=1u
M18115 o7 ibias vss vss sky130_fd_pr__nfet_01v8 L=0.5u W=1u
M18116 o7 ibias vss vss sky130_fd_pr__nfet_01v8 L=0.5u W=1u
M18117 o7 ibias vss vss sky130_fd_pr__nfet_01v8 L=0.5u W=1u
M18118 o7 ibias vss vss sky130_fd_pr__nfet_01v8 L=0.5u W=1u
M18119 o7 ibias vss vss sky130_fd_pr__nfet_01v8 L=0.5u W=1u
M18120 o7 ibias vss vss sky130_fd_pr__nfet_01v8 L=0.5u W=1u
M18121 o7 ibias vss vss sky130_fd_pr__nfet_01v8 L=0.5u W=1u
M18122 o7 ibias vss vss sky130_fd_pr__nfet_01v8 L=0.5u W=1u
M18123 o7 ibias vss vss sky130_fd_pr__nfet_01v8 L=0.5u W=1u
M18124 o7 ibias vss vss sky130_fd_pr__nfet_01v8 L=0.5u W=1u
M18125 o7 ibias vss vss sky130_fd_pr__nfet_01v8 L=0.5u W=1u
M18126 o7 ibias vss vss sky130_fd_pr__nfet_01v8 L=0.5u W=1u
M18127 o7 ibias vss vss sky130_fd_pr__nfet_01v8 L=0.5u W=1u
M18128 o7 ibias vss vss sky130_fd_pr__nfet_01v8 L=0.5u W=1u
M18129 o7 ibias vss vss sky130_fd_pr__nfet_01v8 L=0.5u W=1u
M18130 o7 ibias vss vss sky130_fd_pr__nfet_01v8 L=0.5u W=1u
M18131 o7 ibias vss vss sky130_fd_pr__nfet_01v8 L=0.5u W=1u
M18132 o7 ibias vss vss sky130_fd_pr__nfet_01v8 L=0.5u W=1u
M18133 o7 ibias vss vss sky130_fd_pr__nfet_01v8 L=0.5u W=1u
M18134 o7 ibias vss vss sky130_fd_pr__nfet_01v8 L=0.5u W=1u
M18135 o7 ibias vss vss sky130_fd_pr__nfet_01v8 L=0.5u W=1u
M18136 o7 ibias vss vss sky130_fd_pr__nfet_01v8 L=0.5u W=1u
M18137 o7 ibias vss vss sky130_fd_pr__nfet_01v8 L=0.5u W=1u
M18138 o7 ibias vss vss sky130_fd_pr__nfet_01v8 L=0.5u W=1u
M18139 o7 ibias vss vss sky130_fd_pr__nfet_01v8 L=0.5u W=1u
M18140 o7 ibias vss vss sky130_fd_pr__nfet_01v8 L=0.5u W=1u
M18141 o7 ibias vss vss sky130_fd_pr__nfet_01v8 L=0.5u W=1u
M18142 o7 ibias vss vss sky130_fd_pr__nfet_01v8 L=0.5u W=1u
M18143 o7 ibias vss vss sky130_fd_pr__nfet_01v8 L=0.5u W=1u
M18144 o7 ibias vss vss sky130_fd_pr__nfet_01v8 L=0.5u W=1u
M18145 o7 ibias vss vss sky130_fd_pr__nfet_01v8 L=0.5u W=1u
M18146 o7 ibias vss vss sky130_fd_pr__nfet_01v8 L=0.5u W=1u
M18147 o7 ibias vss vss sky130_fd_pr__nfet_01v8 L=0.5u W=1u
M18148 o7 ibias vss vss sky130_fd_pr__nfet_01v8 L=0.5u W=1u
M18149 o7 ibias vss vss sky130_fd_pr__nfet_01v8 L=0.5u W=1u
M18150 o7 ibias vss vss sky130_fd_pr__nfet_01v8 L=0.5u W=1u
M18151 o7 ibias vss vss sky130_fd_pr__nfet_01v8 L=0.5u W=1u
M18152 o7 ibias vss vss sky130_fd_pr__nfet_01v8 L=0.5u W=1u
M18153 o7 ibias vss vss sky130_fd_pr__nfet_01v8 L=0.5u W=1u
M18154 o7 ibias vss vss sky130_fd_pr__nfet_01v8 L=0.5u W=1u
M18155 o7 ibias vss vss sky130_fd_pr__nfet_01v8 L=0.5u W=1u
M18156 o7 ibias vss vss sky130_fd_pr__nfet_01v8 L=0.5u W=1u
M18157 o7 ibias vss vss sky130_fd_pr__nfet_01v8 L=0.5u W=1u
M18158 o7 ibias vss vss sky130_fd_pr__nfet_01v8 L=0.5u W=1u
M18159 o7 ibias vss vss sky130_fd_pr__nfet_01v8 L=0.5u W=1u
M18160 o7 ibias vss vss sky130_fd_pr__nfet_01v8 L=0.5u W=1u
M18161 o7 ibias vss vss sky130_fd_pr__nfet_01v8 L=0.5u W=1u
M18162 o7 ibias vss vss sky130_fd_pr__nfet_01v8 L=0.5u W=1u
M18163 o7 ibias vss vss sky130_fd_pr__nfet_01v8 L=0.5u W=1u
M18164 o7 ibias vss vss sky130_fd_pr__nfet_01v8 L=0.5u W=1u
M18165 o7 ibias vss vss sky130_fd_pr__nfet_01v8 L=0.5u W=1u
M18166 o7 ibias vss vss sky130_fd_pr__nfet_01v8 L=0.5u W=1u
M18167 o7 ibias vss vss sky130_fd_pr__nfet_01v8 L=0.5u W=1u
M18168 o7 ibias vss vss sky130_fd_pr__nfet_01v8 L=0.5u W=1u
M18169 o7 ibias vss vss sky130_fd_pr__nfet_01v8 L=0.5u W=1u
M18170 o7 ibias vss vss sky130_fd_pr__nfet_01v8 L=0.5u W=1u
M18171 o7 ibias vss vss sky130_fd_pr__nfet_01v8 L=0.5u W=1u
M18172 o7 ibias vss vss sky130_fd_pr__nfet_01v8 L=0.5u W=1u
M18173 o7 ibias vss vss sky130_fd_pr__nfet_01v8 L=0.5u W=1u
M18174 o7 ibias vss vss sky130_fd_pr__nfet_01v8 L=0.5u W=1u
M18175 o7 ibias vss vss sky130_fd_pr__nfet_01v8 L=0.5u W=1u
M18176 o7 ibias vss vss sky130_fd_pr__nfet_01v8 L=0.5u W=1u
M18177 o7 ibias vss vss sky130_fd_pr__nfet_01v8 L=0.5u W=1u
M18178 o7 ibias vss vss sky130_fd_pr__nfet_01v8 L=0.5u W=1u
M18179 o7 ibias vss vss sky130_fd_pr__nfet_01v8 L=0.5u W=1u
M18180 o7 ibias vss vss sky130_fd_pr__nfet_01v8 L=0.5u W=1u
M18181 o7 ibias vss vss sky130_fd_pr__nfet_01v8 L=0.5u W=1u
M18182 o7 ibias vss vss sky130_fd_pr__nfet_01v8 L=0.5u W=1u
M18183 o7 ibias vss vss sky130_fd_pr__nfet_01v8 L=0.5u W=1u
M18184 o7 ibias vss vss sky130_fd_pr__nfet_01v8 L=0.5u W=1u
M18185 o7 ibias vss vss sky130_fd_pr__nfet_01v8 L=0.5u W=1u
M18186 o7 ibias vss vss sky130_fd_pr__nfet_01v8 L=0.5u W=1u
M18187 o7 ibias vss vss sky130_fd_pr__nfet_01v8 L=0.5u W=1u
M18188 o7 ibias vss vss sky130_fd_pr__nfet_01v8 L=0.5u W=1u
M18189 o7 ibias vss vss sky130_fd_pr__nfet_01v8 L=0.5u W=1u
M18190 o7 ibias vss vss sky130_fd_pr__nfet_01v8 L=0.5u W=1u
M18191 o7 ibias vss vss sky130_fd_pr__nfet_01v8 L=0.5u W=1u
M18192 o7 ibias vss vss sky130_fd_pr__nfet_01v8 L=0.5u W=1u
M18193 o7 ibias vss vss sky130_fd_pr__nfet_01v8 L=0.5u W=1u
M18194 o7 ibias vss vss sky130_fd_pr__nfet_01v8 L=0.5u W=1u
M18195 o7 ibias vss vss sky130_fd_pr__nfet_01v8 L=0.5u W=1u
M18196 o7 ibias vss vss sky130_fd_pr__nfet_01v8 L=0.5u W=1u
M18197 o7 ibias vss vss sky130_fd_pr__nfet_01v8 L=0.5u W=1u
M18198 o7 ibias vss vss sky130_fd_pr__nfet_01v8 L=0.5u W=1u
M18199 o7 ibias vss vss sky130_fd_pr__nfet_01v8 L=0.5u W=1u
M18200 o7 ibias vss vss sky130_fd_pr__nfet_01v8 L=0.5u W=1u
M18201 o7 ibias vss vss sky130_fd_pr__nfet_01v8 L=0.5u W=1u
M18202 o7 ibias vss vss sky130_fd_pr__nfet_01v8 L=0.5u W=1u
M18203 o7 ibias vss vss sky130_fd_pr__nfet_01v8 L=0.5u W=1u
M18204 o7 ibias vss vss sky130_fd_pr__nfet_01v8 L=0.5u W=1u
M18205 o7 ibias vss vss sky130_fd_pr__nfet_01v8 L=0.5u W=1u
M18206 o7 ibias vss vss sky130_fd_pr__nfet_01v8 L=0.5u W=1u
M18207 o7 ibias vss vss sky130_fd_pr__nfet_01v8 L=0.5u W=1u
M18208 o7 ibias vss vss sky130_fd_pr__nfet_01v8 L=0.5u W=1u
M18209 o7 ibias vss vss sky130_fd_pr__nfet_01v8 L=0.5u W=1u
M18210 o7 ibias vss vss sky130_fd_pr__nfet_01v8 L=0.5u W=1u
M18211 o7 ibias vss vss sky130_fd_pr__nfet_01v8 L=0.5u W=1u
M18212 o7 ibias vss vss sky130_fd_pr__nfet_01v8 L=0.5u W=1u
M18213 o7 ibias vss vss sky130_fd_pr__nfet_01v8 L=0.5u W=1u
M18214 o7 ibias vss vss sky130_fd_pr__nfet_01v8 L=0.5u W=1u
M18215 o7 ibias vss vss sky130_fd_pr__nfet_01v8 L=0.5u W=1u
M18216 o7 ibias vss vss sky130_fd_pr__nfet_01v8 L=0.5u W=1u
M18217 o7 ibias vss vss sky130_fd_pr__nfet_01v8 L=0.5u W=1u
M18218 o7 ibias vss vss sky130_fd_pr__nfet_01v8 L=0.5u W=1u
M18219 o7 ibias vss vss sky130_fd_pr__nfet_01v8 L=0.5u W=1u
M18220 o7 ibias vss vss sky130_fd_pr__nfet_01v8 L=0.5u W=1u
M18221 o7 ibias vss vss sky130_fd_pr__nfet_01v8 L=0.5u W=1u
M18222 o7 ibias vss vss sky130_fd_pr__nfet_01v8 L=0.5u W=1u
M18223 o7 ibias vss vss sky130_fd_pr__nfet_01v8 L=0.5u W=1u
M18224 o7 ibias vss vss sky130_fd_pr__nfet_01v8 L=0.5u W=1u
M18225 o7 ibias vss vss sky130_fd_pr__nfet_01v8 L=0.5u W=1u
M18226 o7 ibias vss vss sky130_fd_pr__nfet_01v8 L=0.5u W=1u
M18227 o7 ibias vss vss sky130_fd_pr__nfet_01v8 L=0.5u W=1u
M18228 o7 ibias vss vss sky130_fd_pr__nfet_01v8 L=0.5u W=1u
M18229 o7 ibias vss vss sky130_fd_pr__nfet_01v8 L=0.5u W=1u
M18230 o7 ibias vss vss sky130_fd_pr__nfet_01v8 L=0.5u W=1u
M18231 o7 ibias vss vss sky130_fd_pr__nfet_01v8 L=0.5u W=1u
M18232 o7 ibias vss vss sky130_fd_pr__nfet_01v8 L=0.5u W=1u
M18233 o7 ibias vss vss sky130_fd_pr__nfet_01v8 L=0.5u W=1u
M18234 o7 ibias vss vss sky130_fd_pr__nfet_01v8 L=0.5u W=1u
M18235 o7 ibias vss vss sky130_fd_pr__nfet_01v8 L=0.5u W=1u
M18236 o7 ibias vss vss sky130_fd_pr__nfet_01v8 L=0.5u W=1u
M18237 o7 ibias vss vss sky130_fd_pr__nfet_01v8 L=0.5u W=1u
M18238 o7 ibias vss vss sky130_fd_pr__nfet_01v8 L=0.5u W=1u
M18239 o7 ibias vss vss sky130_fd_pr__nfet_01v8 L=0.5u W=1u
M18240 o7 ibias vss vss sky130_fd_pr__nfet_01v8 L=0.5u W=1u
M18241 o7 ibias vss vss sky130_fd_pr__nfet_01v8 L=0.5u W=1u
M18242 o7 ibias vss vss sky130_fd_pr__nfet_01v8 L=0.5u W=1u
M18243 o7 ibias vss vss sky130_fd_pr__nfet_01v8 L=0.5u W=1u
M18244 o7 ibias vss vss sky130_fd_pr__nfet_01v8 L=0.5u W=1u
M18245 o7 ibias vss vss sky130_fd_pr__nfet_01v8 L=0.5u W=1u
M18246 o7 ibias vss vss sky130_fd_pr__nfet_01v8 L=0.5u W=1u
M18247 o7 ibias vss vss sky130_fd_pr__nfet_01v8 L=0.5u W=1u
M18248 o7 ibias vss vss sky130_fd_pr__nfet_01v8 L=0.5u W=1u
M18249 o7 ibias vss vss sky130_fd_pr__nfet_01v8 L=0.5u W=1u
M18250 o7 ibias vss vss sky130_fd_pr__nfet_01v8 L=0.5u W=1u
M18251 o7 ibias vss vss sky130_fd_pr__nfet_01v8 L=0.5u W=1u
M18252 o7 ibias vss vss sky130_fd_pr__nfet_01v8 L=0.5u W=1u
M18253 o7 ibias vss vss sky130_fd_pr__nfet_01v8 L=0.5u W=1u
M18254 o7 ibias vss vss sky130_fd_pr__nfet_01v8 L=0.5u W=1u
M18255 o7 ibias vss vss sky130_fd_pr__nfet_01v8 L=0.5u W=1u
M18256 o7 ibias vss vss sky130_fd_pr__nfet_01v8 L=0.5u W=1u
M18257 o7 ibias vss vss sky130_fd_pr__nfet_01v8 L=0.5u W=1u
M18258 o7 ibias vss vss sky130_fd_pr__nfet_01v8 L=0.5u W=1u
M18259 o7 ibias vss vss sky130_fd_pr__nfet_01v8 L=0.5u W=1u
M18260 o7 ibias vss vss sky130_fd_pr__nfet_01v8 L=0.5u W=1u
M18261 o7 ibias vss vss sky130_fd_pr__nfet_01v8 L=0.5u W=1u
M18262 o7 ibias vss vss sky130_fd_pr__nfet_01v8 L=0.5u W=1u
M18263 o7 ibias vss vss sky130_fd_pr__nfet_01v8 L=0.5u W=1u
M18264 o7 ibias vss vss sky130_fd_pr__nfet_01v8 L=0.5u W=1u
M18265 o7 ibias vss vss sky130_fd_pr__nfet_01v8 L=0.5u W=1u
M18266 o7 ibias vss vss sky130_fd_pr__nfet_01v8 L=0.5u W=1u
M18267 o7 ibias vss vss sky130_fd_pr__nfet_01v8 L=0.5u W=1u
M18268 o7 ibias vss vss sky130_fd_pr__nfet_01v8 L=0.5u W=1u
M18269 o7 ibias vss vss sky130_fd_pr__nfet_01v8 L=0.5u W=1u
M18270 o7 ibias vss vss sky130_fd_pr__nfet_01v8 L=0.5u W=1u
M18271 o7 ibias vss vss sky130_fd_pr__nfet_01v8 L=0.5u W=1u
M18272 o7 ibias vss vss sky130_fd_pr__nfet_01v8 L=0.5u W=1u
M18273 o7 ibias vss vss sky130_fd_pr__nfet_01v8 L=0.5u W=1u
M18274 o7 ibias vss vss sky130_fd_pr__nfet_01v8 L=0.5u W=1u
M18275 o7 ibias vss vss sky130_fd_pr__nfet_01v8 L=0.5u W=1u
M18276 o7 ibias vss vss sky130_fd_pr__nfet_01v8 L=0.5u W=1u
M18277 o7 ibias vss vss sky130_fd_pr__nfet_01v8 L=0.5u W=1u
M18278 o7 ibias vss vss sky130_fd_pr__nfet_01v8 L=0.5u W=1u
M18279 o7 ibias vss vss sky130_fd_pr__nfet_01v8 L=0.5u W=1u
M18280 o7 ibias vss vss sky130_fd_pr__nfet_01v8 L=0.5u W=1u
M18281 o7 ibias vss vss sky130_fd_pr__nfet_01v8 L=0.5u W=1u
M18282 o7 ibias vss vss sky130_fd_pr__nfet_01v8 L=0.5u W=1u
M18283 o7 ibias vss vss sky130_fd_pr__nfet_01v8 L=0.5u W=1u
M18284 o7 ibias vss vss sky130_fd_pr__nfet_01v8 L=0.5u W=1u
M18285 o7 ibias vss vss sky130_fd_pr__nfet_01v8 L=0.5u W=1u
M18286 o7 ibias vss vss sky130_fd_pr__nfet_01v8 L=0.5u W=1u
M18287 o7 ibias vss vss sky130_fd_pr__nfet_01v8 L=0.5u W=1u
M18288 o7 ibias vss vss sky130_fd_pr__nfet_01v8 L=0.5u W=1u
M18289 o7 ibias vss vss sky130_fd_pr__nfet_01v8 L=0.5u W=1u
M18290 o7 ibias vss vss sky130_fd_pr__nfet_01v8 L=0.5u W=1u
M18291 o7 ibias vss vss sky130_fd_pr__nfet_01v8 L=0.5u W=1u
M18292 o7 ibias vss vss sky130_fd_pr__nfet_01v8 L=0.5u W=1u
M18293 o7 ibias vss vss sky130_fd_pr__nfet_01v8 L=0.5u W=1u
M18294 o7 ibias vss vss sky130_fd_pr__nfet_01v8 L=0.5u W=1u
M18295 o7 ibias vss vss sky130_fd_pr__nfet_01v8 L=0.5u W=1u
M18296 o7 ibias vss vss sky130_fd_pr__nfet_01v8 L=0.5u W=1u
M18297 o7 ibias vss vss sky130_fd_pr__nfet_01v8 L=0.5u W=1u
M18298 o7 ibias vss vss sky130_fd_pr__nfet_01v8 L=0.5u W=1u
M18299 o7 ibias vss vss sky130_fd_pr__nfet_01v8 L=0.5u W=1u
M18300 o7 ibias vss vss sky130_fd_pr__nfet_01v8 L=0.5u W=1u
M18301 o7 ibias vss vss sky130_fd_pr__nfet_01v8 L=0.5u W=1u
M18302 o7 ibias vss vss sky130_fd_pr__nfet_01v8 L=0.5u W=1u
M18303 o7 ibias vss vss sky130_fd_pr__nfet_01v8 L=0.5u W=1u
M18304 o7 ibias vss vss sky130_fd_pr__nfet_01v8 L=0.5u W=1u
M18305 o7 ibias vss vss sky130_fd_pr__nfet_01v8 L=0.5u W=1u
M18306 o7 ibias vss vss sky130_fd_pr__nfet_01v8 L=0.5u W=1u
M18307 o7 ibias vss vss sky130_fd_pr__nfet_01v8 L=0.5u W=1u
M18308 o7 ibias vss vss sky130_fd_pr__nfet_01v8 L=0.5u W=1u
M18309 o7 ibias vss vss sky130_fd_pr__nfet_01v8 L=0.5u W=1u
M18310 o7 ibias vss vss sky130_fd_pr__nfet_01v8 L=0.5u W=1u
M18311 o7 ibias vss vss sky130_fd_pr__nfet_01v8 L=0.5u W=1u
M18312 o7 ibias vss vss sky130_fd_pr__nfet_01v8 L=0.5u W=1u
M18313 o7 ibias vss vss sky130_fd_pr__nfet_01v8 L=0.5u W=1u
M18314 o7 ibias vss vss sky130_fd_pr__nfet_01v8 L=0.5u W=1u
M18315 o7 ibias vss vss sky130_fd_pr__nfet_01v8 L=0.5u W=1u
M18316 o7 ibias vss vss sky130_fd_pr__nfet_01v8 L=0.5u W=1u
M18317 o7 ibias vss vss sky130_fd_pr__nfet_01v8 L=0.5u W=1u
M18318 o7 ibias vss vss sky130_fd_pr__nfet_01v8 L=0.5u W=1u
M18319 o7 ibias vss vss sky130_fd_pr__nfet_01v8 L=0.5u W=1u
M18320 o7 ibias vss vss sky130_fd_pr__nfet_01v8 L=0.5u W=1u
M18321 o7 ibias vss vss sky130_fd_pr__nfet_01v8 L=0.5u W=1u
M18322 o7 ibias vss vss sky130_fd_pr__nfet_01v8 L=0.5u W=1u
M18323 o7 ibias vss vss sky130_fd_pr__nfet_01v8 L=0.5u W=1u
M18324 o7 ibias vss vss sky130_fd_pr__nfet_01v8 L=0.5u W=1u
M18325 o7 ibias vss vss sky130_fd_pr__nfet_01v8 L=0.5u W=1u
M18326 o7 ibias vss vss sky130_fd_pr__nfet_01v8 L=0.5u W=1u
M18327 o7 ibias vss vss sky130_fd_pr__nfet_01v8 L=0.5u W=1u
M18328 o7 ibias vss vss sky130_fd_pr__nfet_01v8 L=0.5u W=1u
M18329 o7 ibias vss vss sky130_fd_pr__nfet_01v8 L=0.5u W=1u
M18330 o7 ibias vss vss sky130_fd_pr__nfet_01v8 L=0.5u W=1u
M18331 o7 ibias vss vss sky130_fd_pr__nfet_01v8 L=0.5u W=1u
M18332 o7 ibias vss vss sky130_fd_pr__nfet_01v8 L=0.5u W=1u
M18333 o7 ibias vss vss sky130_fd_pr__nfet_01v8 L=0.5u W=1u
M18334 o7 ibias vss vss sky130_fd_pr__nfet_01v8 L=0.5u W=1u
M18335 o7 ibias vss vss sky130_fd_pr__nfet_01v8 L=0.5u W=1u
M18336 o7 ibias vss vss sky130_fd_pr__nfet_01v8 L=0.5u W=1u
M18337 o7 ibias vss vss sky130_fd_pr__nfet_01v8 L=0.5u W=1u
M18338 o7 ibias vss vss sky130_fd_pr__nfet_01v8 L=0.5u W=1u
M18339 o7 ibias vss vss sky130_fd_pr__nfet_01v8 L=0.5u W=1u
M18340 o7 ibias vss vss sky130_fd_pr__nfet_01v8 L=0.5u W=1u
M18341 o7 ibias vss vss sky130_fd_pr__nfet_01v8 L=0.5u W=1u
M18342 o7 ibias vss vss sky130_fd_pr__nfet_01v8 L=0.5u W=1u
M18343 o7 ibias vss vss sky130_fd_pr__nfet_01v8 L=0.5u W=1u
M18344 o7 ibias vss vss sky130_fd_pr__nfet_01v8 L=0.5u W=1u
M18345 o7 ibias vss vss sky130_fd_pr__nfet_01v8 L=0.5u W=1u
M18346 o7 ibias vss vss sky130_fd_pr__nfet_01v8 L=0.5u W=1u
M18347 o7 ibias vss vss sky130_fd_pr__nfet_01v8 L=0.5u W=1u
M18348 o7 ibias vss vss sky130_fd_pr__nfet_01v8 L=0.5u W=1u
M18349 o7 ibias vss vss sky130_fd_pr__nfet_01v8 L=0.5u W=1u
M18350 o7 ibias vss vss sky130_fd_pr__nfet_01v8 L=0.5u W=1u
M18351 o7 ibias vss vss sky130_fd_pr__nfet_01v8 L=0.5u W=1u
M18352 o7 ibias vss vss sky130_fd_pr__nfet_01v8 L=0.5u W=1u
M18353 o7 ibias vss vss sky130_fd_pr__nfet_01v8 L=0.5u W=1u
M18354 o7 ibias vss vss sky130_fd_pr__nfet_01v8 L=0.5u W=1u
M18355 o7 ibias vss vss sky130_fd_pr__nfet_01v8 L=0.5u W=1u
M18356 o7 ibias vss vss sky130_fd_pr__nfet_01v8 L=0.5u W=1u
M18357 o7 ibias vss vss sky130_fd_pr__nfet_01v8 L=0.5u W=1u
M18358 o7 ibias vss vss sky130_fd_pr__nfet_01v8 L=0.5u W=1u
M18359 o7 ibias vss vss sky130_fd_pr__nfet_01v8 L=0.5u W=1u
M18360 o7 ibias vss vss sky130_fd_pr__nfet_01v8 L=0.5u W=1u
M18361 o7 ibias vss vss sky130_fd_pr__nfet_01v8 L=0.5u W=1u
M18362 o7 ibias vss vss sky130_fd_pr__nfet_01v8 L=0.5u W=1u
M18363 o7 ibias vss vss sky130_fd_pr__nfet_01v8 L=0.5u W=1u
M18364 o7 ibias vss vss sky130_fd_pr__nfet_01v8 L=0.5u W=1u
M18365 o7 ibias vss vss sky130_fd_pr__nfet_01v8 L=0.5u W=1u
M18366 o7 ibias vss vss sky130_fd_pr__nfet_01v8 L=0.5u W=1u
M18367 o7 ibias vss vss sky130_fd_pr__nfet_01v8 L=0.5u W=1u
M18368 o7 ibias vss vss sky130_fd_pr__nfet_01v8 L=0.5u W=1u
M18369 o7 ibias vss vss sky130_fd_pr__nfet_01v8 L=0.5u W=1u
M18370 o7 ibias vss vss sky130_fd_pr__nfet_01v8 L=0.5u W=1u
M18371 o7 ibias vss vss sky130_fd_pr__nfet_01v8 L=0.5u W=1u
M18372 o7 ibias vss vss sky130_fd_pr__nfet_01v8 L=0.5u W=1u
M18373 o7 ibias vss vss sky130_fd_pr__nfet_01v8 L=0.5u W=1u
M18374 o7 ibias vss vss sky130_fd_pr__nfet_01v8 L=0.5u W=1u
M18375 o7 ibias vss vss sky130_fd_pr__nfet_01v8 L=0.5u W=1u
M18376 o7 ibias vss vss sky130_fd_pr__nfet_01v8 L=0.5u W=1u
M18377 o7 ibias vss vss sky130_fd_pr__nfet_01v8 L=0.5u W=1u
M18378 o7 ibias vss vss sky130_fd_pr__nfet_01v8 L=0.5u W=1u
M18379 o7 ibias vss vss sky130_fd_pr__nfet_01v8 L=0.5u W=1u
M18380 o7 ibias vss vss sky130_fd_pr__nfet_01v8 L=0.5u W=1u
M18381 o7 ibias vss vss sky130_fd_pr__nfet_01v8 L=0.5u W=1u
M18382 o7 ibias vss vss sky130_fd_pr__nfet_01v8 L=0.5u W=1u
M18383 o7 ibias vss vss sky130_fd_pr__nfet_01v8 L=0.5u W=1u
M18384 o7 ibias vss vss sky130_fd_pr__nfet_01v8 L=0.5u W=1u
M18385 o7 ibias vss vss sky130_fd_pr__nfet_01v8 L=0.5u W=1u
M18386 o7 ibias vss vss sky130_fd_pr__nfet_01v8 L=0.5u W=1u
M18387 o7 ibias vss vss sky130_fd_pr__nfet_01v8 L=0.5u W=1u
M18388 o7 ibias vss vss sky130_fd_pr__nfet_01v8 L=0.5u W=1u
M18389 o7 ibias vss vss sky130_fd_pr__nfet_01v8 L=0.5u W=1u
M18390 o7 ibias vss vss sky130_fd_pr__nfet_01v8 L=0.5u W=1u
M18391 o7 ibias vss vss sky130_fd_pr__nfet_01v8 L=0.5u W=1u
M18392 o7 ibias vss vss sky130_fd_pr__nfet_01v8 L=0.5u W=1u
M18393 o7 ibias vss vss sky130_fd_pr__nfet_01v8 L=0.5u W=1u
M18394 o7 ibias vss vss sky130_fd_pr__nfet_01v8 L=0.5u W=1u
M18395 o7 ibias vss vss sky130_fd_pr__nfet_01v8 L=0.5u W=1u
M18396 o7 ibias vss vss sky130_fd_pr__nfet_01v8 L=0.5u W=1u
M18397 o7 ibias vss vss sky130_fd_pr__nfet_01v8 L=0.5u W=1u
M18398 o7 ibias vss vss sky130_fd_pr__nfet_01v8 L=0.5u W=1u
M18399 o7 ibias vss vss sky130_fd_pr__nfet_01v8 L=0.5u W=1u
M18400 o7 ibias vss vss sky130_fd_pr__nfet_01v8 L=0.5u W=1u
M18401 o7 ibias vss vss sky130_fd_pr__nfet_01v8 L=0.5u W=1u
M18402 o7 ibias vss vss sky130_fd_pr__nfet_01v8 L=0.5u W=1u
M18403 o7 ibias vss vss sky130_fd_pr__nfet_01v8 L=0.5u W=1u
M18404 o7 ibias vss vss sky130_fd_pr__nfet_01v8 L=0.5u W=1u
M18405 o7 ibias vss vss sky130_fd_pr__nfet_01v8 L=0.5u W=1u
M18406 o7 ibias vss vss sky130_fd_pr__nfet_01v8 L=0.5u W=1u
M18407 o7 ibias vss vss sky130_fd_pr__nfet_01v8 L=0.5u W=1u
M18408 o7 ibias vss vss sky130_fd_pr__nfet_01v8 L=0.5u W=1u
M18409 o7 ibias vss vss sky130_fd_pr__nfet_01v8 L=0.5u W=1u
M18410 o7 ibias vss vss sky130_fd_pr__nfet_01v8 L=0.5u W=1u
M18411 o7 ibias vss vss sky130_fd_pr__nfet_01v8 L=0.5u W=1u
M18412 o7 ibias vss vss sky130_fd_pr__nfet_01v8 L=0.5u W=1u
M18413 o7 ibias vss vss sky130_fd_pr__nfet_01v8 L=0.5u W=1u
M18414 o7 ibias vss vss sky130_fd_pr__nfet_01v8 L=0.5u W=1u
M18415 o7 ibias vss vss sky130_fd_pr__nfet_01v8 L=0.5u W=1u
M18416 o7 ibias vss vss sky130_fd_pr__nfet_01v8 L=0.5u W=1u
M18417 o7 ibias vss vss sky130_fd_pr__nfet_01v8 L=0.5u W=1u
M18418 o7 ibias vss vss sky130_fd_pr__nfet_01v8 L=0.5u W=1u
M18419 o7 ibias vss vss sky130_fd_pr__nfet_01v8 L=0.5u W=1u
M18420 o7 ibias vss vss sky130_fd_pr__nfet_01v8 L=0.5u W=1u
M18421 o7 ibias vss vss sky130_fd_pr__nfet_01v8 L=0.5u W=1u
M18422 o7 ibias vss vss sky130_fd_pr__nfet_01v8 L=0.5u W=1u
M18423 o7 ibias vss vss sky130_fd_pr__nfet_01v8 L=0.5u W=1u
M18424 o7 ibias vss vss sky130_fd_pr__nfet_01v8 L=0.5u W=1u
M18425 o7 ibias vss vss sky130_fd_pr__nfet_01v8 L=0.5u W=1u
M18426 o7 ibias vss vss sky130_fd_pr__nfet_01v8 L=0.5u W=1u
M18427 o7 ibias vss vss sky130_fd_pr__nfet_01v8 L=0.5u W=1u
M18428 o7 ibias vss vss sky130_fd_pr__nfet_01v8 L=0.5u W=1u
M18429 o7 ibias vss vss sky130_fd_pr__nfet_01v8 L=0.5u W=1u
M18430 o7 ibias vss vss sky130_fd_pr__nfet_01v8 L=0.5u W=1u
M18431 o7 ibias vss vss sky130_fd_pr__nfet_01v8 L=0.5u W=1u
M18432 o7 ibias vss vss sky130_fd_pr__nfet_01v8 L=0.5u W=1u
M18433 o7 ibias vss vss sky130_fd_pr__nfet_01v8 L=0.5u W=1u
M18434 o7 ibias vss vss sky130_fd_pr__nfet_01v8 L=0.5u W=1u
M18435 o7 ibias vss vss sky130_fd_pr__nfet_01v8 L=0.5u W=1u
M18436 o7 ibias vss vss sky130_fd_pr__nfet_01v8 L=0.5u W=1u
M18437 o7 ibias vss vss sky130_fd_pr__nfet_01v8 L=0.5u W=1u
M18438 o7 ibias vss vss sky130_fd_pr__nfet_01v8 L=0.5u W=1u
M18439 o7 ibias vss vss sky130_fd_pr__nfet_01v8 L=0.5u W=1u
M18440 o7 ibias vss vss sky130_fd_pr__nfet_01v8 L=0.5u W=1u
M18441 o7 ibias vss vss sky130_fd_pr__nfet_01v8 L=0.5u W=1u
M18442 o7 ibias vss vss sky130_fd_pr__nfet_01v8 L=0.5u W=1u
M18443 o7 ibias vss vss sky130_fd_pr__nfet_01v8 L=0.5u W=1u
M18444 o7 ibias vss vss sky130_fd_pr__nfet_01v8 L=0.5u W=1u
M18445 o7 ibias vss vss sky130_fd_pr__nfet_01v8 L=0.5u W=1u
M18446 o7 ibias vss vss sky130_fd_pr__nfet_01v8 L=0.5u W=1u
M18447 o7 ibias vss vss sky130_fd_pr__nfet_01v8 L=0.5u W=1u
M18448 o7 ibias vss vss sky130_fd_pr__nfet_01v8 L=0.5u W=1u
M18449 o7 ibias vss vss sky130_fd_pr__nfet_01v8 L=0.5u W=1u
M18450 o7 ibias vss vss sky130_fd_pr__nfet_01v8 L=0.5u W=1u
M18451 o7 ibias vss vss sky130_fd_pr__nfet_01v8 L=0.5u W=1u
M18452 o7 ibias vss vss sky130_fd_pr__nfet_01v8 L=0.5u W=1u
M18453 o7 ibias vss vss sky130_fd_pr__nfet_01v8 L=0.5u W=1u
M18454 o7 ibias vss vss sky130_fd_pr__nfet_01v8 L=0.5u W=1u
M18455 o7 ibias vss vss sky130_fd_pr__nfet_01v8 L=0.5u W=1u
M18456 o7 ibias vss vss sky130_fd_pr__nfet_01v8 L=0.5u W=1u
M18457 o7 ibias vss vss sky130_fd_pr__nfet_01v8 L=0.5u W=1u
M18458 o7 ibias vss vss sky130_fd_pr__nfet_01v8 L=0.5u W=1u
M18459 o7 ibias vss vss sky130_fd_pr__nfet_01v8 L=0.5u W=1u
M18460 o7 ibias vss vss sky130_fd_pr__nfet_01v8 L=0.5u W=1u
M18461 o7 ibias vss vss sky130_fd_pr__nfet_01v8 L=0.5u W=1u
M18462 o7 ibias vss vss sky130_fd_pr__nfet_01v8 L=0.5u W=1u
M18463 o7 ibias vss vss sky130_fd_pr__nfet_01v8 L=0.5u W=1u
M18464 o7 ibias vss vss sky130_fd_pr__nfet_01v8 L=0.5u W=1u
M18465 o7 ibias vss vss sky130_fd_pr__nfet_01v8 L=0.5u W=1u
M18466 o7 ibias vss vss sky130_fd_pr__nfet_01v8 L=0.5u W=1u
M18467 o7 ibias vss vss sky130_fd_pr__nfet_01v8 L=0.5u W=1u
M18468 o7 ibias vss vss sky130_fd_pr__nfet_01v8 L=0.5u W=1u
M18469 o7 ibias vss vss sky130_fd_pr__nfet_01v8 L=0.5u W=1u
M18470 o7 ibias vss vss sky130_fd_pr__nfet_01v8 L=0.5u W=1u
M18471 o7 ibias vss vss sky130_fd_pr__nfet_01v8 L=0.5u W=1u
M18472 o7 ibias vss vss sky130_fd_pr__nfet_01v8 L=0.5u W=1u
M18473 o7 ibias vss vss sky130_fd_pr__nfet_01v8 L=0.5u W=1u
M18474 o7 ibias vss vss sky130_fd_pr__nfet_01v8 L=0.5u W=1u
M18475 o7 ibias vss vss sky130_fd_pr__nfet_01v8 L=0.5u W=1u
M18476 o7 ibias vss vss sky130_fd_pr__nfet_01v8 L=0.5u W=1u
M18477 o7 ibias vss vss sky130_fd_pr__nfet_01v8 L=0.5u W=1u
M18478 o7 ibias vss vss sky130_fd_pr__nfet_01v8 L=0.5u W=1u
M18479 o7 ibias vss vss sky130_fd_pr__nfet_01v8 L=0.5u W=1u
M18480 o7 ibias vss vss sky130_fd_pr__nfet_01v8 L=0.5u W=1u
M18481 o7 ibias vss vss sky130_fd_pr__nfet_01v8 L=0.5u W=1u
M18482 o7 ibias vss vss sky130_fd_pr__nfet_01v8 L=0.5u W=1u
M18483 o7 ibias vss vss sky130_fd_pr__nfet_01v8 L=0.5u W=1u
M18484 o7 ibias vss vss sky130_fd_pr__nfet_01v8 L=0.5u W=1u
M18485 o7 ibias vss vss sky130_fd_pr__nfet_01v8 L=0.5u W=1u
M18486 o7 ibias vss vss sky130_fd_pr__nfet_01v8 L=0.5u W=1u
M18487 o7 ibias vss vss sky130_fd_pr__nfet_01v8 L=0.5u W=1u
M18488 o7 ibias vss vss sky130_fd_pr__nfet_01v8 L=0.5u W=1u
M18489 o7 ibias vss vss sky130_fd_pr__nfet_01v8 L=0.5u W=1u
M18490 o7 ibias vss vss sky130_fd_pr__nfet_01v8 L=0.5u W=1u
M18491 o7 ibias vss vss sky130_fd_pr__nfet_01v8 L=0.5u W=1u
M18492 o7 ibias vss vss sky130_fd_pr__nfet_01v8 L=0.5u W=1u
M18493 o7 ibias vss vss sky130_fd_pr__nfet_01v8 L=0.5u W=1u
M18494 o7 ibias vss vss sky130_fd_pr__nfet_01v8 L=0.5u W=1u
M18495 o7 ibias vss vss sky130_fd_pr__nfet_01v8 L=0.5u W=1u
M18496 o7 ibias vss vss sky130_fd_pr__nfet_01v8 L=0.5u W=1u
M18497 o7 ibias vss vss sky130_fd_pr__nfet_01v8 L=0.5u W=1u
M18498 o7 ibias vss vss sky130_fd_pr__nfet_01v8 L=0.5u W=1u
M18499 o7 ibias vss vss sky130_fd_pr__nfet_01v8 L=0.5u W=1u
M18500 o7 ibias vss vss sky130_fd_pr__nfet_01v8 L=0.5u W=1u
M18501 o7 ibias vss vss sky130_fd_pr__nfet_01v8 L=0.5u W=1u
M18502 o7 ibias vss vss sky130_fd_pr__nfet_01v8 L=0.5u W=1u
M18503 o7 ibias vss vss sky130_fd_pr__nfet_01v8 L=0.5u W=1u
M18504 o7 ibias vss vss sky130_fd_pr__nfet_01v8 L=0.5u W=1u
M18505 o7 ibias vss vss sky130_fd_pr__nfet_01v8 L=0.5u W=1u
M18506 o7 ibias vss vss sky130_fd_pr__nfet_01v8 L=0.5u W=1u
M18507 o7 ibias vss vss sky130_fd_pr__nfet_01v8 L=0.5u W=1u
M18508 o7 ibias vss vss sky130_fd_pr__nfet_01v8 L=0.5u W=1u
M18509 o7 ibias vss vss sky130_fd_pr__nfet_01v8 L=0.5u W=1u
M18510 o7 ibias vss vss sky130_fd_pr__nfet_01v8 L=0.5u W=1u
M18511 o7 ibias vss vss sky130_fd_pr__nfet_01v8 L=0.5u W=1u
M18512 o7 ibias vss vss sky130_fd_pr__nfet_01v8 L=0.5u W=1u
M18513 o7 ibias vss vss sky130_fd_pr__nfet_01v8 L=0.5u W=1u
M18514 o7 ibias vss vss sky130_fd_pr__nfet_01v8 L=0.5u W=1u
M18515 o7 ibias vss vss sky130_fd_pr__nfet_01v8 L=0.5u W=1u
M18516 o7 ibias vss vss sky130_fd_pr__nfet_01v8 L=0.5u W=1u
M18517 o7 ibias vss vss sky130_fd_pr__nfet_01v8 L=0.5u W=1u
M18518 o7 ibias vss vss sky130_fd_pr__nfet_01v8 L=0.5u W=1u
M18519 o7 ibias vss vss sky130_fd_pr__nfet_01v8 L=0.5u W=1u
M18520 o7 ibias vss vss sky130_fd_pr__nfet_01v8 L=0.5u W=1u
M18521 o7 ibias vss vss sky130_fd_pr__nfet_01v8 L=0.5u W=1u
M18522 o7 ibias vss vss sky130_fd_pr__nfet_01v8 L=0.5u W=1u
M18523 o7 ibias vss vss sky130_fd_pr__nfet_01v8 L=0.5u W=1u
M18524 o7 ibias vss vss sky130_fd_pr__nfet_01v8 L=0.5u W=1u
M18525 o7 ibias vss vss sky130_fd_pr__nfet_01v8 L=0.5u W=1u
M18526 o7 ibias vss vss sky130_fd_pr__nfet_01v8 L=0.5u W=1u
M18527 o7 ibias vss vss sky130_fd_pr__nfet_01v8 L=0.5u W=1u
M18528 o7 ibias vss vss sky130_fd_pr__nfet_01v8 L=0.5u W=1u
M18529 o7 ibias vss vss sky130_fd_pr__nfet_01v8 L=0.5u W=1u
M18530 o7 ibias vss vss sky130_fd_pr__nfet_01v8 L=0.5u W=1u
M18531 o7 ibias vss vss sky130_fd_pr__nfet_01v8 L=0.5u W=1u
M18532 o7 ibias vss vss sky130_fd_pr__nfet_01v8 L=0.5u W=1u
M18533 o7 ibias vss vss sky130_fd_pr__nfet_01v8 L=0.5u W=1u
M18534 o7 ibias vss vss sky130_fd_pr__nfet_01v8 L=0.5u W=1u
M18535 o7 ibias vss vss sky130_fd_pr__nfet_01v8 L=0.5u W=1u
M18536 o7 ibias vss vss sky130_fd_pr__nfet_01v8 L=0.5u W=1u
M18537 o7 ibias vss vss sky130_fd_pr__nfet_01v8 L=0.5u W=1u
M18538 o7 ibias vss vss sky130_fd_pr__nfet_01v8 L=0.5u W=1u
M18539 o7 ibias vss vss sky130_fd_pr__nfet_01v8 L=0.5u W=1u
M18540 o7 ibias vss vss sky130_fd_pr__nfet_01v8 L=0.5u W=1u
M18541 o7 ibias vss vss sky130_fd_pr__nfet_01v8 L=0.5u W=1u
M18542 o7 ibias vss vss sky130_fd_pr__nfet_01v8 L=0.5u W=1u
M18543 o7 ibias vss vss sky130_fd_pr__nfet_01v8 L=0.5u W=1u
M18544 o7 ibias vss vss sky130_fd_pr__nfet_01v8 L=0.5u W=1u
M18545 o7 ibias vss vss sky130_fd_pr__nfet_01v8 L=0.5u W=1u
M18546 o7 ibias vss vss sky130_fd_pr__nfet_01v8 L=0.5u W=1u
M18547 o7 ibias vss vss sky130_fd_pr__nfet_01v8 L=0.5u W=1u
M18548 o7 ibias vss vss sky130_fd_pr__nfet_01v8 L=0.5u W=1u
M18549 o7 ibias vss vss sky130_fd_pr__nfet_01v8 L=0.5u W=1u
M18550 o7 ibias vss vss sky130_fd_pr__nfet_01v8 L=0.5u W=1u
M18551 o7 ibias vss vss sky130_fd_pr__nfet_01v8 L=0.5u W=1u
M18552 o7 ibias vss vss sky130_fd_pr__nfet_01v8 L=0.5u W=1u
M18553 o7 ibias vss vss sky130_fd_pr__nfet_01v8 L=0.5u W=1u
M18554 o7 ibias vss vss sky130_fd_pr__nfet_01v8 L=0.5u W=1u
M18555 o7 ibias vss vss sky130_fd_pr__nfet_01v8 L=0.5u W=1u
M18556 o7 ibias vss vss sky130_fd_pr__nfet_01v8 L=0.5u W=1u
M18557 o7 ibias vss vss sky130_fd_pr__nfet_01v8 L=0.5u W=1u
M18558 o7 ibias vss vss sky130_fd_pr__nfet_01v8 L=0.5u W=1u
M18559 o7 ibias vss vss sky130_fd_pr__nfet_01v8 L=0.5u W=1u
M18560 o7 ibias vss vss sky130_fd_pr__nfet_01v8 L=0.5u W=1u
M18561 o7 ibias vss vss sky130_fd_pr__nfet_01v8 L=0.5u W=1u
M18562 o7 ibias vss vss sky130_fd_pr__nfet_01v8 L=0.5u W=1u
M18563 o7 ibias vss vss sky130_fd_pr__nfet_01v8 L=0.5u W=1u
M18564 o7 ibias vss vss sky130_fd_pr__nfet_01v8 L=0.5u W=1u
M18565 o7 ibias vss vss sky130_fd_pr__nfet_01v8 L=0.5u W=1u
M18566 o7 ibias vss vss sky130_fd_pr__nfet_01v8 L=0.5u W=1u
M18567 o7 ibias vss vss sky130_fd_pr__nfet_01v8 L=0.5u W=1u
M18568 o7 ibias vss vss sky130_fd_pr__nfet_01v8 L=0.5u W=1u
M18569 o7 ibias vss vss sky130_fd_pr__nfet_01v8 L=0.5u W=1u
M18570 o7 ibias vss vss sky130_fd_pr__nfet_01v8 L=0.5u W=1u
M18571 o7 ibias vss vss sky130_fd_pr__nfet_01v8 L=0.5u W=1u
M18572 o7 ibias vss vss sky130_fd_pr__nfet_01v8 L=0.5u W=1u
M18573 o7 ibias vss vss sky130_fd_pr__nfet_01v8 L=0.5u W=1u
M18574 o7 ibias vss vss sky130_fd_pr__nfet_01v8 L=0.5u W=1u
M18575 o7 ibias vss vss sky130_fd_pr__nfet_01v8 L=0.5u W=1u
M18576 o7 ibias vss vss sky130_fd_pr__nfet_01v8 L=0.5u W=1u
M18577 o7 ibias vss vss sky130_fd_pr__nfet_01v8 L=0.5u W=1u
M18578 o7 ibias vss vss sky130_fd_pr__nfet_01v8 L=0.5u W=1u
M18579 o7 ibias vss vss sky130_fd_pr__nfet_01v8 L=0.5u W=1u
M18580 o7 ibias vss vss sky130_fd_pr__nfet_01v8 L=0.5u W=1u
M18581 o7 ibias vss vss sky130_fd_pr__nfet_01v8 L=0.5u W=1u
M18582 o7 ibias vss vss sky130_fd_pr__nfet_01v8 L=0.5u W=1u
M18583 o7 ibias vss vss sky130_fd_pr__nfet_01v8 L=0.5u W=1u
M18584 o7 ibias vss vss sky130_fd_pr__nfet_01v8 L=0.5u W=1u
M18585 o7 ibias vss vss sky130_fd_pr__nfet_01v8 L=0.5u W=1u
M18586 o7 ibias vss vss sky130_fd_pr__nfet_01v8 L=0.5u W=1u
M18587 o7 ibias vss vss sky130_fd_pr__nfet_01v8 L=0.5u W=1u
M18588 o7 ibias vss vss sky130_fd_pr__nfet_01v8 L=0.5u W=1u
M18589 o7 ibias vss vss sky130_fd_pr__nfet_01v8 L=0.5u W=1u
M18590 o7 ibias vss vss sky130_fd_pr__nfet_01v8 L=0.5u W=1u
M18591 o7 ibias vss vss sky130_fd_pr__nfet_01v8 L=0.5u W=1u
M18592 o7 ibias vss vss sky130_fd_pr__nfet_01v8 L=0.5u W=1u
M18593 o7 ibias vss vss sky130_fd_pr__nfet_01v8 L=0.5u W=1u
M18594 o7 ibias vss vss sky130_fd_pr__nfet_01v8 L=0.5u W=1u
M18595 o7 ibias vss vss sky130_fd_pr__nfet_01v8 L=0.5u W=1u
M18596 o7 ibias vss vss sky130_fd_pr__nfet_01v8 L=0.5u W=1u
M18597 o7 ibias vss vss sky130_fd_pr__nfet_01v8 L=0.5u W=1u
M18598 o7 ibias vss vss sky130_fd_pr__nfet_01v8 L=0.5u W=1u
M18599 o7 ibias vss vss sky130_fd_pr__nfet_01v8 L=0.5u W=1u
M18600 o7 ibias vss vss sky130_fd_pr__nfet_01v8 L=0.5u W=1u
M18601 o7 ibias vss vss sky130_fd_pr__nfet_01v8 L=0.5u W=1u
M18602 o7 ibias vss vss sky130_fd_pr__nfet_01v8 L=0.5u W=1u
M18603 o7 ibias vss vss sky130_fd_pr__nfet_01v8 L=0.5u W=1u
M18604 o7 ibias vss vss sky130_fd_pr__nfet_01v8 L=0.5u W=1u
M18605 o7 ibias vss vss sky130_fd_pr__nfet_01v8 L=0.5u W=1u
M18606 o7 ibias vss vss sky130_fd_pr__nfet_01v8 L=0.5u W=1u
M18607 o7 ibias vss vss sky130_fd_pr__nfet_01v8 L=0.5u W=1u
M18608 o7 ibias vss vss sky130_fd_pr__nfet_01v8 L=0.5u W=1u
M18609 o7 ibias vss vss sky130_fd_pr__nfet_01v8 L=0.5u W=1u
M18610 o7 ibias vss vss sky130_fd_pr__nfet_01v8 L=0.5u W=1u
M18611 o7 ibias vss vss sky130_fd_pr__nfet_01v8 L=0.5u W=1u
M18612 o7 ibias vss vss sky130_fd_pr__nfet_01v8 L=0.5u W=1u
M18613 o7 ibias vss vss sky130_fd_pr__nfet_01v8 L=0.5u W=1u
M18614 o7 ibias vss vss sky130_fd_pr__nfet_01v8 L=0.5u W=1u
M18615 o7 ibias vss vss sky130_fd_pr__nfet_01v8 L=0.5u W=1u
M18616 o7 ibias vss vss sky130_fd_pr__nfet_01v8 L=0.5u W=1u
M18617 o7 ibias vss vss sky130_fd_pr__nfet_01v8 L=0.5u W=1u
M18618 o7 ibias vss vss sky130_fd_pr__nfet_01v8 L=0.5u W=1u
M18619 o7 ibias vss vss sky130_fd_pr__nfet_01v8 L=0.5u W=1u
M18620 o7 ibias vss vss sky130_fd_pr__nfet_01v8 L=0.5u W=1u
M18621 o7 ibias vss vss sky130_fd_pr__nfet_01v8 L=0.5u W=1u
M18622 o7 ibias vss vss sky130_fd_pr__nfet_01v8 L=0.5u W=1u
M18623 o7 ibias vss vss sky130_fd_pr__nfet_01v8 L=0.5u W=1u
M18624 o7 ibias vss vss sky130_fd_pr__nfet_01v8 L=0.5u W=1u
M18625 o7 ibias vss vss sky130_fd_pr__nfet_01v8 L=0.5u W=1u
M18626 o7 ibias vss vss sky130_fd_pr__nfet_01v8 L=0.5u W=1u
M18627 o7 ibias vss vss sky130_fd_pr__nfet_01v8 L=0.5u W=1u
M18628 o7 ibias vss vss sky130_fd_pr__nfet_01v8 L=0.5u W=1u
M18629 o7 ibias vss vss sky130_fd_pr__nfet_01v8 L=0.5u W=1u
M18630 o7 ibias vss vss sky130_fd_pr__nfet_01v8 L=0.5u W=1u
M18631 o7 ibias vss vss sky130_fd_pr__nfet_01v8 L=0.5u W=1u
M18632 o7 ibias vss vss sky130_fd_pr__nfet_01v8 L=0.5u W=1u
M18633 o7 ibias vss vss sky130_fd_pr__nfet_01v8 L=0.5u W=1u
M18634 o7 ibias vss vss sky130_fd_pr__nfet_01v8 L=0.5u W=1u
M18635 o7 ibias vss vss sky130_fd_pr__nfet_01v8 L=0.5u W=1u
M18636 o7 ibias vss vss sky130_fd_pr__nfet_01v8 L=0.5u W=1u
M18637 o7 ibias vss vss sky130_fd_pr__nfet_01v8 L=0.5u W=1u
M18638 o7 ibias vss vss sky130_fd_pr__nfet_01v8 L=0.5u W=1u
M18639 o7 ibias vss vss sky130_fd_pr__nfet_01v8 L=0.5u W=1u
M18640 o7 ibias vss vss sky130_fd_pr__nfet_01v8 L=0.5u W=1u
M18641 o7 ibias vss vss sky130_fd_pr__nfet_01v8 L=0.5u W=1u
M18642 o7 ibias vss vss sky130_fd_pr__nfet_01v8 L=0.5u W=1u
M18643 o7 ibias vss vss sky130_fd_pr__nfet_01v8 L=0.5u W=1u
M18644 o7 ibias vss vss sky130_fd_pr__nfet_01v8 L=0.5u W=1u
M18645 o7 ibias vss vss sky130_fd_pr__nfet_01v8 L=0.5u W=1u
M18646 o7 ibias vss vss sky130_fd_pr__nfet_01v8 L=0.5u W=1u
M18647 o7 ibias vss vss sky130_fd_pr__nfet_01v8 L=0.5u W=1u
M18648 o7 ibias vss vss sky130_fd_pr__nfet_01v8 L=0.5u W=1u
M18649 o7 ibias vss vss sky130_fd_pr__nfet_01v8 L=0.5u W=1u
M18650 o7 ibias vss vss sky130_fd_pr__nfet_01v8 L=0.5u W=1u
M18651 o7 ibias vss vss sky130_fd_pr__nfet_01v8 L=0.5u W=1u
M18652 o7 ibias vss vss sky130_fd_pr__nfet_01v8 L=0.5u W=1u
M18653 o7 ibias vss vss sky130_fd_pr__nfet_01v8 L=0.5u W=1u
M18654 o7 ibias vss vss sky130_fd_pr__nfet_01v8 L=0.5u W=1u
M18655 o7 ibias vss vss sky130_fd_pr__nfet_01v8 L=0.5u W=1u
M18656 o7 ibias vss vss sky130_fd_pr__nfet_01v8 L=0.5u W=1u
M18657 o7 ibias vss vss sky130_fd_pr__nfet_01v8 L=0.5u W=1u
M18658 o7 ibias vss vss sky130_fd_pr__nfet_01v8 L=0.5u W=1u
M18659 o7 ibias vss vss sky130_fd_pr__nfet_01v8 L=0.5u W=1u
M18660 o7 ibias vss vss sky130_fd_pr__nfet_01v8 L=0.5u W=1u
M18661 o7 ibias vss vss sky130_fd_pr__nfet_01v8 L=0.5u W=1u
M18662 o7 ibias vss vss sky130_fd_pr__nfet_01v8 L=0.5u W=1u
M18663 o7 ibias vss vss sky130_fd_pr__nfet_01v8 L=0.5u W=1u
M18664 o7 ibias vss vss sky130_fd_pr__nfet_01v8 L=0.5u W=1u
M18665 o7 ibias vss vss sky130_fd_pr__nfet_01v8 L=0.5u W=1u
M18666 o7 ibias vss vss sky130_fd_pr__nfet_01v8 L=0.5u W=1u
M18667 o7 ibias vss vss sky130_fd_pr__nfet_01v8 L=0.5u W=1u
M18668 o7 ibias vss vss sky130_fd_pr__nfet_01v8 L=0.5u W=1u
M18669 o7 ibias vss vss sky130_fd_pr__nfet_01v8 L=0.5u W=1u
M18670 o7 ibias vss vss sky130_fd_pr__nfet_01v8 L=0.5u W=1u
M18671 o7 ibias vss vss sky130_fd_pr__nfet_01v8 L=0.5u W=1u
M18672 o7 ibias vss vss sky130_fd_pr__nfet_01v8 L=0.5u W=1u
M18673 o7 ibias vss vss sky130_fd_pr__nfet_01v8 L=0.5u W=1u
M18674 o7 ibias vss vss sky130_fd_pr__nfet_01v8 L=0.5u W=1u
M18675 o7 ibias vss vss sky130_fd_pr__nfet_01v8 L=0.5u W=1u
M18676 o7 ibias vss vss sky130_fd_pr__nfet_01v8 L=0.5u W=1u
M18677 o7 ibias vss vss sky130_fd_pr__nfet_01v8 L=0.5u W=1u
M18678 o7 ibias vss vss sky130_fd_pr__nfet_01v8 L=0.5u W=1u
M18679 o7 ibias vss vss sky130_fd_pr__nfet_01v8 L=0.5u W=1u
M18680 o7 ibias vss vss sky130_fd_pr__nfet_01v8 L=0.5u W=1u
M18681 o7 ibias vss vss sky130_fd_pr__nfet_01v8 L=0.5u W=1u
M18682 o7 ibias vss vss sky130_fd_pr__nfet_01v8 L=0.5u W=1u
M18683 o7 ibias vss vss sky130_fd_pr__nfet_01v8 L=0.5u W=1u
M18684 o7 ibias vss vss sky130_fd_pr__nfet_01v8 L=0.5u W=1u
M18685 o7 ibias vss vss sky130_fd_pr__nfet_01v8 L=0.5u W=1u
M18686 o7 ibias vss vss sky130_fd_pr__nfet_01v8 L=0.5u W=1u
M18687 o7 ibias vss vss sky130_fd_pr__nfet_01v8 L=0.5u W=1u
M18688 o7 ibias vss vss sky130_fd_pr__nfet_01v8 L=0.5u W=1u
M18689 o7 ibias vss vss sky130_fd_pr__nfet_01v8 L=0.5u W=1u
M18690 o7 ibias vss vss sky130_fd_pr__nfet_01v8 L=0.5u W=1u
M18691 o7 ibias vss vss sky130_fd_pr__nfet_01v8 L=0.5u W=1u
M18692 o7 ibias vss vss sky130_fd_pr__nfet_01v8 L=0.5u W=1u
M18693 o7 ibias vss vss sky130_fd_pr__nfet_01v8 L=0.5u W=1u
M18694 o7 ibias vss vss sky130_fd_pr__nfet_01v8 L=0.5u W=1u
M18695 o7 ibias vss vss sky130_fd_pr__nfet_01v8 L=0.5u W=1u
M18696 o7 ibias vss vss sky130_fd_pr__nfet_01v8 L=0.5u W=1u
M18697 o7 ibias vss vss sky130_fd_pr__nfet_01v8 L=0.5u W=1u
M18698 o7 ibias vss vss sky130_fd_pr__nfet_01v8 L=0.5u W=1u
M18699 o7 ibias vss vss sky130_fd_pr__nfet_01v8 L=0.5u W=1u
M18700 o7 ibias vss vss sky130_fd_pr__nfet_01v8 L=0.5u W=1u
M18701 o7 ibias vss vss sky130_fd_pr__nfet_01v8 L=0.5u W=1u
M18702 o7 ibias vss vss sky130_fd_pr__nfet_01v8 L=0.5u W=1u
M18703 o7 ibias vss vss sky130_fd_pr__nfet_01v8 L=0.5u W=1u
M18704 o7 ibias vss vss sky130_fd_pr__nfet_01v8 L=0.5u W=1u
M18705 o7 ibias vss vss sky130_fd_pr__nfet_01v8 L=0.5u W=1u
M18706 o7 ibias vss vss sky130_fd_pr__nfet_01v8 L=0.5u W=1u
M18707 o7 ibias vss vss sky130_fd_pr__nfet_01v8 L=0.5u W=1u
M18708 o7 ibias vss vss sky130_fd_pr__nfet_01v8 L=0.5u W=1u
M18709 o7 ibias vss vss sky130_fd_pr__nfet_01v8 L=0.5u W=1u
M18710 o7 ibias vss vss sky130_fd_pr__nfet_01v8 L=0.5u W=1u
M18711 o7 ibias vss vss sky130_fd_pr__nfet_01v8 L=0.5u W=1u
M18712 o7 ibias vss vss sky130_fd_pr__nfet_01v8 L=0.5u W=1u
M18713 o7 ibias vss vss sky130_fd_pr__nfet_01v8 L=0.5u W=1u
M18714 o7 ibias vss vss sky130_fd_pr__nfet_01v8 L=0.5u W=1u
M18715 o7 ibias vss vss sky130_fd_pr__nfet_01v8 L=0.5u W=1u
M18716 o7 ibias vss vss sky130_fd_pr__nfet_01v8 L=0.5u W=1u
M18717 o7 ibias vss vss sky130_fd_pr__nfet_01v8 L=0.5u W=1u
M18718 o7 ibias vss vss sky130_fd_pr__nfet_01v8 L=0.5u W=1u
M18719 o7 ibias vss vss sky130_fd_pr__nfet_01v8 L=0.5u W=1u
M18720 o7 ibias vss vss sky130_fd_pr__nfet_01v8 L=0.5u W=1u
M18721 o7 ibias vss vss sky130_fd_pr__nfet_01v8 L=0.5u W=1u
M18722 o7 ibias vss vss sky130_fd_pr__nfet_01v8 L=0.5u W=1u
M18723 o7 ibias vss vss sky130_fd_pr__nfet_01v8 L=0.5u W=1u
M18724 o7 ibias vss vss sky130_fd_pr__nfet_01v8 L=0.5u W=1u
M18725 o7 ibias vss vss sky130_fd_pr__nfet_01v8 L=0.5u W=1u
M18726 o7 ibias vss vss sky130_fd_pr__nfet_01v8 L=0.5u W=1u
M18727 o7 ibias vss vss sky130_fd_pr__nfet_01v8 L=0.5u W=1u
M18728 o7 ibias vss vss sky130_fd_pr__nfet_01v8 L=0.5u W=1u
M18729 o7 ibias vss vss sky130_fd_pr__nfet_01v8 L=0.5u W=1u
M18730 o7 ibias vss vss sky130_fd_pr__nfet_01v8 L=0.5u W=1u
M18731 o7 ibias vss vss sky130_fd_pr__nfet_01v8 L=0.5u W=1u
M18732 o7 ibias vss vss sky130_fd_pr__nfet_01v8 L=0.5u W=1u
M18733 o7 ibias vss vss sky130_fd_pr__nfet_01v8 L=0.5u W=1u
M18734 o7 ibias vss vss sky130_fd_pr__nfet_01v8 L=0.5u W=1u
M18735 o7 ibias vss vss sky130_fd_pr__nfet_01v8 L=0.5u W=1u
M18736 o7 ibias vss vss sky130_fd_pr__nfet_01v8 L=0.5u W=1u
M18737 o7 ibias vss vss sky130_fd_pr__nfet_01v8 L=0.5u W=1u
M18738 o7 ibias vss vss sky130_fd_pr__nfet_01v8 L=0.5u W=1u
M18739 o7 ibias vss vss sky130_fd_pr__nfet_01v8 L=0.5u W=1u
M18740 o7 ibias vss vss sky130_fd_pr__nfet_01v8 L=0.5u W=1u
M18741 o7 ibias vss vss sky130_fd_pr__nfet_01v8 L=0.5u W=1u
M18742 o7 ibias vss vss sky130_fd_pr__nfet_01v8 L=0.5u W=1u
M18743 o7 ibias vss vss sky130_fd_pr__nfet_01v8 L=0.5u W=1u
M18744 o7 ibias vss vss sky130_fd_pr__nfet_01v8 L=0.5u W=1u
M18745 o7 ibias vss vss sky130_fd_pr__nfet_01v8 L=0.5u W=1u
M18746 o7 ibias vss vss sky130_fd_pr__nfet_01v8 L=0.5u W=1u
M18747 o7 ibias vss vss sky130_fd_pr__nfet_01v8 L=0.5u W=1u
M18748 o7 ibias vss vss sky130_fd_pr__nfet_01v8 L=0.5u W=1u
M18749 o7 ibias vss vss sky130_fd_pr__nfet_01v8 L=0.5u W=1u
M18750 o7 ibias vss vss sky130_fd_pr__nfet_01v8 L=0.5u W=1u
M18751 o7 ibias vss vss sky130_fd_pr__nfet_01v8 L=0.5u W=1u
M18752 o7 ibias vss vss sky130_fd_pr__nfet_01v8 L=0.5u W=1u
M18753 o7 ibias vss vss sky130_fd_pr__nfet_01v8 L=0.5u W=1u
M18754 o7 ibias vss vss sky130_fd_pr__nfet_01v8 L=0.5u W=1u
M18755 o7 ibias vss vss sky130_fd_pr__nfet_01v8 L=0.5u W=1u
M18756 o7 ibias vss vss sky130_fd_pr__nfet_01v8 L=0.5u W=1u
M18757 o7 ibias vss vss sky130_fd_pr__nfet_01v8 L=0.5u W=1u
M18758 o7 ibias vss vss sky130_fd_pr__nfet_01v8 L=0.5u W=1u
M18759 o7 ibias vss vss sky130_fd_pr__nfet_01v8 L=0.5u W=1u
M18760 o7 ibias vss vss sky130_fd_pr__nfet_01v8 L=0.5u W=1u
M18761 o7 ibias vss vss sky130_fd_pr__nfet_01v8 L=0.5u W=1u
M18762 o7 ibias vss vss sky130_fd_pr__nfet_01v8 L=0.5u W=1u
M18763 o7 ibias vss vss sky130_fd_pr__nfet_01v8 L=0.5u W=1u
M18764 o7 ibias vss vss sky130_fd_pr__nfet_01v8 L=0.5u W=1u
M18765 o7 ibias vss vss sky130_fd_pr__nfet_01v8 L=0.5u W=1u
M18766 o7 ibias vss vss sky130_fd_pr__nfet_01v8 L=0.5u W=1u
M18767 o7 ibias vss vss sky130_fd_pr__nfet_01v8 L=0.5u W=1u
M18768 o7 ibias vss vss sky130_fd_pr__nfet_01v8 L=0.5u W=1u
M18769 o7 ibias vss vss sky130_fd_pr__nfet_01v8 L=0.5u W=1u
M18770 o7 ibias vss vss sky130_fd_pr__nfet_01v8 L=0.5u W=1u
M18771 o7 ibias vss vss sky130_fd_pr__nfet_01v8 L=0.5u W=1u
M18772 o7 ibias vss vss sky130_fd_pr__nfet_01v8 L=0.5u W=1u
M18773 o7 ibias vss vss sky130_fd_pr__nfet_01v8 L=0.5u W=1u
M18774 o7 ibias vss vss sky130_fd_pr__nfet_01v8 L=0.5u W=1u
M18775 o7 ibias vss vss sky130_fd_pr__nfet_01v8 L=0.5u W=1u
M18776 o7 ibias vss vss sky130_fd_pr__nfet_01v8 L=0.5u W=1u
M18777 o7 ibias vss vss sky130_fd_pr__nfet_01v8 L=0.5u W=1u
M18778 o7 ibias vss vss sky130_fd_pr__nfet_01v8 L=0.5u W=1u
M18779 o7 ibias vss vss sky130_fd_pr__nfet_01v8 L=0.5u W=1u
M18780 o7 ibias vss vss sky130_fd_pr__nfet_01v8 L=0.5u W=1u
M18781 o7 ibias vss vss sky130_fd_pr__nfet_01v8 L=0.5u W=1u
M18782 o7 ibias vss vss sky130_fd_pr__nfet_01v8 L=0.5u W=1u
M18783 o7 ibias vss vss sky130_fd_pr__nfet_01v8 L=0.5u W=1u
M18784 o7 ibias vss vss sky130_fd_pr__nfet_01v8 L=0.5u W=1u
M18785 o7 ibias vss vss sky130_fd_pr__nfet_01v8 L=0.5u W=1u
M18786 o7 ibias vss vss sky130_fd_pr__nfet_01v8 L=0.5u W=1u
M18787 o7 ibias vss vss sky130_fd_pr__nfet_01v8 L=0.5u W=1u
M18788 o7 ibias vss vss sky130_fd_pr__nfet_01v8 L=0.5u W=1u
M18789 o7 ibias vss vss sky130_fd_pr__nfet_01v8 L=0.5u W=1u
M18790 o7 ibias vss vss sky130_fd_pr__nfet_01v8 L=0.5u W=1u
M18791 o7 ibias vss vss sky130_fd_pr__nfet_01v8 L=0.5u W=1u
M18792 o7 ibias vss vss sky130_fd_pr__nfet_01v8 L=0.5u W=1u
M18793 o7 ibias vss vss sky130_fd_pr__nfet_01v8 L=0.5u W=1u
M18794 o7 ibias vss vss sky130_fd_pr__nfet_01v8 L=0.5u W=1u
M18795 o7 ibias vss vss sky130_fd_pr__nfet_01v8 L=0.5u W=1u
M18796 o7 ibias vss vss sky130_fd_pr__nfet_01v8 L=0.5u W=1u
M18797 o7 ibias vss vss sky130_fd_pr__nfet_01v8 L=0.5u W=1u
M18798 o7 ibias vss vss sky130_fd_pr__nfet_01v8 L=0.5u W=1u
M18799 o7 ibias vss vss sky130_fd_pr__nfet_01v8 L=0.5u W=1u
M18800 o7 ibias vss vss sky130_fd_pr__nfet_01v8 L=0.5u W=1u
M18801 o7 ibias vss vss sky130_fd_pr__nfet_01v8 L=0.5u W=1u
M18802 o7 ibias vss vss sky130_fd_pr__nfet_01v8 L=0.5u W=1u
M18803 o7 ibias vss vss sky130_fd_pr__nfet_01v8 L=0.5u W=1u
M18804 o7 ibias vss vss sky130_fd_pr__nfet_01v8 L=0.5u W=1u
M18805 o7 ibias vss vss sky130_fd_pr__nfet_01v8 L=0.5u W=1u
M18806 o7 ibias vss vss sky130_fd_pr__nfet_01v8 L=0.5u W=1u
M18807 o7 ibias vss vss sky130_fd_pr__nfet_01v8 L=0.5u W=1u
M18808 o7 ibias vss vss sky130_fd_pr__nfet_01v8 L=0.5u W=1u
M18809 o7 ibias vss vss sky130_fd_pr__nfet_01v8 L=0.5u W=1u
M18810 o7 ibias vss vss sky130_fd_pr__nfet_01v8 L=0.5u W=1u
M18811 o7 ibias vss vss sky130_fd_pr__nfet_01v8 L=0.5u W=1u
M18812 o7 ibias vss vss sky130_fd_pr__nfet_01v8 L=0.5u W=1u
M18813 o7 ibias vss vss sky130_fd_pr__nfet_01v8 L=0.5u W=1u
M18814 o7 ibias vss vss sky130_fd_pr__nfet_01v8 L=0.5u W=1u
M18815 o7 ibias vss vss sky130_fd_pr__nfet_01v8 L=0.5u W=1u
M18816 o7 ibias vss vss sky130_fd_pr__nfet_01v8 L=0.5u W=1u
M18817 o7 ibias vss vss sky130_fd_pr__nfet_01v8 L=0.5u W=1u
M18818 o7 ibias vss vss sky130_fd_pr__nfet_01v8 L=0.5u W=1u
M18819 o7 ibias vss vss sky130_fd_pr__nfet_01v8 L=0.5u W=1u
M18820 o7 ibias vss vss sky130_fd_pr__nfet_01v8 L=0.5u W=1u
M18821 o7 ibias vss vss sky130_fd_pr__nfet_01v8 L=0.5u W=1u
M18822 o7 ibias vss vss sky130_fd_pr__nfet_01v8 L=0.5u W=1u
M18823 o7 ibias vss vss sky130_fd_pr__nfet_01v8 L=0.5u W=1u
M18824 o7 ibias vss vss sky130_fd_pr__nfet_01v8 L=0.5u W=1u
M18825 o7 ibias vss vss sky130_fd_pr__nfet_01v8 L=0.5u W=1u
M18826 o7 ibias vss vss sky130_fd_pr__nfet_01v8 L=0.5u W=1u
M18827 o7 ibias vss vss sky130_fd_pr__nfet_01v8 L=0.5u W=1u
M18828 o7 ibias vss vss sky130_fd_pr__nfet_01v8 L=0.5u W=1u
M18829 o7 ibias vss vss sky130_fd_pr__nfet_01v8 L=0.5u W=1u
M18830 o7 ibias vss vss sky130_fd_pr__nfet_01v8 L=0.5u W=1u
M18831 o7 ibias vss vss sky130_fd_pr__nfet_01v8 L=0.5u W=1u
M18832 o7 ibias vss vss sky130_fd_pr__nfet_01v8 L=0.5u W=1u
M18833 o7 ibias vss vss sky130_fd_pr__nfet_01v8 L=0.5u W=1u
M18834 o7 ibias vss vss sky130_fd_pr__nfet_01v8 L=0.5u W=1u
M18835 o7 ibias vss vss sky130_fd_pr__nfet_01v8 L=0.5u W=1u
M18836 o7 ibias vss vss sky130_fd_pr__nfet_01v8 L=0.5u W=1u
M18837 o7 ibias vss vss sky130_fd_pr__nfet_01v8 L=0.5u W=1u
M18838 o7 ibias vss vss sky130_fd_pr__nfet_01v8 L=0.5u W=1u
M18839 o7 ibias vss vss sky130_fd_pr__nfet_01v8 L=0.5u W=1u
M18840 o7 ibias vss vss sky130_fd_pr__nfet_01v8 L=0.5u W=1u
M18841 o7 ibias vss vss sky130_fd_pr__nfet_01v8 L=0.5u W=1u
M18842 o7 ibias vss vss sky130_fd_pr__nfet_01v8 L=0.5u W=1u
M18843 o7 ibias vss vss sky130_fd_pr__nfet_01v8 L=0.5u W=1u
M18844 o7 ibias vss vss sky130_fd_pr__nfet_01v8 L=0.5u W=1u
M18845 o7 ibias vss vss sky130_fd_pr__nfet_01v8 L=0.5u W=1u
M18846 o7 ibias vss vss sky130_fd_pr__nfet_01v8 L=0.5u W=1u
M18847 o7 ibias vss vss sky130_fd_pr__nfet_01v8 L=0.5u W=1u
M18848 o7 ibias vss vss sky130_fd_pr__nfet_01v8 L=0.5u W=1u
M18849 o7 ibias vss vss sky130_fd_pr__nfet_01v8 L=0.5u W=1u
M18850 o7 ibias vss vss sky130_fd_pr__nfet_01v8 L=0.5u W=1u
M18851 o7 ibias vss vss sky130_fd_pr__nfet_01v8 L=0.5u W=1u
M18852 o7 ibias vss vss sky130_fd_pr__nfet_01v8 L=0.5u W=1u
M18853 o7 ibias vss vss sky130_fd_pr__nfet_01v8 L=0.5u W=1u
M18854 o7 ibias vss vss sky130_fd_pr__nfet_01v8 L=0.5u W=1u
M18855 o7 ibias vss vss sky130_fd_pr__nfet_01v8 L=0.5u W=1u
M18856 o7 ibias vss vss sky130_fd_pr__nfet_01v8 L=0.5u W=1u
M18857 o7 ibias vss vss sky130_fd_pr__nfet_01v8 L=0.5u W=1u
M18858 o7 ibias vss vss sky130_fd_pr__nfet_01v8 L=0.5u W=1u
M18859 o7 ibias vss vss sky130_fd_pr__nfet_01v8 L=0.5u W=1u
M18860 o7 ibias vss vss sky130_fd_pr__nfet_01v8 L=0.5u W=1u
M18861 o7 ibias vss vss sky130_fd_pr__nfet_01v8 L=0.5u W=1u
M18862 o7 ibias vss vss sky130_fd_pr__nfet_01v8 L=0.5u W=1u
M18863 o7 ibias vss vss sky130_fd_pr__nfet_01v8 L=0.5u W=1u
M18864 o7 ibias vss vss sky130_fd_pr__nfet_01v8 L=0.5u W=1u
M18865 o7 ibias vss vss sky130_fd_pr__nfet_01v8 L=0.5u W=1u
M18866 o7 ibias vss vss sky130_fd_pr__nfet_01v8 L=0.5u W=1u
M18867 o7 ibias vss vss sky130_fd_pr__nfet_01v8 L=0.5u W=1u
M18868 o7 ibias vss vss sky130_fd_pr__nfet_01v8 L=0.5u W=1u
M18869 o7 ibias vss vss sky130_fd_pr__nfet_01v8 L=0.5u W=1u
M18870 o7 ibias vss vss sky130_fd_pr__nfet_01v8 L=0.5u W=1u
M18871 o7 ibias vss vss sky130_fd_pr__nfet_01v8 L=0.5u W=1u
M18872 o7 ibias vss vss sky130_fd_pr__nfet_01v8 L=0.5u W=1u
M18873 o7 ibias vss vss sky130_fd_pr__nfet_01v8 L=0.5u W=1u
M18874 o7 ibias vss vss sky130_fd_pr__nfet_01v8 L=0.5u W=1u
M18875 o7 ibias vss vss sky130_fd_pr__nfet_01v8 L=0.5u W=1u
M18876 o7 ibias vss vss sky130_fd_pr__nfet_01v8 L=0.5u W=1u
M18877 o7 ibias vss vss sky130_fd_pr__nfet_01v8 L=0.5u W=1u
M18878 o7 ibias vss vss sky130_fd_pr__nfet_01v8 L=0.5u W=1u
M18879 o7 ibias vss vss sky130_fd_pr__nfet_01v8 L=0.5u W=1u
M18880 o7 ibias vss vss sky130_fd_pr__nfet_01v8 L=0.5u W=1u
M18881 o7 ibias vss vss sky130_fd_pr__nfet_01v8 L=0.5u W=1u
M18882 o7 ibias vss vss sky130_fd_pr__nfet_01v8 L=0.5u W=1u
M18883 o7 ibias vss vss sky130_fd_pr__nfet_01v8 L=0.5u W=1u
M18884 o7 ibias vss vss sky130_fd_pr__nfet_01v8 L=0.5u W=1u
M18885 o7 ibias vss vss sky130_fd_pr__nfet_01v8 L=0.5u W=1u
M18886 o7 ibias vss vss sky130_fd_pr__nfet_01v8 L=0.5u W=1u
M18887 o7 ibias vss vss sky130_fd_pr__nfet_01v8 L=0.5u W=1u
M18888 o7 ibias vss vss sky130_fd_pr__nfet_01v8 L=0.5u W=1u
M18889 o7 ibias vss vss sky130_fd_pr__nfet_01v8 L=0.5u W=1u
M18890 o7 ibias vss vss sky130_fd_pr__nfet_01v8 L=0.5u W=1u
M18891 o7 ibias vss vss sky130_fd_pr__nfet_01v8 L=0.5u W=1u
M18892 o7 ibias vss vss sky130_fd_pr__nfet_01v8 L=0.5u W=1u
M18893 o7 ibias vss vss sky130_fd_pr__nfet_01v8 L=0.5u W=1u
M18894 o7 ibias vss vss sky130_fd_pr__nfet_01v8 L=0.5u W=1u
M18895 o7 ibias vss vss sky130_fd_pr__nfet_01v8 L=0.5u W=1u
M18896 o7 ibias vss vss sky130_fd_pr__nfet_01v8 L=0.5u W=1u
M18897 o7 ibias vss vss sky130_fd_pr__nfet_01v8 L=0.5u W=1u
M18898 o7 ibias vss vss sky130_fd_pr__nfet_01v8 L=0.5u W=1u
M18899 o7 ibias vss vss sky130_fd_pr__nfet_01v8 L=0.5u W=1u
M18900 o7 ibias vss vss sky130_fd_pr__nfet_01v8 L=0.5u W=1u
M18901 o7 ibias vss vss sky130_fd_pr__nfet_01v8 L=0.5u W=1u
M18902 o7 ibias vss vss sky130_fd_pr__nfet_01v8 L=0.5u W=1u
M18903 o7 ibias vss vss sky130_fd_pr__nfet_01v8 L=0.5u W=1u
M18904 o7 ibias vss vss sky130_fd_pr__nfet_01v8 L=0.5u W=1u
M18905 o7 ibias vss vss sky130_fd_pr__nfet_01v8 L=0.5u W=1u
M18906 o7 ibias vss vss sky130_fd_pr__nfet_01v8 L=0.5u W=1u
M18907 o7 ibias vss vss sky130_fd_pr__nfet_01v8 L=0.5u W=1u
M18908 o7 ibias vss vss sky130_fd_pr__nfet_01v8 L=0.5u W=1u
M18909 o7 ibias vss vss sky130_fd_pr__nfet_01v8 L=0.5u W=1u
M18910 o7 ibias vss vss sky130_fd_pr__nfet_01v8 L=0.5u W=1u
M18911 o7 ibias vss vss sky130_fd_pr__nfet_01v8 L=0.5u W=1u
M18912 o7 ibias vss vss sky130_fd_pr__nfet_01v8 L=0.5u W=1u
M18913 o7 ibias vss vss sky130_fd_pr__nfet_01v8 L=0.5u W=1u
M18914 o7 ibias vss vss sky130_fd_pr__nfet_01v8 L=0.5u W=1u
M18915 o7 ibias vss vss sky130_fd_pr__nfet_01v8 L=0.5u W=1u
M18916 o7 ibias vss vss sky130_fd_pr__nfet_01v8 L=0.5u W=1u
M18917 o7 ibias vss vss sky130_fd_pr__nfet_01v8 L=0.5u W=1u
M18918 o7 ibias vss vss sky130_fd_pr__nfet_01v8 L=0.5u W=1u
M18919 o7 ibias vss vss sky130_fd_pr__nfet_01v8 L=0.5u W=1u
M18920 o7 ibias vss vss sky130_fd_pr__nfet_01v8 L=0.5u W=1u
M18921 o7 ibias vss vss sky130_fd_pr__nfet_01v8 L=0.5u W=1u
M18922 o7 ibias vss vss sky130_fd_pr__nfet_01v8 L=0.5u W=1u
M18923 o7 ibias vss vss sky130_fd_pr__nfet_01v8 L=0.5u W=1u
M18924 o7 ibias vss vss sky130_fd_pr__nfet_01v8 L=0.5u W=1u
M18925 o7 ibias vss vss sky130_fd_pr__nfet_01v8 L=0.5u W=1u
M18926 o7 ibias vss vss sky130_fd_pr__nfet_01v8 L=0.5u W=1u
M18927 o7 ibias vss vss sky130_fd_pr__nfet_01v8 L=0.5u W=1u
M18928 o7 ibias vss vss sky130_fd_pr__nfet_01v8 L=0.5u W=1u
M18929 o7 ibias vss vss sky130_fd_pr__nfet_01v8 L=0.5u W=1u
M18930 o7 ibias vss vss sky130_fd_pr__nfet_01v8 L=0.5u W=1u
M18931 o7 ibias vss vss sky130_fd_pr__nfet_01v8 L=0.5u W=1u
M18932 o7 ibias vss vss sky130_fd_pr__nfet_01v8 L=0.5u W=1u
M18933 o7 ibias vss vss sky130_fd_pr__nfet_01v8 L=0.5u W=1u
M18934 o7 ibias vss vss sky130_fd_pr__nfet_01v8 L=0.5u W=1u
M18935 o7 ibias vss vss sky130_fd_pr__nfet_01v8 L=0.5u W=1u
M18936 o7 ibias vss vss sky130_fd_pr__nfet_01v8 L=0.5u W=1u
M18937 o7 ibias vss vss sky130_fd_pr__nfet_01v8 L=0.5u W=1u
M18938 o7 ibias vss vss sky130_fd_pr__nfet_01v8 L=0.5u W=1u
M18939 o7 ibias vss vss sky130_fd_pr__nfet_01v8 L=0.5u W=1u
M18940 o7 ibias vss vss sky130_fd_pr__nfet_01v8 L=0.5u W=1u
M18941 o7 ibias vss vss sky130_fd_pr__nfet_01v8 L=0.5u W=1u
M18942 o7 ibias vss vss sky130_fd_pr__nfet_01v8 L=0.5u W=1u
M18943 o7 ibias vss vss sky130_fd_pr__nfet_01v8 L=0.5u W=1u
M18944 o7 ibias vss vss sky130_fd_pr__nfet_01v8 L=0.5u W=1u
M18945 o7 ibias vss vss sky130_fd_pr__nfet_01v8 L=0.5u W=1u
M18946 o7 ibias vss vss sky130_fd_pr__nfet_01v8 L=0.5u W=1u
M18947 o7 ibias vss vss sky130_fd_pr__nfet_01v8 L=0.5u W=1u
M18948 o7 ibias vss vss sky130_fd_pr__nfet_01v8 L=0.5u W=1u
M18949 o7 ibias vss vss sky130_fd_pr__nfet_01v8 L=0.5u W=1u
M18950 o7 ibias vss vss sky130_fd_pr__nfet_01v8 L=0.5u W=1u
M18951 o7 ibias vss vss sky130_fd_pr__nfet_01v8 L=0.5u W=1u
M18952 o7 ibias vss vss sky130_fd_pr__nfet_01v8 L=0.5u W=1u
M18953 o7 ibias vss vss sky130_fd_pr__nfet_01v8 L=0.5u W=1u
M18954 o7 ibias vss vss sky130_fd_pr__nfet_01v8 L=0.5u W=1u
M18955 o7 ibias vss vss sky130_fd_pr__nfet_01v8 L=0.5u W=1u
M18956 o7 ibias vss vss sky130_fd_pr__nfet_01v8 L=0.5u W=1u
M18957 o7 ibias vss vss sky130_fd_pr__nfet_01v8 L=0.5u W=1u
M18958 o7 ibias vss vss sky130_fd_pr__nfet_01v8 L=0.5u W=1u
M18959 o7 ibias vss vss sky130_fd_pr__nfet_01v8 L=0.5u W=1u
M18960 o7 ibias vss vss sky130_fd_pr__nfet_01v8 L=0.5u W=1u
M18961 o7 ibias vss vss sky130_fd_pr__nfet_01v8 L=0.5u W=1u
M18962 o7 ibias vss vss sky130_fd_pr__nfet_01v8 L=0.5u W=1u
M18963 o7 ibias vss vss sky130_fd_pr__nfet_01v8 L=0.5u W=1u
M18964 o7 ibias vss vss sky130_fd_pr__nfet_01v8 L=0.5u W=1u
M18965 o7 ibias vss vss sky130_fd_pr__nfet_01v8 L=0.5u W=1u
M18966 o7 ibias vss vss sky130_fd_pr__nfet_01v8 L=0.5u W=1u
M18967 o7 ibias vss vss sky130_fd_pr__nfet_01v8 L=0.5u W=1u
M18968 o7 ibias vss vss sky130_fd_pr__nfet_01v8 L=0.5u W=1u
M18969 o7 ibias vss vss sky130_fd_pr__nfet_01v8 L=0.5u W=1u
M18970 o7 ibias vss vss sky130_fd_pr__nfet_01v8 L=0.5u W=1u
M18971 o7 ibias vss vss sky130_fd_pr__nfet_01v8 L=0.5u W=1u
M18972 o7 ibias vss vss sky130_fd_pr__nfet_01v8 L=0.5u W=1u
M18973 o7 ibias vss vss sky130_fd_pr__nfet_01v8 L=0.5u W=1u
M18974 o7 ibias vss vss sky130_fd_pr__nfet_01v8 L=0.5u W=1u
M18975 o7 ibias vss vss sky130_fd_pr__nfet_01v8 L=0.5u W=1u
M18976 o7 ibias vss vss sky130_fd_pr__nfet_01v8 L=0.5u W=1u
M18977 o7 ibias vss vss sky130_fd_pr__nfet_01v8 L=0.5u W=1u
M18978 o7 ibias vss vss sky130_fd_pr__nfet_01v8 L=0.5u W=1u
M18979 o7 ibias vss vss sky130_fd_pr__nfet_01v8 L=0.5u W=1u
M18980 o7 ibias vss vss sky130_fd_pr__nfet_01v8 L=0.5u W=1u
M18981 o7 ibias vss vss sky130_fd_pr__nfet_01v8 L=0.5u W=1u
M18982 o7 ibias vss vss sky130_fd_pr__nfet_01v8 L=0.5u W=1u
M18983 o7 ibias vss vss sky130_fd_pr__nfet_01v8 L=0.5u W=1u
M18984 o7 ibias vss vss sky130_fd_pr__nfet_01v8 L=0.5u W=1u
M18985 o7 ibias vss vss sky130_fd_pr__nfet_01v8 L=0.5u W=1u
M18986 o7 ibias vss vss sky130_fd_pr__nfet_01v8 L=0.5u W=1u
M18987 o7 ibias vss vss sky130_fd_pr__nfet_01v8 L=0.5u W=1u
M18988 o7 ibias vss vss sky130_fd_pr__nfet_01v8 L=0.5u W=1u
M18989 o7 ibias vss vss sky130_fd_pr__nfet_01v8 L=0.5u W=1u
M18990 o7 ibias vss vss sky130_fd_pr__nfet_01v8 L=0.5u W=1u
M18991 o7 ibias vss vss sky130_fd_pr__nfet_01v8 L=0.5u W=1u
M18992 o7 ibias vss vss sky130_fd_pr__nfet_01v8 L=0.5u W=1u
M18993 o7 ibias vss vss sky130_fd_pr__nfet_01v8 L=0.5u W=1u
M18994 o7 ibias vss vss sky130_fd_pr__nfet_01v8 L=0.5u W=1u
M18995 o7 ibias vss vss sky130_fd_pr__nfet_01v8 L=0.5u W=1u
M18996 o7 ibias vss vss sky130_fd_pr__nfet_01v8 L=0.5u W=1u
M18997 o7 ibias vss vss sky130_fd_pr__nfet_01v8 L=0.5u W=1u
M18998 o7 ibias vss vss sky130_fd_pr__nfet_01v8 L=0.5u W=1u
M18999 o7 ibias vss vss sky130_fd_pr__nfet_01v8 L=0.5u W=1u
M19000 o7 ibias vss vss sky130_fd_pr__nfet_01v8 L=0.5u W=1u
M19001 o7 ibias vss vss sky130_fd_pr__nfet_01v8 L=0.5u W=1u
M19002 o7 ibias vss vss sky130_fd_pr__nfet_01v8 L=0.5u W=1u
M19003 o7 ibias vss vss sky130_fd_pr__nfet_01v8 L=0.5u W=1u
M19004 o7 ibias vss vss sky130_fd_pr__nfet_01v8 L=0.5u W=1u
M19005 o7 ibias vss vss sky130_fd_pr__nfet_01v8 L=0.5u W=1u
M19006 o7 ibias vss vss sky130_fd_pr__nfet_01v8 L=0.5u W=1u
M19007 o7 ibias vss vss sky130_fd_pr__nfet_01v8 L=0.5u W=1u
M19008 o7 ibias vss vss sky130_fd_pr__nfet_01v8 L=0.5u W=1u
M19009 o7 ibias vss vss sky130_fd_pr__nfet_01v8 L=0.5u W=1u
M19010 o7 ibias vss vss sky130_fd_pr__nfet_01v8 L=0.5u W=1u
M19011 o7 ibias vss vss sky130_fd_pr__nfet_01v8 L=0.5u W=1u
M19012 o7 ibias vss vss sky130_fd_pr__nfet_01v8 L=0.5u W=1u
M19013 o7 ibias vss vss sky130_fd_pr__nfet_01v8 L=0.5u W=1u
M19014 o7 ibias vss vss sky130_fd_pr__nfet_01v8 L=0.5u W=1u
M19015 o7 ibias vss vss sky130_fd_pr__nfet_01v8 L=0.5u W=1u
M19016 o7 ibias vss vss sky130_fd_pr__nfet_01v8 L=0.5u W=1u
M19017 o7 ibias vss vss sky130_fd_pr__nfet_01v8 L=0.5u W=1u
M19018 o7 ibias vss vss sky130_fd_pr__nfet_01v8 L=0.5u W=1u
M19019 o7 ibias vss vss sky130_fd_pr__nfet_01v8 L=0.5u W=1u
M19020 o7 ibias vss vss sky130_fd_pr__nfet_01v8 L=0.5u W=1u
M19021 o7 ibias vss vss sky130_fd_pr__nfet_01v8 L=0.5u W=1u
M19022 o7 ibias vss vss sky130_fd_pr__nfet_01v8 L=0.5u W=1u
M19023 o7 ibias vss vss sky130_fd_pr__nfet_01v8 L=0.5u W=1u
M19024 o7 ibias vss vss sky130_fd_pr__nfet_01v8 L=0.5u W=1u
M19025 o7 ibias vss vss sky130_fd_pr__nfet_01v8 L=0.5u W=1u
M19026 o7 ibias vss vss sky130_fd_pr__nfet_01v8 L=0.5u W=1u
M19027 o7 ibias vss vss sky130_fd_pr__nfet_01v8 L=0.5u W=1u
M19028 o7 ibias vss vss sky130_fd_pr__nfet_01v8 L=0.5u W=1u
M19029 o7 ibias vss vss sky130_fd_pr__nfet_01v8 L=0.5u W=1u
M19030 o7 ibias vss vss sky130_fd_pr__nfet_01v8 L=0.5u W=1u
M19031 o7 ibias vss vss sky130_fd_pr__nfet_01v8 L=0.5u W=1u
M19032 o7 ibias vss vss sky130_fd_pr__nfet_01v8 L=0.5u W=1u
M19033 o7 ibias vss vss sky130_fd_pr__nfet_01v8 L=0.5u W=1u
M19034 o7 ibias vss vss sky130_fd_pr__nfet_01v8 L=0.5u W=1u
M19035 o7 ibias vss vss sky130_fd_pr__nfet_01v8 L=0.5u W=1u
M19036 o7 ibias vss vss sky130_fd_pr__nfet_01v8 L=0.5u W=1u
M19037 o7 ibias vss vss sky130_fd_pr__nfet_01v8 L=0.5u W=1u
M19038 o7 ibias vss vss sky130_fd_pr__nfet_01v8 L=0.5u W=1u
M19039 o7 ibias vss vss sky130_fd_pr__nfet_01v8 L=0.5u W=1u
M19040 o7 ibias vss vss sky130_fd_pr__nfet_01v8 L=0.5u W=1u
M19041 o7 ibias vss vss sky130_fd_pr__nfet_01v8 L=0.5u W=1u
M19042 o7 ibias vss vss sky130_fd_pr__nfet_01v8 L=0.5u W=1u
M19043 o7 ibias vss vss sky130_fd_pr__nfet_01v8 L=0.5u W=1u
M19044 o7 ibias vss vss sky130_fd_pr__nfet_01v8 L=0.5u W=1u
M19045 o7 ibias vss vss sky130_fd_pr__nfet_01v8 L=0.5u W=1u
M19046 o7 ibias vss vss sky130_fd_pr__nfet_01v8 L=0.5u W=1u
M19047 o7 ibias vss vss sky130_fd_pr__nfet_01v8 L=0.5u W=1u
M19048 o7 ibias vss vss sky130_fd_pr__nfet_01v8 L=0.5u W=1u
M19049 o7 ibias vss vss sky130_fd_pr__nfet_01v8 L=0.5u W=1u
M19050 o7 ibias vss vss sky130_fd_pr__nfet_01v8 L=0.5u W=1u
M19051 o7 ibias vss vss sky130_fd_pr__nfet_01v8 L=0.5u W=1u
M19052 o7 ibias vss vss sky130_fd_pr__nfet_01v8 L=0.5u W=1u
M19053 o7 ibias vss vss sky130_fd_pr__nfet_01v8 L=0.5u W=1u
M19054 o7 ibias vss vss sky130_fd_pr__nfet_01v8 L=0.5u W=1u
M19055 o7 ibias vss vss sky130_fd_pr__nfet_01v8 L=0.5u W=1u
M19056 o7 ibias vss vss sky130_fd_pr__nfet_01v8 L=0.5u W=1u
M19057 o7 ibias vss vss sky130_fd_pr__nfet_01v8 L=0.5u W=1u
M19058 o7 ibias vss vss sky130_fd_pr__nfet_01v8 L=0.5u W=1u
M19059 o7 ibias vss vss sky130_fd_pr__nfet_01v8 L=0.5u W=1u
M19060 o7 ibias vss vss sky130_fd_pr__nfet_01v8 L=0.5u W=1u
M19061 o7 ibias vss vss sky130_fd_pr__nfet_01v8 L=0.5u W=1u
M19062 o7 ibias vss vss sky130_fd_pr__nfet_01v8 L=0.5u W=1u
M19063 o7 ibias vss vss sky130_fd_pr__nfet_01v8 L=0.5u W=1u
M19064 o7 ibias vss vss sky130_fd_pr__nfet_01v8 L=0.5u W=1u
M19065 o7 ibias vss vss sky130_fd_pr__nfet_01v8 L=0.5u W=1u
M19066 o7 ibias vss vss sky130_fd_pr__nfet_01v8 L=0.5u W=1u
M19067 o7 ibias vss vss sky130_fd_pr__nfet_01v8 L=0.5u W=1u
M19068 o7 ibias vss vss sky130_fd_pr__nfet_01v8 L=0.5u W=1u
M19069 o7 ibias vss vss sky130_fd_pr__nfet_01v8 L=0.5u W=1u
M19070 o7 ibias vss vss sky130_fd_pr__nfet_01v8 L=0.5u W=1u
M19071 o7 ibias vss vss sky130_fd_pr__nfet_01v8 L=0.5u W=1u
M19072 o7 ibias vss vss sky130_fd_pr__nfet_01v8 L=0.5u W=1u
M19073 o7 ibias vss vss sky130_fd_pr__nfet_01v8 L=0.5u W=1u
M19074 o7 ibias vss vss sky130_fd_pr__nfet_01v8 L=0.5u W=1u
M19075 o7 ibias vss vss sky130_fd_pr__nfet_01v8 L=0.5u W=1u
M19076 o7 ibias vss vss sky130_fd_pr__nfet_01v8 L=0.5u W=1u
M19077 o7 ibias vss vss sky130_fd_pr__nfet_01v8 L=0.5u W=1u
M19078 o7 ibias vss vss sky130_fd_pr__nfet_01v8 L=0.5u W=1u
M19079 o7 ibias vss vss sky130_fd_pr__nfet_01v8 L=0.5u W=1u
M19080 o7 ibias vss vss sky130_fd_pr__nfet_01v8 L=0.5u W=1u
M19081 o7 ibias vss vss sky130_fd_pr__nfet_01v8 L=0.5u W=1u
M19082 o7 ibias vss vss sky130_fd_pr__nfet_01v8 L=0.5u W=1u
M19083 o7 ibias vss vss sky130_fd_pr__nfet_01v8 L=0.5u W=1u
M19084 o7 ibias vss vss sky130_fd_pr__nfet_01v8 L=0.5u W=1u
M19085 o7 ibias vss vss sky130_fd_pr__nfet_01v8 L=0.5u W=1u
M19086 o7 ibias vss vss sky130_fd_pr__nfet_01v8 L=0.5u W=1u
M19087 o7 ibias vss vss sky130_fd_pr__nfet_01v8 L=0.5u W=1u
M19088 o7 ibias vss vss sky130_fd_pr__nfet_01v8 L=0.5u W=1u
M19089 o7 ibias vss vss sky130_fd_pr__nfet_01v8 L=0.5u W=1u
M19090 o7 ibias vss vss sky130_fd_pr__nfet_01v8 L=0.5u W=1u
M19091 o7 ibias vss vss sky130_fd_pr__nfet_01v8 L=0.5u W=1u
M19092 o7 ibias vss vss sky130_fd_pr__nfet_01v8 L=0.5u W=1u
M19093 o7 ibias vss vss sky130_fd_pr__nfet_01v8 L=0.5u W=1u
M19094 o7 ibias vss vss sky130_fd_pr__nfet_01v8 L=0.5u W=1u
M19095 o7 ibias vss vss sky130_fd_pr__nfet_01v8 L=0.5u W=1u
M19096 o7 ibias vss vss sky130_fd_pr__nfet_01v8 L=0.5u W=1u
M19097 o7 ibias vss vss sky130_fd_pr__nfet_01v8 L=0.5u W=1u
M19098 o7 ibias vss vss sky130_fd_pr__nfet_01v8 L=0.5u W=1u
M19099 o7 ibias vss vss sky130_fd_pr__nfet_01v8 L=0.5u W=1u
M19100 o7 ibias vss vss sky130_fd_pr__nfet_01v8 L=0.5u W=1u
M19101 o7 ibias vss vss sky130_fd_pr__nfet_01v8 L=0.5u W=1u
M19102 o7 ibias vss vss sky130_fd_pr__nfet_01v8 L=0.5u W=1u
M19103 o7 ibias vss vss sky130_fd_pr__nfet_01v8 L=0.5u W=1u
M19104 o7 ibias vss vss sky130_fd_pr__nfet_01v8 L=0.5u W=1u
M19105 o7 ibias vss vss sky130_fd_pr__nfet_01v8 L=0.5u W=1u
M19106 o7 ibias vss vss sky130_fd_pr__nfet_01v8 L=0.5u W=1u
M19107 o7 ibias vss vss sky130_fd_pr__nfet_01v8 L=0.5u W=1u
M19108 o7 ibias vss vss sky130_fd_pr__nfet_01v8 L=0.5u W=1u
M19109 o7 ibias vss vss sky130_fd_pr__nfet_01v8 L=0.5u W=1u
M19110 o7 ibias vss vss sky130_fd_pr__nfet_01v8 L=0.5u W=1u
M19111 o7 ibias vss vss sky130_fd_pr__nfet_01v8 L=0.5u W=1u
M19112 o7 ibias vss vss sky130_fd_pr__nfet_01v8 L=0.5u W=1u
M19113 o7 ibias vss vss sky130_fd_pr__nfet_01v8 L=0.5u W=1u
M19114 o7 ibias vss vss sky130_fd_pr__nfet_01v8 L=0.5u W=1u
M19115 o7 ibias vss vss sky130_fd_pr__nfet_01v8 L=0.5u W=1u
M19116 o7 ibias vss vss sky130_fd_pr__nfet_01v8 L=0.5u W=1u
M19117 o7 ibias vss vss sky130_fd_pr__nfet_01v8 L=0.5u W=1u
M19118 o7 ibias vss vss sky130_fd_pr__nfet_01v8 L=0.5u W=1u
M19119 o7 ibias vss vss sky130_fd_pr__nfet_01v8 L=0.5u W=1u
M19120 o7 ibias vss vss sky130_fd_pr__nfet_01v8 L=0.5u W=1u
M19121 o7 ibias vss vss sky130_fd_pr__nfet_01v8 L=0.5u W=1u
M19122 o7 ibias vss vss sky130_fd_pr__nfet_01v8 L=0.5u W=1u
M19123 o7 ibias vss vss sky130_fd_pr__nfet_01v8 L=0.5u W=1u
M19124 o7 ibias vss vss sky130_fd_pr__nfet_01v8 L=0.5u W=1u
M19125 o7 ibias vss vss sky130_fd_pr__nfet_01v8 L=0.5u W=1u
M19126 o7 ibias vss vss sky130_fd_pr__nfet_01v8 L=0.5u W=1u
M19127 o7 ibias vss vss sky130_fd_pr__nfet_01v8 L=0.5u W=1u
M19128 o7 ibias vss vss sky130_fd_pr__nfet_01v8 L=0.5u W=1u
M19129 o7 ibias vss vss sky130_fd_pr__nfet_01v8 L=0.5u W=1u
M19130 o7 ibias vss vss sky130_fd_pr__nfet_01v8 L=0.5u W=1u
M19131 o7 ibias vss vss sky130_fd_pr__nfet_01v8 L=0.5u W=1u
M19132 o7 ibias vss vss sky130_fd_pr__nfet_01v8 L=0.5u W=1u
M19133 o7 ibias vss vss sky130_fd_pr__nfet_01v8 L=0.5u W=1u
M19134 o7 ibias vss vss sky130_fd_pr__nfet_01v8 L=0.5u W=1u
M19135 o7 ibias vss vss sky130_fd_pr__nfet_01v8 L=0.5u W=1u
M19136 o7 ibias vss vss sky130_fd_pr__nfet_01v8 L=0.5u W=1u
M19137 o7 ibias vss vss sky130_fd_pr__nfet_01v8 L=0.5u W=1u
M19138 o7 ibias vss vss sky130_fd_pr__nfet_01v8 L=0.5u W=1u
M19139 o7 ibias vss vss sky130_fd_pr__nfet_01v8 L=0.5u W=1u
M19140 o7 ibias vss vss sky130_fd_pr__nfet_01v8 L=0.5u W=1u
M19141 o7 ibias vss vss sky130_fd_pr__nfet_01v8 L=0.5u W=1u
M19142 o7 ibias vss vss sky130_fd_pr__nfet_01v8 L=0.5u W=1u
M19143 o7 ibias vss vss sky130_fd_pr__nfet_01v8 L=0.5u W=1u
M19144 o7 ibias vss vss sky130_fd_pr__nfet_01v8 L=0.5u W=1u
M19145 o7 ibias vss vss sky130_fd_pr__nfet_01v8 L=0.5u W=1u
M19146 o7 ibias vss vss sky130_fd_pr__nfet_01v8 L=0.5u W=1u
M19147 o7 ibias vss vss sky130_fd_pr__nfet_01v8 L=0.5u W=1u
M19148 o7 ibias vss vss sky130_fd_pr__nfet_01v8 L=0.5u W=1u
M19149 o7 ibias vss vss sky130_fd_pr__nfet_01v8 L=0.5u W=1u
M19150 o7 ibias vss vss sky130_fd_pr__nfet_01v8 L=0.5u W=1u
M19151 o7 ibias vss vss sky130_fd_pr__nfet_01v8 L=0.5u W=1u
M19152 o7 ibias vss vss sky130_fd_pr__nfet_01v8 L=0.5u W=1u
M19153 o7 ibias vss vss sky130_fd_pr__nfet_01v8 L=0.5u W=1u
M19154 o7 ibias vss vss sky130_fd_pr__nfet_01v8 L=0.5u W=1u
M19155 o7 ibias vss vss sky130_fd_pr__nfet_01v8 L=0.5u W=1u
M19156 o7 ibias vss vss sky130_fd_pr__nfet_01v8 L=0.5u W=1u
M19157 o7 ibias vss vss sky130_fd_pr__nfet_01v8 L=0.5u W=1u
M19158 o7 ibias vss vss sky130_fd_pr__nfet_01v8 L=0.5u W=1u
M19159 o7 ibias vss vss sky130_fd_pr__nfet_01v8 L=0.5u W=1u
M19160 o7 ibias vss vss sky130_fd_pr__nfet_01v8 L=0.5u W=1u
M19161 o7 ibias vss vss sky130_fd_pr__nfet_01v8 L=0.5u W=1u
M19162 o7 ibias vss vss sky130_fd_pr__nfet_01v8 L=0.5u W=1u
M19163 o7 ibias vss vss sky130_fd_pr__nfet_01v8 L=0.5u W=1u
M19164 o7 ibias vss vss sky130_fd_pr__nfet_01v8 L=0.5u W=1u
M19165 o7 ibias vss vss sky130_fd_pr__nfet_01v8 L=0.5u W=1u
M19166 o7 ibias vss vss sky130_fd_pr__nfet_01v8 L=0.5u W=1u
M19167 o7 ibias vss vss sky130_fd_pr__nfet_01v8 L=0.5u W=1u
M19168 o7 ibias vss vss sky130_fd_pr__nfet_01v8 L=0.5u W=1u
M19169 o7 ibias vss vss sky130_fd_pr__nfet_01v8 L=0.5u W=1u
M19170 o7 ibias vss vss sky130_fd_pr__nfet_01v8 L=0.5u W=1u
M19171 o7 ibias vss vss sky130_fd_pr__nfet_01v8 L=0.5u W=1u
M19172 o7 ibias vss vss sky130_fd_pr__nfet_01v8 L=0.5u W=1u
M19173 o7 ibias vss vss sky130_fd_pr__nfet_01v8 L=0.5u W=1u
M19174 o7 ibias vss vss sky130_fd_pr__nfet_01v8 L=0.5u W=1u
M19175 o7 ibias vss vss sky130_fd_pr__nfet_01v8 L=0.5u W=1u
M19176 o7 ibias vss vss sky130_fd_pr__nfet_01v8 L=0.5u W=1u
M19177 o7 ibias vss vss sky130_fd_pr__nfet_01v8 L=0.5u W=1u
M19178 o7 ibias vss vss sky130_fd_pr__nfet_01v8 L=0.5u W=1u
M19179 o7 ibias vss vss sky130_fd_pr__nfet_01v8 L=0.5u W=1u
M19180 o7 ibias vss vss sky130_fd_pr__nfet_01v8 L=0.5u W=1u
M19181 o7 ibias vss vss sky130_fd_pr__nfet_01v8 L=0.5u W=1u
M19182 o7 ibias vss vss sky130_fd_pr__nfet_01v8 L=0.5u W=1u
M19183 o7 ibias vss vss sky130_fd_pr__nfet_01v8 L=0.5u W=1u
M19184 o7 ibias vss vss sky130_fd_pr__nfet_01v8 L=0.5u W=1u
M19185 o7 ibias vss vss sky130_fd_pr__nfet_01v8 L=0.5u W=1u
M19186 o7 ibias vss vss sky130_fd_pr__nfet_01v8 L=0.5u W=1u
M19187 o7 ibias vss vss sky130_fd_pr__nfet_01v8 L=0.5u W=1u
M19188 o7 ibias vss vss sky130_fd_pr__nfet_01v8 L=0.5u W=1u
M19189 o7 ibias vss vss sky130_fd_pr__nfet_01v8 L=0.5u W=1u
M19190 o7 ibias vss vss sky130_fd_pr__nfet_01v8 L=0.5u W=1u
M19191 o7 ibias vss vss sky130_fd_pr__nfet_01v8 L=0.5u W=1u
M19192 o7 ibias vss vss sky130_fd_pr__nfet_01v8 L=0.5u W=1u
M19193 o7 ibias vss vss sky130_fd_pr__nfet_01v8 L=0.5u W=1u
M19194 o7 ibias vss vss sky130_fd_pr__nfet_01v8 L=0.5u W=1u
M19195 o7 ibias vss vss sky130_fd_pr__nfet_01v8 L=0.5u W=1u
M19196 o7 ibias vss vss sky130_fd_pr__nfet_01v8 L=0.5u W=1u
M19197 o7 ibias vss vss sky130_fd_pr__nfet_01v8 L=0.5u W=1u
M19198 o7 ibias vss vss sky130_fd_pr__nfet_01v8 L=0.5u W=1u
M19199 o7 ibias vss vss sky130_fd_pr__nfet_01v8 L=0.5u W=1u
M19200 o7 ibias vss vss sky130_fd_pr__nfet_01v8 L=0.5u W=1u
M19201 o7 ibias vss vss sky130_fd_pr__nfet_01v8 L=0.5u W=1u
M19202 o7 ibias vss vss sky130_fd_pr__nfet_01v8 L=0.5u W=1u
M19203 o7 ibias vss vss sky130_fd_pr__nfet_01v8 L=0.5u W=1u
M19204 o7 ibias vss vss sky130_fd_pr__nfet_01v8 L=0.5u W=1u
M19205 o7 ibias vss vss sky130_fd_pr__nfet_01v8 L=0.5u W=1u
M19206 o7 ibias vss vss sky130_fd_pr__nfet_01v8 L=0.5u W=1u
M19207 o7 ibias vss vss sky130_fd_pr__nfet_01v8 L=0.5u W=1u
M19208 o7 ibias vss vss sky130_fd_pr__nfet_01v8 L=0.5u W=1u
M19209 o7 ibias vss vss sky130_fd_pr__nfet_01v8 L=0.5u W=1u
M19210 o7 ibias vss vss sky130_fd_pr__nfet_01v8 L=0.5u W=1u
M19211 o7 ibias vss vss sky130_fd_pr__nfet_01v8 L=0.5u W=1u
M19212 o7 ibias vss vss sky130_fd_pr__nfet_01v8 L=0.5u W=1u
M19213 o7 ibias vss vss sky130_fd_pr__nfet_01v8 L=0.5u W=1u
M19214 o7 ibias vss vss sky130_fd_pr__nfet_01v8 L=0.5u W=1u
M19215 o7 ibias vss vss sky130_fd_pr__nfet_01v8 L=0.5u W=1u
M19216 o7 ibias vss vss sky130_fd_pr__nfet_01v8 L=0.5u W=1u
M19217 o7 ibias vss vss sky130_fd_pr__nfet_01v8 L=0.5u W=1u
M19218 o7 ibias vss vss sky130_fd_pr__nfet_01v8 L=0.5u W=1u
M19219 o7 ibias vss vss sky130_fd_pr__nfet_01v8 L=0.5u W=1u
M19220 o7 ibias vss vss sky130_fd_pr__nfet_01v8 L=0.5u W=1u
M19221 o7 ibias vss vss sky130_fd_pr__nfet_01v8 L=0.5u W=1u
M19222 o7 ibias vss vss sky130_fd_pr__nfet_01v8 L=0.5u W=1u
M19223 o7 ibias vss vss sky130_fd_pr__nfet_01v8 L=0.5u W=1u
M19224 o7 ibias vss vss sky130_fd_pr__nfet_01v8 L=0.5u W=1u
M19225 o7 ibias vss vss sky130_fd_pr__nfet_01v8 L=0.5u W=1u
M19226 o7 ibias vss vss sky130_fd_pr__nfet_01v8 L=0.5u W=1u
M19227 o7 ibias vss vss sky130_fd_pr__nfet_01v8 L=0.5u W=1u
M19228 o7 ibias vss vss sky130_fd_pr__nfet_01v8 L=0.5u W=1u
M19229 o7 ibias vss vss sky130_fd_pr__nfet_01v8 L=0.5u W=1u
M19230 o7 ibias vss vss sky130_fd_pr__nfet_01v8 L=0.5u W=1u
M19231 o7 ibias vss vss sky130_fd_pr__nfet_01v8 L=0.5u W=1u
M19232 o7 ibias vss vss sky130_fd_pr__nfet_01v8 L=0.5u W=1u
M19233 o7 ibias vss vss sky130_fd_pr__nfet_01v8 L=0.5u W=1u
M19234 o7 ibias vss vss sky130_fd_pr__nfet_01v8 L=0.5u W=1u
M19235 o7 ibias vss vss sky130_fd_pr__nfet_01v8 L=0.5u W=1u
M19236 o7 ibias vss vss sky130_fd_pr__nfet_01v8 L=0.5u W=1u
M19237 o7 ibias vss vss sky130_fd_pr__nfet_01v8 L=0.5u W=1u
M19238 o7 ibias vss vss sky130_fd_pr__nfet_01v8 L=0.5u W=1u
M19239 o7 ibias vss vss sky130_fd_pr__nfet_01v8 L=0.5u W=1u
M19240 o7 ibias vss vss sky130_fd_pr__nfet_01v8 L=0.5u W=1u
M19241 o7 ibias vss vss sky130_fd_pr__nfet_01v8 L=0.5u W=1u
M19242 o7 ibias vss vss sky130_fd_pr__nfet_01v8 L=0.5u W=1u
M19243 o7 ibias vss vss sky130_fd_pr__nfet_01v8 L=0.5u W=1u
M19244 o7 ibias vss vss sky130_fd_pr__nfet_01v8 L=0.5u W=1u
M19245 o7 ibias vss vss sky130_fd_pr__nfet_01v8 L=0.5u W=1u
M19246 o7 ibias vss vss sky130_fd_pr__nfet_01v8 L=0.5u W=1u
M19247 o7 ibias vss vss sky130_fd_pr__nfet_01v8 L=0.5u W=1u
M19248 o7 ibias vss vss sky130_fd_pr__nfet_01v8 L=0.5u W=1u
M19249 o7 ibias vss vss sky130_fd_pr__nfet_01v8 L=0.5u W=1u
M19250 o7 ibias vss vss sky130_fd_pr__nfet_01v8 L=0.5u W=1u
M19251 o7 ibias vss vss sky130_fd_pr__nfet_01v8 L=0.5u W=1u
M19252 o7 ibias vss vss sky130_fd_pr__nfet_01v8 L=0.5u W=1u
M19253 o7 ibias vss vss sky130_fd_pr__nfet_01v8 L=0.5u W=1u
M19254 o7 ibias vss vss sky130_fd_pr__nfet_01v8 L=0.5u W=1u
M19255 o7 ibias vss vss sky130_fd_pr__nfet_01v8 L=0.5u W=1u
M19256 o7 ibias vss vss sky130_fd_pr__nfet_01v8 L=0.5u W=1u
M19257 o7 ibias vss vss sky130_fd_pr__nfet_01v8 L=0.5u W=1u
M19258 o7 ibias vss vss sky130_fd_pr__nfet_01v8 L=0.5u W=1u
M19259 o7 ibias vss vss sky130_fd_pr__nfet_01v8 L=0.5u W=1u
M19260 o7 ibias vss vss sky130_fd_pr__nfet_01v8 L=0.5u W=1u
M19261 o7 ibias vss vss sky130_fd_pr__nfet_01v8 L=0.5u W=1u
M19262 o7 ibias vss vss sky130_fd_pr__nfet_01v8 L=0.5u W=1u
M19263 o7 ibias vss vss sky130_fd_pr__nfet_01v8 L=0.5u W=1u
M19264 o7 ibias vss vss sky130_fd_pr__nfet_01v8 L=0.5u W=1u
M19265 o7 ibias vss vss sky130_fd_pr__nfet_01v8 L=0.5u W=1u
M19266 o7 ibias vss vss sky130_fd_pr__nfet_01v8 L=0.5u W=1u
M19267 o7 ibias vss vss sky130_fd_pr__nfet_01v8 L=0.5u W=1u
M19268 o7 ibias vss vss sky130_fd_pr__nfet_01v8 L=0.5u W=1u
M19269 o7 ibias vss vss sky130_fd_pr__nfet_01v8 L=0.5u W=1u
M19270 o7 ibias vss vss sky130_fd_pr__nfet_01v8 L=0.5u W=1u
M19271 o7 ibias vss vss sky130_fd_pr__nfet_01v8 L=0.5u W=1u
M19272 o7 ibias vss vss sky130_fd_pr__nfet_01v8 L=0.5u W=1u
M19273 o7 ibias vss vss sky130_fd_pr__nfet_01v8 L=0.5u W=1u
M19274 o7 ibias vss vss sky130_fd_pr__nfet_01v8 L=0.5u W=1u
M19275 o7 ibias vss vss sky130_fd_pr__nfet_01v8 L=0.5u W=1u
M19276 o7 ibias vss vss sky130_fd_pr__nfet_01v8 L=0.5u W=1u
M19277 o7 ibias vss vss sky130_fd_pr__nfet_01v8 L=0.5u W=1u
M19278 o7 ibias vss vss sky130_fd_pr__nfet_01v8 L=0.5u W=1u
M19279 o7 ibias vss vss sky130_fd_pr__nfet_01v8 L=0.5u W=1u
M19280 o7 ibias vss vss sky130_fd_pr__nfet_01v8 L=0.5u W=1u
M19281 o7 ibias vss vss sky130_fd_pr__nfet_01v8 L=0.5u W=1u
M19282 o7 ibias vss vss sky130_fd_pr__nfet_01v8 L=0.5u W=1u
M19283 o7 ibias vss vss sky130_fd_pr__nfet_01v8 L=0.5u W=1u
M19284 o7 ibias vss vss sky130_fd_pr__nfet_01v8 L=0.5u W=1u
M19285 o7 ibias vss vss sky130_fd_pr__nfet_01v8 L=0.5u W=1u
M19286 o7 ibias vss vss sky130_fd_pr__nfet_01v8 L=0.5u W=1u
M19287 o7 ibias vss vss sky130_fd_pr__nfet_01v8 L=0.5u W=1u
M19288 o7 ibias vss vss sky130_fd_pr__nfet_01v8 L=0.5u W=1u
M19289 o7 ibias vss vss sky130_fd_pr__nfet_01v8 L=0.5u W=1u
M19290 o7 ibias vss vss sky130_fd_pr__nfet_01v8 L=0.5u W=1u
M19291 o7 ibias vss vss sky130_fd_pr__nfet_01v8 L=0.5u W=1u
M19292 o7 ibias vss vss sky130_fd_pr__nfet_01v8 L=0.5u W=1u
M19293 o7 ibias vss vss sky130_fd_pr__nfet_01v8 L=0.5u W=1u
M19294 o7 ibias vss vss sky130_fd_pr__nfet_01v8 L=0.5u W=1u
M19295 o7 ibias vss vss sky130_fd_pr__nfet_01v8 L=0.5u W=1u
M19296 o7 ibias vss vss sky130_fd_pr__nfet_01v8 L=0.5u W=1u
M19297 o7 ibias vss vss sky130_fd_pr__nfet_01v8 L=0.5u W=1u
M19298 o7 ibias vss vss sky130_fd_pr__nfet_01v8 L=0.5u W=1u
M19299 o7 ibias vss vss sky130_fd_pr__nfet_01v8 L=0.5u W=1u
M19300 o7 ibias vss vss sky130_fd_pr__nfet_01v8 L=0.5u W=1u
M19301 o7 ibias vss vss sky130_fd_pr__nfet_01v8 L=0.5u W=1u
M19302 o7 ibias vss vss sky130_fd_pr__nfet_01v8 L=0.5u W=1u
M19303 o7 ibias vss vss sky130_fd_pr__nfet_01v8 L=0.5u W=1u
M19304 o7 ibias vss vss sky130_fd_pr__nfet_01v8 L=0.5u W=1u
M19305 o7 ibias vss vss sky130_fd_pr__nfet_01v8 L=0.5u W=1u
M19306 o7 ibias vss vss sky130_fd_pr__nfet_01v8 L=0.5u W=1u
M19307 o7 ibias vss vss sky130_fd_pr__nfet_01v8 L=0.5u W=1u
M19308 o7 ibias vss vss sky130_fd_pr__nfet_01v8 L=0.5u W=1u
M19309 o7 ibias vss vss sky130_fd_pr__nfet_01v8 L=0.5u W=1u
M19310 o7 ibias vss vss sky130_fd_pr__nfet_01v8 L=0.5u W=1u
M19311 o7 ibias vss vss sky130_fd_pr__nfet_01v8 L=0.5u W=1u
M19312 o7 ibias vss vss sky130_fd_pr__nfet_01v8 L=0.5u W=1u
M19313 o7 ibias vss vss sky130_fd_pr__nfet_01v8 L=0.5u W=1u
M19314 o7 ibias vss vss sky130_fd_pr__nfet_01v8 L=0.5u W=1u
M19315 o7 ibias vss vss sky130_fd_pr__nfet_01v8 L=0.5u W=1u
M19316 o7 ibias vss vss sky130_fd_pr__nfet_01v8 L=0.5u W=1u
M19317 o7 ibias vss vss sky130_fd_pr__nfet_01v8 L=0.5u W=1u
M19318 o7 ibias vss vss sky130_fd_pr__nfet_01v8 L=0.5u W=1u
M19319 o7 ibias vss vss sky130_fd_pr__nfet_01v8 L=0.5u W=1u
M19320 o7 ibias vss vss sky130_fd_pr__nfet_01v8 L=0.5u W=1u
M19321 o7 ibias vss vss sky130_fd_pr__nfet_01v8 L=0.5u W=1u
M19322 o7 ibias vss vss sky130_fd_pr__nfet_01v8 L=0.5u W=1u
M19323 o7 ibias vss vss sky130_fd_pr__nfet_01v8 L=0.5u W=1u
M19324 o7 ibias vss vss sky130_fd_pr__nfet_01v8 L=0.5u W=1u
M19325 o7 ibias vss vss sky130_fd_pr__nfet_01v8 L=0.5u W=1u
M19326 o7 ibias vss vss sky130_fd_pr__nfet_01v8 L=0.5u W=1u
M19327 o7 ibias vss vss sky130_fd_pr__nfet_01v8 L=0.5u W=1u
M19328 o7 ibias vss vss sky130_fd_pr__nfet_01v8 L=0.5u W=1u
M19329 o7 ibias vss vss sky130_fd_pr__nfet_01v8 L=0.5u W=1u
M19330 o7 ibias vss vss sky130_fd_pr__nfet_01v8 L=0.5u W=1u
M19331 o7 ibias vss vss sky130_fd_pr__nfet_01v8 L=0.5u W=1u
M19332 o7 ibias vss vss sky130_fd_pr__nfet_01v8 L=0.5u W=1u
M19333 o7 ibias vss vss sky130_fd_pr__nfet_01v8 L=0.5u W=1u
M19334 o7 ibias vss vss sky130_fd_pr__nfet_01v8 L=0.5u W=1u
M19335 o7 ibias vss vss sky130_fd_pr__nfet_01v8 L=0.5u W=1u
M19336 o7 ibias vss vss sky130_fd_pr__nfet_01v8 L=0.5u W=1u
M19337 o7 ibias vss vss sky130_fd_pr__nfet_01v8 L=0.5u W=1u
M19338 o7 ibias vss vss sky130_fd_pr__nfet_01v8 L=0.5u W=1u
M19339 o7 ibias vss vss sky130_fd_pr__nfet_01v8 L=0.5u W=1u
M19340 o7 ibias vss vss sky130_fd_pr__nfet_01v8 L=0.5u W=1u
M19341 o7 ibias vss vss sky130_fd_pr__nfet_01v8 L=0.5u W=1u
M19342 o7 ibias vss vss sky130_fd_pr__nfet_01v8 L=0.5u W=1u
M19343 o7 ibias vss vss sky130_fd_pr__nfet_01v8 L=0.5u W=1u
M19344 o7 ibias vss vss sky130_fd_pr__nfet_01v8 L=0.5u W=1u
M19345 o7 ibias vss vss sky130_fd_pr__nfet_01v8 L=0.5u W=1u
M19346 o7 ibias vss vss sky130_fd_pr__nfet_01v8 L=0.5u W=1u
M19347 o7 ibias vss vss sky130_fd_pr__nfet_01v8 L=0.5u W=1u
M19348 o7 ibias vss vss sky130_fd_pr__nfet_01v8 L=0.5u W=1u
M19349 o7 ibias vss vss sky130_fd_pr__nfet_01v8 L=0.5u W=1u
M19350 o7 ibias vss vss sky130_fd_pr__nfet_01v8 L=0.5u W=1u
M19351 o7 ibias vss vss sky130_fd_pr__nfet_01v8 L=0.5u W=1u
M19352 o7 ibias vss vss sky130_fd_pr__nfet_01v8 L=0.5u W=1u
M19353 o7 ibias vss vss sky130_fd_pr__nfet_01v8 L=0.5u W=1u
M19354 o7 ibias vss vss sky130_fd_pr__nfet_01v8 L=0.5u W=1u
M19355 o7 ibias vss vss sky130_fd_pr__nfet_01v8 L=0.5u W=1u
M19356 o7 ibias vss vss sky130_fd_pr__nfet_01v8 L=0.5u W=1u
M19357 o7 ibias vss vss sky130_fd_pr__nfet_01v8 L=0.5u W=1u
M19358 o7 ibias vss vss sky130_fd_pr__nfet_01v8 L=0.5u W=1u
M19359 o7 ibias vss vss sky130_fd_pr__nfet_01v8 L=0.5u W=1u
M19360 o7 ibias vss vss sky130_fd_pr__nfet_01v8 L=0.5u W=1u
M19361 o7 ibias vss vss sky130_fd_pr__nfet_01v8 L=0.5u W=1u
M19362 o7 ibias vss vss sky130_fd_pr__nfet_01v8 L=0.5u W=1u
M19363 o7 ibias vss vss sky130_fd_pr__nfet_01v8 L=0.5u W=1u
M19364 o7 ibias vss vss sky130_fd_pr__nfet_01v8 L=0.5u W=1u
M19365 o7 ibias vss vss sky130_fd_pr__nfet_01v8 L=0.5u W=1u
M19366 o7 ibias vss vss sky130_fd_pr__nfet_01v8 L=0.5u W=1u
M19367 o7 ibias vss vss sky130_fd_pr__nfet_01v8 L=0.5u W=1u
M19368 o7 ibias vss vss sky130_fd_pr__nfet_01v8 L=0.5u W=1u
M19369 o7 ibias vss vss sky130_fd_pr__nfet_01v8 L=0.5u W=1u
M19370 o7 ibias vss vss sky130_fd_pr__nfet_01v8 L=0.5u W=1u
M19371 o7 ibias vss vss sky130_fd_pr__nfet_01v8 L=0.5u W=1u
M19372 o7 ibias vss vss sky130_fd_pr__nfet_01v8 L=0.5u W=1u
M19373 o7 ibias vss vss sky130_fd_pr__nfet_01v8 L=0.5u W=1u
M19374 o7 ibias vss vss sky130_fd_pr__nfet_01v8 L=0.5u W=1u
M19375 o7 ibias vss vss sky130_fd_pr__nfet_01v8 L=0.5u W=1u
M19376 o7 ibias vss vss sky130_fd_pr__nfet_01v8 L=0.5u W=1u
M19377 o7 ibias vss vss sky130_fd_pr__nfet_01v8 L=0.5u W=1u
M19378 o7 ibias vss vss sky130_fd_pr__nfet_01v8 L=0.5u W=1u
M19379 o7 ibias vss vss sky130_fd_pr__nfet_01v8 L=0.5u W=1u
M19380 o7 ibias vss vss sky130_fd_pr__nfet_01v8 L=0.5u W=1u
M19381 o7 ibias vss vss sky130_fd_pr__nfet_01v8 L=0.5u W=1u
M19382 o7 ibias vss vss sky130_fd_pr__nfet_01v8 L=0.5u W=1u
M19383 o7 ibias vss vss sky130_fd_pr__nfet_01v8 L=0.5u W=1u
M19384 o7 ibias vss vss sky130_fd_pr__nfet_01v8 L=0.5u W=1u
M19385 o7 ibias vss vss sky130_fd_pr__nfet_01v8 L=0.5u W=1u
M19386 o7 ibias vss vss sky130_fd_pr__nfet_01v8 L=0.5u W=1u
M19387 o7 ibias vss vss sky130_fd_pr__nfet_01v8 L=0.5u W=1u
M19388 o7 ibias vss vss sky130_fd_pr__nfet_01v8 L=0.5u W=1u
M19389 o7 ibias vss vss sky130_fd_pr__nfet_01v8 L=0.5u W=1u
M19390 o7 ibias vss vss sky130_fd_pr__nfet_01v8 L=0.5u W=1u
M19391 o7 ibias vss vss sky130_fd_pr__nfet_01v8 L=0.5u W=1u
M19392 o7 ibias vss vss sky130_fd_pr__nfet_01v8 L=0.5u W=1u
M19393 o7 ibias vss vss sky130_fd_pr__nfet_01v8 L=0.5u W=1u
M19394 o7 ibias vss vss sky130_fd_pr__nfet_01v8 L=0.5u W=1u
M19395 o7 ibias vss vss sky130_fd_pr__nfet_01v8 L=0.5u W=1u
M19396 o7 ibias vss vss sky130_fd_pr__nfet_01v8 L=0.5u W=1u
M19397 o7 ibias vss vss sky130_fd_pr__nfet_01v8 L=0.5u W=1u
M19398 o7 ibias vss vss sky130_fd_pr__nfet_01v8 L=0.5u W=1u
M19399 o7 ibias vss vss sky130_fd_pr__nfet_01v8 L=0.5u W=1u
M19400 o7 ibias vss vss sky130_fd_pr__nfet_01v8 L=0.5u W=1u
M19401 o7 ibias vss vss sky130_fd_pr__nfet_01v8 L=0.5u W=1u
M19402 o7 ibias vss vss sky130_fd_pr__nfet_01v8 L=0.5u W=1u
M19403 o7 ibias vss vss sky130_fd_pr__nfet_01v8 L=0.5u W=1u
M19404 o7 ibias vss vss sky130_fd_pr__nfet_01v8 L=0.5u W=1u
M19405 o7 ibias vss vss sky130_fd_pr__nfet_01v8 L=0.5u W=1u
M19406 o7 ibias vss vss sky130_fd_pr__nfet_01v8 L=0.5u W=1u
M19407 o7 ibias vss vss sky130_fd_pr__nfet_01v8 L=0.5u W=1u
M19408 o7 ibias vss vss sky130_fd_pr__nfet_01v8 L=0.5u W=1u
M19409 o7 ibias vss vss sky130_fd_pr__nfet_01v8 L=0.5u W=1u
M19410 o7 ibias vss vss sky130_fd_pr__nfet_01v8 L=0.5u W=1u
M19411 o7 ibias vss vss sky130_fd_pr__nfet_01v8 L=0.5u W=1u
M19412 o7 ibias vss vss sky130_fd_pr__nfet_01v8 L=0.5u W=1u
M19413 o7 ibias vss vss sky130_fd_pr__nfet_01v8 L=0.5u W=1u
M19414 o7 ibias vss vss sky130_fd_pr__nfet_01v8 L=0.5u W=1u
M19415 o7 ibias vss vss sky130_fd_pr__nfet_01v8 L=0.5u W=1u
M19416 o7 ibias vss vss sky130_fd_pr__nfet_01v8 L=0.5u W=1u
M19417 o7 ibias vss vss sky130_fd_pr__nfet_01v8 L=0.5u W=1u
M19418 o7 ibias vss vss sky130_fd_pr__nfet_01v8 L=0.5u W=1u
M19419 o7 ibias vss vss sky130_fd_pr__nfet_01v8 L=0.5u W=1u
M19420 o7 ibias vss vss sky130_fd_pr__nfet_01v8 L=0.5u W=1u
M19421 o7 ibias vss vss sky130_fd_pr__nfet_01v8 L=0.5u W=1u
M19422 o7 ibias vss vss sky130_fd_pr__nfet_01v8 L=0.5u W=1u
M19423 o7 ibias vss vss sky130_fd_pr__nfet_01v8 L=0.5u W=1u
M19424 o7 ibias vss vss sky130_fd_pr__nfet_01v8 L=0.5u W=1u
M19425 o7 ibias vss vss sky130_fd_pr__nfet_01v8 L=0.5u W=1u
M19426 o7 ibias vss vss sky130_fd_pr__nfet_01v8 L=0.5u W=1u
M19427 o7 ibias vss vss sky130_fd_pr__nfet_01v8 L=0.5u W=1u
M19428 o7 ibias vss vss sky130_fd_pr__nfet_01v8 L=0.5u W=1u
M19429 o7 ibias vss vss sky130_fd_pr__nfet_01v8 L=0.5u W=1u
M19430 o7 ibias vss vss sky130_fd_pr__nfet_01v8 L=0.5u W=1u
M19431 o7 ibias vss vss sky130_fd_pr__nfet_01v8 L=0.5u W=1u
M19432 o7 ibias vss vss sky130_fd_pr__nfet_01v8 L=0.5u W=1u
M19433 o7 ibias vss vss sky130_fd_pr__nfet_01v8 L=0.5u W=1u
M19434 o7 ibias vss vss sky130_fd_pr__nfet_01v8 L=0.5u W=1u
M19435 o7 ibias vss vss sky130_fd_pr__nfet_01v8 L=0.5u W=1u
M19436 o7 ibias vss vss sky130_fd_pr__nfet_01v8 L=0.5u W=1u
M19437 o7 ibias vss vss sky130_fd_pr__nfet_01v8 L=0.5u W=1u
M19438 o7 ibias vss vss sky130_fd_pr__nfet_01v8 L=0.5u W=1u
M19439 o7 ibias vss vss sky130_fd_pr__nfet_01v8 L=0.5u W=1u
M19440 o7 ibias vss vss sky130_fd_pr__nfet_01v8 L=0.5u W=1u
M19441 o7 ibias vss vss sky130_fd_pr__nfet_01v8 L=0.5u W=1u
M19442 o7 ibias vss vss sky130_fd_pr__nfet_01v8 L=0.5u W=1u
M19443 o7 ibias vss vss sky130_fd_pr__nfet_01v8 L=0.5u W=1u
M19444 o7 ibias vss vss sky130_fd_pr__nfet_01v8 L=0.5u W=1u
M19445 o7 ibias vss vss sky130_fd_pr__nfet_01v8 L=0.5u W=1u
M19446 o7 ibias vss vss sky130_fd_pr__nfet_01v8 L=0.5u W=1u
M19447 o7 ibias vss vss sky130_fd_pr__nfet_01v8 L=0.5u W=1u
M19448 o7 ibias vss vss sky130_fd_pr__nfet_01v8 L=0.5u W=1u
M19449 o7 ibias vss vss sky130_fd_pr__nfet_01v8 L=0.5u W=1u
M19450 o7 ibias vss vss sky130_fd_pr__nfet_01v8 L=0.5u W=1u
M19451 o7 ibias vss vss sky130_fd_pr__nfet_01v8 L=0.5u W=1u
M19452 o7 ibias vss vss sky130_fd_pr__nfet_01v8 L=0.5u W=1u
M19453 o7 ibias vss vss sky130_fd_pr__nfet_01v8 L=0.5u W=1u
M19454 o7 ibias vss vss sky130_fd_pr__nfet_01v8 L=0.5u W=1u
M19455 o7 ibias vss vss sky130_fd_pr__nfet_01v8 L=0.5u W=1u
M19456 o7 ibias vss vss sky130_fd_pr__nfet_01v8 L=0.5u W=1u
M19457 o7 ibias vss vss sky130_fd_pr__nfet_01v8 L=0.5u W=1u
M19458 o7 ibias vss vss sky130_fd_pr__nfet_01v8 L=0.5u W=1u
M19459 o7 ibias vss vss sky130_fd_pr__nfet_01v8 L=0.5u W=1u
M19460 o7 ibias vss vss sky130_fd_pr__nfet_01v8 L=0.5u W=1u
M19461 o7 ibias vss vss sky130_fd_pr__nfet_01v8 L=0.5u W=1u
M19462 o7 ibias vss vss sky130_fd_pr__nfet_01v8 L=0.5u W=1u
M19463 o7 ibias vss vss sky130_fd_pr__nfet_01v8 L=0.5u W=1u
M19464 o7 ibias vss vss sky130_fd_pr__nfet_01v8 L=0.5u W=1u
M19465 o7 ibias vss vss sky130_fd_pr__nfet_01v8 L=0.5u W=1u
M19466 o7 ibias vss vss sky130_fd_pr__nfet_01v8 L=0.5u W=1u
M19467 o7 ibias vss vss sky130_fd_pr__nfet_01v8 L=0.5u W=1u
M19468 o7 ibias vss vss sky130_fd_pr__nfet_01v8 L=0.5u W=1u
M19469 o7 ibias vss vss sky130_fd_pr__nfet_01v8 L=0.5u W=1u
M19470 o7 ibias vss vss sky130_fd_pr__nfet_01v8 L=0.5u W=1u
M19471 o7 ibias vss vss sky130_fd_pr__nfet_01v8 L=0.5u W=1u
M19472 o7 ibias vss vss sky130_fd_pr__nfet_01v8 L=0.5u W=1u
M19473 o7 ibias vss vss sky130_fd_pr__nfet_01v8 L=0.5u W=1u
M19474 o7 ibias vss vss sky130_fd_pr__nfet_01v8 L=0.5u W=1u
M19475 o7 ibias vss vss sky130_fd_pr__nfet_01v8 L=0.5u W=1u
M19476 o7 ibias vss vss sky130_fd_pr__nfet_01v8 L=0.5u W=1u
M19477 o7 ibias vss vss sky130_fd_pr__nfet_01v8 L=0.5u W=1u
M19478 o7 ibias vss vss sky130_fd_pr__nfet_01v8 L=0.5u W=1u
M19479 o7 ibias vss vss sky130_fd_pr__nfet_01v8 L=0.5u W=1u
M19480 o7 ibias vss vss sky130_fd_pr__nfet_01v8 L=0.5u W=1u
M19481 o7 ibias vss vss sky130_fd_pr__nfet_01v8 L=0.5u W=1u
M19482 o7 ibias vss vss sky130_fd_pr__nfet_01v8 L=0.5u W=1u
M19483 o7 ibias vss vss sky130_fd_pr__nfet_01v8 L=0.5u W=1u
M19484 o7 ibias vss vss sky130_fd_pr__nfet_01v8 L=0.5u W=1u
M19485 o7 ibias vss vss sky130_fd_pr__nfet_01v8 L=0.5u W=1u
M19486 o7 ibias vss vss sky130_fd_pr__nfet_01v8 L=0.5u W=1u
M19487 o7 ibias vss vss sky130_fd_pr__nfet_01v8 L=0.5u W=1u
M19488 o7 ibias vss vss sky130_fd_pr__nfet_01v8 L=0.5u W=1u
M19489 o7 ibias vss vss sky130_fd_pr__nfet_01v8 L=0.5u W=1u
M19490 o7 ibias vss vss sky130_fd_pr__nfet_01v8 L=0.5u W=1u
M19491 o7 ibias vss vss sky130_fd_pr__nfet_01v8 L=0.5u W=1u
M19492 o7 ibias vss vss sky130_fd_pr__nfet_01v8 L=0.5u W=1u
M19493 o7 ibias vss vss sky130_fd_pr__nfet_01v8 L=0.5u W=1u
M19494 o7 ibias vss vss sky130_fd_pr__nfet_01v8 L=0.5u W=1u
M19495 o7 ibias vss vss sky130_fd_pr__nfet_01v8 L=0.5u W=1u
M19496 o7 ibias vss vss sky130_fd_pr__nfet_01v8 L=0.5u W=1u
M19497 o7 ibias vss vss sky130_fd_pr__nfet_01v8 L=0.5u W=1u
M19498 o7 ibias vss vss sky130_fd_pr__nfet_01v8 L=0.5u W=1u
M19499 o7 ibias vss vss sky130_fd_pr__nfet_01v8 L=0.5u W=1u
M19500 o7 ibias vss vss sky130_fd_pr__nfet_01v8 L=0.5u W=1u
M19501 o7 ibias vss vss sky130_fd_pr__nfet_01v8 L=0.5u W=1u
M19502 o7 ibias vss vss sky130_fd_pr__nfet_01v8 L=0.5u W=1u
M19503 o7 ibias vss vss sky130_fd_pr__nfet_01v8 L=0.5u W=1u
M19504 o7 ibias vss vss sky130_fd_pr__nfet_01v8 L=0.5u W=1u
M19505 o7 ibias vss vss sky130_fd_pr__nfet_01v8 L=0.5u W=1u
M19506 o7 ibias vss vss sky130_fd_pr__nfet_01v8 L=0.5u W=1u
M19507 o7 ibias vss vss sky130_fd_pr__nfet_01v8 L=0.5u W=1u
M19508 o7 ibias vss vss sky130_fd_pr__nfet_01v8 L=0.5u W=1u
M19509 o7 ibias vss vss sky130_fd_pr__nfet_01v8 L=0.5u W=1u
M19510 o7 ibias vss vss sky130_fd_pr__nfet_01v8 L=0.5u W=1u
M19511 o7 ibias vss vss sky130_fd_pr__nfet_01v8 L=0.5u W=1u
M19512 o7 ibias vss vss sky130_fd_pr__nfet_01v8 L=0.5u W=1u
M19513 o7 ibias vss vss sky130_fd_pr__nfet_01v8 L=0.5u W=1u
M19514 o7 ibias vss vss sky130_fd_pr__nfet_01v8 L=0.5u W=1u
M19515 o7 ibias vss vss sky130_fd_pr__nfet_01v8 L=0.5u W=1u
M19516 o7 ibias vss vss sky130_fd_pr__nfet_01v8 L=0.5u W=1u
M19517 o7 ibias vss vss sky130_fd_pr__nfet_01v8 L=0.5u W=1u
M19518 o7 ibias vss vss sky130_fd_pr__nfet_01v8 L=0.5u W=1u
M19519 o7 ibias vss vss sky130_fd_pr__nfet_01v8 L=0.5u W=1u
M19520 o7 ibias vss vss sky130_fd_pr__nfet_01v8 L=0.5u W=1u
M19521 o7 ibias vss vss sky130_fd_pr__nfet_01v8 L=0.5u W=1u
M19522 o7 ibias vss vss sky130_fd_pr__nfet_01v8 L=0.5u W=1u
M19523 o7 ibias vss vss sky130_fd_pr__nfet_01v8 L=0.5u W=1u
M19524 o7 ibias vss vss sky130_fd_pr__nfet_01v8 L=0.5u W=1u
M19525 o7 ibias vss vss sky130_fd_pr__nfet_01v8 L=0.5u W=1u
M19526 o7 ibias vss vss sky130_fd_pr__nfet_01v8 L=0.5u W=1u
M19527 o7 ibias vss vss sky130_fd_pr__nfet_01v8 L=0.5u W=1u
M19528 o7 ibias vss vss sky130_fd_pr__nfet_01v8 L=0.5u W=1u
M19529 o7 ibias vss vss sky130_fd_pr__nfet_01v8 L=0.5u W=1u
M19530 o7 ibias vss vss sky130_fd_pr__nfet_01v8 L=0.5u W=1u
M19531 o7 ibias vss vss sky130_fd_pr__nfet_01v8 L=0.5u W=1u
M19532 o7 ibias vss vss sky130_fd_pr__nfet_01v8 L=0.5u W=1u
M19533 o7 ibias vss vss sky130_fd_pr__nfet_01v8 L=0.5u W=1u
M19534 o7 ibias vss vss sky130_fd_pr__nfet_01v8 L=0.5u W=1u
M19535 o7 ibias vss vss sky130_fd_pr__nfet_01v8 L=0.5u W=1u
M19536 o7 ibias vss vss sky130_fd_pr__nfet_01v8 L=0.5u W=1u
M19537 o7 ibias vss vss sky130_fd_pr__nfet_01v8 L=0.5u W=1u
M19538 o7 ibias vss vss sky130_fd_pr__nfet_01v8 L=0.5u W=1u
M19539 o7 ibias vss vss sky130_fd_pr__nfet_01v8 L=0.5u W=1u
M19540 o7 ibias vss vss sky130_fd_pr__nfet_01v8 L=0.5u W=1u
M19541 o7 ibias vss vss sky130_fd_pr__nfet_01v8 L=0.5u W=1u
M19542 o7 ibias vss vss sky130_fd_pr__nfet_01v8 L=0.5u W=1u
M19543 o7 ibias vss vss sky130_fd_pr__nfet_01v8 L=0.5u W=1u
M19544 o7 ibias vss vss sky130_fd_pr__nfet_01v8 L=0.5u W=1u
M19545 o7 ibias vss vss sky130_fd_pr__nfet_01v8 L=0.5u W=1u
M19546 o7 ibias vss vss sky130_fd_pr__nfet_01v8 L=0.5u W=1u
M19547 o7 ibias vss vss sky130_fd_pr__nfet_01v8 L=0.5u W=1u
M19548 o7 ibias vss vss sky130_fd_pr__nfet_01v8 L=0.5u W=1u
M19549 o7 ibias vss vss sky130_fd_pr__nfet_01v8 L=0.5u W=1u
M19550 o7 ibias vss vss sky130_fd_pr__nfet_01v8 L=0.5u W=1u
M19551 o7 ibias vss vss sky130_fd_pr__nfet_01v8 L=0.5u W=1u
M19552 o7 ibias vss vss sky130_fd_pr__nfet_01v8 L=0.5u W=1u
M19553 o7 ibias vss vss sky130_fd_pr__nfet_01v8 L=0.5u W=1u
M19554 o7 ibias vss vss sky130_fd_pr__nfet_01v8 L=0.5u W=1u
M19555 o7 ibias vss vss sky130_fd_pr__nfet_01v8 L=0.5u W=1u
M19556 o7 ibias vss vss sky130_fd_pr__nfet_01v8 L=0.5u W=1u
M19557 o7 ibias vss vss sky130_fd_pr__nfet_01v8 L=0.5u W=1u
M19558 o7 ibias vss vss sky130_fd_pr__nfet_01v8 L=0.5u W=1u
M19559 o7 ibias vss vss sky130_fd_pr__nfet_01v8 L=0.5u W=1u
M19560 o7 ibias vss vss sky130_fd_pr__nfet_01v8 L=0.5u W=1u
M19561 o7 ibias vss vss sky130_fd_pr__nfet_01v8 L=0.5u W=1u
M19562 o7 ibias vss vss sky130_fd_pr__nfet_01v8 L=0.5u W=1u
M19563 o7 ibias vss vss sky130_fd_pr__nfet_01v8 L=0.5u W=1u
M19564 o7 ibias vss vss sky130_fd_pr__nfet_01v8 L=0.5u W=1u
M19565 o7 ibias vss vss sky130_fd_pr__nfet_01v8 L=0.5u W=1u
M19566 o7 ibias vss vss sky130_fd_pr__nfet_01v8 L=0.5u W=1u
M19567 o7 ibias vss vss sky130_fd_pr__nfet_01v8 L=0.5u W=1u
M19568 o7 ibias vss vss sky130_fd_pr__nfet_01v8 L=0.5u W=1u
M19569 o7 ibias vss vss sky130_fd_pr__nfet_01v8 L=0.5u W=1u
M19570 o7 ibias vss vss sky130_fd_pr__nfet_01v8 L=0.5u W=1u
M19571 o7 ibias vss vss sky130_fd_pr__nfet_01v8 L=0.5u W=1u
M19572 o7 ibias vss vss sky130_fd_pr__nfet_01v8 L=0.5u W=1u
M19573 o7 ibias vss vss sky130_fd_pr__nfet_01v8 L=0.5u W=1u
M19574 o7 ibias vss vss sky130_fd_pr__nfet_01v8 L=0.5u W=1u
M19575 o7 ibias vss vss sky130_fd_pr__nfet_01v8 L=0.5u W=1u
M19576 o7 ibias vss vss sky130_fd_pr__nfet_01v8 L=0.5u W=1u
M19577 o7 ibias vss vss sky130_fd_pr__nfet_01v8 L=0.5u W=1u
M19578 o7 ibias vss vss sky130_fd_pr__nfet_01v8 L=0.5u W=1u
M19579 o7 ibias vss vss sky130_fd_pr__nfet_01v8 L=0.5u W=1u
M19580 o7 ibias vss vss sky130_fd_pr__nfet_01v8 L=0.5u W=1u
M19581 o7 ibias vss vss sky130_fd_pr__nfet_01v8 L=0.5u W=1u
M19582 o7 ibias vss vss sky130_fd_pr__nfet_01v8 L=0.5u W=1u
M19583 o7 ibias vss vss sky130_fd_pr__nfet_01v8 L=0.5u W=1u
M19584 o7 ibias vss vss sky130_fd_pr__nfet_01v8 L=0.5u W=1u
M19585 o7 ibias vss vss sky130_fd_pr__nfet_01v8 L=0.5u W=1u
M19586 o7 ibias vss vss sky130_fd_pr__nfet_01v8 L=0.5u W=1u
M19587 o7 ibias vss vss sky130_fd_pr__nfet_01v8 L=0.5u W=1u
M19588 o7 ibias vss vss sky130_fd_pr__nfet_01v8 L=0.5u W=1u
M19589 o7 ibias vss vss sky130_fd_pr__nfet_01v8 L=0.5u W=1u
M19590 o7 ibias vss vss sky130_fd_pr__nfet_01v8 L=0.5u W=1u
M19591 o7 ibias vss vss sky130_fd_pr__nfet_01v8 L=0.5u W=1u
M19592 o7 ibias vss vss sky130_fd_pr__nfet_01v8 L=0.5u W=1u
M19593 o7 ibias vss vss sky130_fd_pr__nfet_01v8 L=0.5u W=1u
M19594 o7 ibias vss vss sky130_fd_pr__nfet_01v8 L=0.5u W=1u
M19595 o7 ibias vss vss sky130_fd_pr__nfet_01v8 L=0.5u W=1u
M19596 o7 ibias vss vss sky130_fd_pr__nfet_01v8 L=0.5u W=1u
M19597 o7 ibias vss vss sky130_fd_pr__nfet_01v8 L=0.5u W=1u
M19598 o7 ibias vss vss sky130_fd_pr__nfet_01v8 L=0.5u W=1u
M19599 o7 ibias vss vss sky130_fd_pr__nfet_01v8 L=0.5u W=1u
M19600 o7 ibias vss vss sky130_fd_pr__nfet_01v8 L=0.5u W=1u
M19601 o7 ibias vss vss sky130_fd_pr__nfet_01v8 L=0.5u W=1u
M19602 o7 ibias vss vss sky130_fd_pr__nfet_01v8 L=0.5u W=1u
M19603 o7 ibias vss vss sky130_fd_pr__nfet_01v8 L=0.5u W=1u
M19604 o7 ibias vss vss sky130_fd_pr__nfet_01v8 L=0.5u W=1u
M19605 o7 ibias vss vss sky130_fd_pr__nfet_01v8 L=0.5u W=1u
M19606 o7 ibias vss vss sky130_fd_pr__nfet_01v8 L=0.5u W=1u
M19607 o7 ibias vss vss sky130_fd_pr__nfet_01v8 L=0.5u W=1u
M19608 o7 ibias vss vss sky130_fd_pr__nfet_01v8 L=0.5u W=1u
M19609 o7 ibias vss vss sky130_fd_pr__nfet_01v8 L=0.5u W=1u
M19610 o7 ibias vss vss sky130_fd_pr__nfet_01v8 L=0.5u W=1u
M19611 o7 ibias vss vss sky130_fd_pr__nfet_01v8 L=0.5u W=1u
M19612 o7 ibias vss vss sky130_fd_pr__nfet_01v8 L=0.5u W=1u
M19613 o7 ibias vss vss sky130_fd_pr__nfet_01v8 L=0.5u W=1u
M19614 o7 ibias vss vss sky130_fd_pr__nfet_01v8 L=0.5u W=1u
M19615 o7 ibias vss vss sky130_fd_pr__nfet_01v8 L=0.5u W=1u
M19616 o7 ibias vss vss sky130_fd_pr__nfet_01v8 L=0.5u W=1u
M19617 o7 ibias vss vss sky130_fd_pr__nfet_01v8 L=0.5u W=1u
M19618 o7 ibias vss vss sky130_fd_pr__nfet_01v8 L=0.5u W=1u
M19619 o7 ibias vss vss sky130_fd_pr__nfet_01v8 L=0.5u W=1u
M19620 o7 ibias vss vss sky130_fd_pr__nfet_01v8 L=0.5u W=1u
M19621 o7 ibias vss vss sky130_fd_pr__nfet_01v8 L=0.5u W=1u
M19622 o7 ibias vss vss sky130_fd_pr__nfet_01v8 L=0.5u W=1u
M19623 o7 ibias vss vss sky130_fd_pr__nfet_01v8 L=0.5u W=1u
M19624 o7 ibias vss vss sky130_fd_pr__nfet_01v8 L=0.5u W=1u
M19625 o7 ibias vss vss sky130_fd_pr__nfet_01v8 L=0.5u W=1u
M19626 o7 ibias vss vss sky130_fd_pr__nfet_01v8 L=0.5u W=1u
M19627 o7 ibias vss vss sky130_fd_pr__nfet_01v8 L=0.5u W=1u
M19628 o7 ibias vss vss sky130_fd_pr__nfet_01v8 L=0.5u W=1u
M19629 o7 ibias vss vss sky130_fd_pr__nfet_01v8 L=0.5u W=1u
M19630 o7 ibias vss vss sky130_fd_pr__nfet_01v8 L=0.5u W=1u
M19631 o7 ibias vss vss sky130_fd_pr__nfet_01v8 L=0.5u W=1u
M19632 o7 ibias vss vss sky130_fd_pr__nfet_01v8 L=0.5u W=1u
M19633 o7 ibias vss vss sky130_fd_pr__nfet_01v8 L=0.5u W=1u
M19634 o7 ibias vss vss sky130_fd_pr__nfet_01v8 L=0.5u W=1u
M19635 o7 ibias vss vss sky130_fd_pr__nfet_01v8 L=0.5u W=1u
M19636 o7 ibias vss vss sky130_fd_pr__nfet_01v8 L=0.5u W=1u
M19637 o7 ibias vss vss sky130_fd_pr__nfet_01v8 L=0.5u W=1u
M19638 o7 ibias vss vss sky130_fd_pr__nfet_01v8 L=0.5u W=1u
M19639 o7 ibias vss vss sky130_fd_pr__nfet_01v8 L=0.5u W=1u
M19640 o7 ibias vss vss sky130_fd_pr__nfet_01v8 L=0.5u W=1u
M19641 o7 ibias vss vss sky130_fd_pr__nfet_01v8 L=0.5u W=1u
M19642 o7 ibias vss vss sky130_fd_pr__nfet_01v8 L=0.5u W=1u
M19643 o7 ibias vss vss sky130_fd_pr__nfet_01v8 L=0.5u W=1u
M19644 o7 ibias vss vss sky130_fd_pr__nfet_01v8 L=0.5u W=1u
M19645 o7 ibias vss vss sky130_fd_pr__nfet_01v8 L=0.5u W=1u
M19646 o7 ibias vss vss sky130_fd_pr__nfet_01v8 L=0.5u W=1u
M19647 o7 ibias vss vss sky130_fd_pr__nfet_01v8 L=0.5u W=1u
M19648 o7 ibias vss vss sky130_fd_pr__nfet_01v8 L=0.5u W=1u
M19649 o7 ibias vss vss sky130_fd_pr__nfet_01v8 L=0.5u W=1u
M19650 o7 ibias vss vss sky130_fd_pr__nfet_01v8 L=0.5u W=1u
M19651 o7 ibias vss vss sky130_fd_pr__nfet_01v8 L=0.5u W=1u
M19652 o7 ibias vss vss sky130_fd_pr__nfet_01v8 L=0.5u W=1u
M19653 o7 ibias vss vss sky130_fd_pr__nfet_01v8 L=0.5u W=1u
M19654 o7 ibias vss vss sky130_fd_pr__nfet_01v8 L=0.5u W=1u
M19655 o7 ibias vss vss sky130_fd_pr__nfet_01v8 L=0.5u W=1u
M19656 o7 ibias vss vss sky130_fd_pr__nfet_01v8 L=0.5u W=1u
M19657 o7 ibias vss vss sky130_fd_pr__nfet_01v8 L=0.5u W=1u
M19658 o7 ibias vss vss sky130_fd_pr__nfet_01v8 L=0.5u W=1u
M19659 o7 ibias vss vss sky130_fd_pr__nfet_01v8 L=0.5u W=1u
M19660 o7 ibias vss vss sky130_fd_pr__nfet_01v8 L=0.5u W=1u
M19661 o7 ibias vss vss sky130_fd_pr__nfet_01v8 L=0.5u W=1u
M19662 o7 ibias vss vss sky130_fd_pr__nfet_01v8 L=0.5u W=1u
M19663 o7 ibias vss vss sky130_fd_pr__nfet_01v8 L=0.5u W=1u
M19664 o7 ibias vss vss sky130_fd_pr__nfet_01v8 L=0.5u W=1u
M19665 o7 ibias vss vss sky130_fd_pr__nfet_01v8 L=0.5u W=1u
M19666 o7 ibias vss vss sky130_fd_pr__nfet_01v8 L=0.5u W=1u
M19667 o7 ibias vss vss sky130_fd_pr__nfet_01v8 L=0.5u W=1u
M19668 o7 ibias vss vss sky130_fd_pr__nfet_01v8 L=0.5u W=1u
M19669 o7 ibias vss vss sky130_fd_pr__nfet_01v8 L=0.5u W=1u
M19670 o7 ibias vss vss sky130_fd_pr__nfet_01v8 L=0.5u W=1u
M19671 o7 ibias vss vss sky130_fd_pr__nfet_01v8 L=0.5u W=1u
M19672 o7 ibias vss vss sky130_fd_pr__nfet_01v8 L=0.5u W=1u
M19673 o7 ibias vss vss sky130_fd_pr__nfet_01v8 L=0.5u W=1u
M19674 o7 ibias vss vss sky130_fd_pr__nfet_01v8 L=0.5u W=1u
M19675 o7 ibias vss vss sky130_fd_pr__nfet_01v8 L=0.5u W=1u
M19676 o7 ibias vss vss sky130_fd_pr__nfet_01v8 L=0.5u W=1u
M19677 o7 ibias vss vss sky130_fd_pr__nfet_01v8 L=0.5u W=1u
M19678 o7 ibias vss vss sky130_fd_pr__nfet_01v8 L=0.5u W=1u
M19679 o7 ibias vss vss sky130_fd_pr__nfet_01v8 L=0.5u W=1u
M19680 o7 ibias vss vss sky130_fd_pr__nfet_01v8 L=0.5u W=1u
M19681 o7 ibias vss vss sky130_fd_pr__nfet_01v8 L=0.5u W=1u
M19682 o7 ibias vss vss sky130_fd_pr__nfet_01v8 L=0.5u W=1u
M19683 o7 ibias vss vss sky130_fd_pr__nfet_01v8 L=0.5u W=1u
M19684 o7 ibias vss vss sky130_fd_pr__nfet_01v8 L=0.5u W=1u
M19685 o7 ibias vss vss sky130_fd_pr__nfet_01v8 L=0.5u W=1u
M19686 o7 ibias vss vss sky130_fd_pr__nfet_01v8 L=0.5u W=1u
M19687 o7 ibias vss vss sky130_fd_pr__nfet_01v8 L=0.5u W=1u
M19688 o7 ibias vss vss sky130_fd_pr__nfet_01v8 L=0.5u W=1u
M19689 o7 ibias vss vss sky130_fd_pr__nfet_01v8 L=0.5u W=1u
M19690 o7 ibias vss vss sky130_fd_pr__nfet_01v8 L=0.5u W=1u
M19691 o7 ibias vss vss sky130_fd_pr__nfet_01v8 L=0.5u W=1u
M19692 o7 ibias vss vss sky130_fd_pr__nfet_01v8 L=0.5u W=1u
M19693 o7 ibias vss vss sky130_fd_pr__nfet_01v8 L=0.5u W=1u
M19694 o7 ibias vss vss sky130_fd_pr__nfet_01v8 L=0.5u W=1u
M19695 o7 ibias vss vss sky130_fd_pr__nfet_01v8 L=0.5u W=1u
M19696 o7 ibias vss vss sky130_fd_pr__nfet_01v8 L=0.5u W=1u
M19697 o7 ibias vss vss sky130_fd_pr__nfet_01v8 L=0.5u W=1u
M19698 o7 ibias vss vss sky130_fd_pr__nfet_01v8 L=0.5u W=1u
M19699 o7 ibias vss vss sky130_fd_pr__nfet_01v8 L=0.5u W=1u
M19700 o7 ibias vss vss sky130_fd_pr__nfet_01v8 L=0.5u W=1u
M19701 o7 ibias vss vss sky130_fd_pr__nfet_01v8 L=0.5u W=1u
M19702 o7 ibias vss vss sky130_fd_pr__nfet_01v8 L=0.5u W=1u
M19703 o7 ibias vss vss sky130_fd_pr__nfet_01v8 L=0.5u W=1u
M19704 o7 ibias vss vss sky130_fd_pr__nfet_01v8 L=0.5u W=1u
M19705 o7 ibias vss vss sky130_fd_pr__nfet_01v8 L=0.5u W=1u
M19706 o7 ibias vss vss sky130_fd_pr__nfet_01v8 L=0.5u W=1u
M19707 o7 ibias vss vss sky130_fd_pr__nfet_01v8 L=0.5u W=1u
M19708 o7 ibias vss vss sky130_fd_pr__nfet_01v8 L=0.5u W=1u
M19709 o7 ibias vss vss sky130_fd_pr__nfet_01v8 L=0.5u W=1u
M19710 o7 ibias vss vss sky130_fd_pr__nfet_01v8 L=0.5u W=1u
M19711 o7 ibias vss vss sky130_fd_pr__nfet_01v8 L=0.5u W=1u
M19712 o7 ibias vss vss sky130_fd_pr__nfet_01v8 L=0.5u W=1u
M19713 o7 ibias vss vss sky130_fd_pr__nfet_01v8 L=0.5u W=1u
M19714 o7 ibias vss vss sky130_fd_pr__nfet_01v8 L=0.5u W=1u
M19715 o7 ibias vss vss sky130_fd_pr__nfet_01v8 L=0.5u W=1u
M19716 o7 ibias vss vss sky130_fd_pr__nfet_01v8 L=0.5u W=1u
M19717 o7 ibias vss vss sky130_fd_pr__nfet_01v8 L=0.5u W=1u
M19718 o7 ibias vss vss sky130_fd_pr__nfet_01v8 L=0.5u W=1u
M19719 o7 ibias vss vss sky130_fd_pr__nfet_01v8 L=0.5u W=1u
M19720 o7 ibias vss vss sky130_fd_pr__nfet_01v8 L=0.5u W=1u
M19721 o7 ibias vss vss sky130_fd_pr__nfet_01v8 L=0.5u W=1u
M19722 o7 ibias vss vss sky130_fd_pr__nfet_01v8 L=0.5u W=1u
M19723 o7 ibias vss vss sky130_fd_pr__nfet_01v8 L=0.5u W=1u
M19724 o7 ibias vss vss sky130_fd_pr__nfet_01v8 L=0.5u W=1u
M19725 o7 ibias vss vss sky130_fd_pr__nfet_01v8 L=0.5u W=1u
M19726 o7 ibias vss vss sky130_fd_pr__nfet_01v8 L=0.5u W=1u
M19727 o7 ibias vss vss sky130_fd_pr__nfet_01v8 L=0.5u W=1u
M19728 o7 ibias vss vss sky130_fd_pr__nfet_01v8 L=0.5u W=1u
M19729 o7 ibias vss vss sky130_fd_pr__nfet_01v8 L=0.5u W=1u
M19730 o7 ibias vss vss sky130_fd_pr__nfet_01v8 L=0.5u W=1u
M19731 o7 ibias vss vss sky130_fd_pr__nfet_01v8 L=0.5u W=1u
M19732 o7 ibias vss vss sky130_fd_pr__nfet_01v8 L=0.5u W=1u
M19733 o7 ibias vss vss sky130_fd_pr__nfet_01v8 L=0.5u W=1u
M19734 o7 ibias vss vss sky130_fd_pr__nfet_01v8 L=0.5u W=1u
M19735 o7 ibias vss vss sky130_fd_pr__nfet_01v8 L=0.5u W=1u
M19736 o7 ibias vss vss sky130_fd_pr__nfet_01v8 L=0.5u W=1u
M19737 o7 ibias vss vss sky130_fd_pr__nfet_01v8 L=0.5u W=1u
M19738 o7 ibias vss vss sky130_fd_pr__nfet_01v8 L=0.5u W=1u
M19739 o7 ibias vss vss sky130_fd_pr__nfet_01v8 L=0.5u W=1u
M19740 o7 ibias vss vss sky130_fd_pr__nfet_01v8 L=0.5u W=1u
M19741 o7 ibias vss vss sky130_fd_pr__nfet_01v8 L=0.5u W=1u
M19742 o7 ibias vss vss sky130_fd_pr__nfet_01v8 L=0.5u W=1u
M19743 o7 ibias vss vss sky130_fd_pr__nfet_01v8 L=0.5u W=1u
M19744 o7 ibias vss vss sky130_fd_pr__nfet_01v8 L=0.5u W=1u
M19745 o7 ibias vss vss sky130_fd_pr__nfet_01v8 L=0.5u W=1u
M19746 o7 ibias vss vss sky130_fd_pr__nfet_01v8 L=0.5u W=1u
M19747 o7 ibias vss vss sky130_fd_pr__nfet_01v8 L=0.5u W=1u
M19748 o7 ibias vss vss sky130_fd_pr__nfet_01v8 L=0.5u W=1u
M19749 o7 ibias vss vss sky130_fd_pr__nfet_01v8 L=0.5u W=1u
M19750 o7 ibias vss vss sky130_fd_pr__nfet_01v8 L=0.5u W=1u
M19751 o7 ibias vss vss sky130_fd_pr__nfet_01v8 L=0.5u W=1u
M19752 o7 ibias vss vss sky130_fd_pr__nfet_01v8 L=0.5u W=1u
M19753 o7 ibias vss vss sky130_fd_pr__nfet_01v8 L=0.5u W=1u
M19754 o7 ibias vss vss sky130_fd_pr__nfet_01v8 L=0.5u W=1u
M19755 o7 ibias vss vss sky130_fd_pr__nfet_01v8 L=0.5u W=1u
M19756 o7 ibias vss vss sky130_fd_pr__nfet_01v8 L=0.5u W=1u
M19757 o7 ibias vss vss sky130_fd_pr__nfet_01v8 L=0.5u W=1u
M19758 o7 ibias vss vss sky130_fd_pr__nfet_01v8 L=0.5u W=1u
M19759 o7 ibias vss vss sky130_fd_pr__nfet_01v8 L=0.5u W=1u
M19760 o7 ibias vss vss sky130_fd_pr__nfet_01v8 L=0.5u W=1u
M19761 o7 ibias vss vss sky130_fd_pr__nfet_01v8 L=0.5u W=1u
M19762 o7 ibias vss vss sky130_fd_pr__nfet_01v8 L=0.5u W=1u
M19763 o7 ibias vss vss sky130_fd_pr__nfet_01v8 L=0.5u W=1u
M19764 o7 ibias vss vss sky130_fd_pr__nfet_01v8 L=0.5u W=1u
M19765 o7 ibias vss vss sky130_fd_pr__nfet_01v8 L=0.5u W=1u
M19766 o7 ibias vss vss sky130_fd_pr__nfet_01v8 L=0.5u W=1u
M19767 o7 ibias vss vss sky130_fd_pr__nfet_01v8 L=0.5u W=1u
M19768 o7 ibias vss vss sky130_fd_pr__nfet_01v8 L=0.5u W=1u
M19769 o7 ibias vss vss sky130_fd_pr__nfet_01v8 L=0.5u W=1u
M19770 o7 ibias vss vss sky130_fd_pr__nfet_01v8 L=0.5u W=1u
M19771 o7 ibias vss vss sky130_fd_pr__nfet_01v8 L=0.5u W=1u
M19772 o7 ibias vss vss sky130_fd_pr__nfet_01v8 L=0.5u W=1u
M19773 o7 ibias vss vss sky130_fd_pr__nfet_01v8 L=0.5u W=1u
M19774 o7 ibias vss vss sky130_fd_pr__nfet_01v8 L=0.5u W=1u
M19775 o7 ibias vss vss sky130_fd_pr__nfet_01v8 L=0.5u W=1u
M19776 o7 ibias vss vss sky130_fd_pr__nfet_01v8 L=0.5u W=1u
M19777 o7 ibias vss vss sky130_fd_pr__nfet_01v8 L=0.5u W=1u
M19778 o7 ibias vss vss sky130_fd_pr__nfet_01v8 L=0.5u W=1u
M19779 o7 ibias vss vss sky130_fd_pr__nfet_01v8 L=0.5u W=1u
M19780 o7 ibias vss vss sky130_fd_pr__nfet_01v8 L=0.5u W=1u
M19781 o7 ibias vss vss sky130_fd_pr__nfet_01v8 L=0.5u W=1u
M19782 o7 ibias vss vss sky130_fd_pr__nfet_01v8 L=0.5u W=1u
M19783 o7 ibias vss vss sky130_fd_pr__nfet_01v8 L=0.5u W=1u
M19784 o7 ibias vss vss sky130_fd_pr__nfet_01v8 L=0.5u W=1u
M19785 o7 ibias vss vss sky130_fd_pr__nfet_01v8 L=0.5u W=1u
M19786 o7 ibias vss vss sky130_fd_pr__nfet_01v8 L=0.5u W=1u
M19787 o7 ibias vss vss sky130_fd_pr__nfet_01v8 L=0.5u W=1u
M19788 o7 ibias vss vss sky130_fd_pr__nfet_01v8 L=0.5u W=1u
M19789 o7 ibias vss vss sky130_fd_pr__nfet_01v8 L=0.5u W=1u
M19790 o7 ibias vss vss sky130_fd_pr__nfet_01v8 L=0.5u W=1u
M19791 o7 ibias vss vss sky130_fd_pr__nfet_01v8 L=0.5u W=1u
M19792 o7 ibias vss vss sky130_fd_pr__nfet_01v8 L=0.5u W=1u
M19793 o7 ibias vss vss sky130_fd_pr__nfet_01v8 L=0.5u W=1u
M19794 o7 ibias vss vss sky130_fd_pr__nfet_01v8 L=0.5u W=1u
M19795 o7 ibias vss vss sky130_fd_pr__nfet_01v8 L=0.5u W=1u
M19796 o7 ibias vss vss sky130_fd_pr__nfet_01v8 L=0.5u W=1u
M19797 o7 ibias vss vss sky130_fd_pr__nfet_01v8 L=0.5u W=1u
M19798 o7 ibias vss vss sky130_fd_pr__nfet_01v8 L=0.5u W=1u
M19799 o7 ibias vss vss sky130_fd_pr__nfet_01v8 L=0.5u W=1u
M19800 o7 ibias vss vss sky130_fd_pr__nfet_01v8 L=0.5u W=1u
M19801 o7 ibias vss vss sky130_fd_pr__nfet_01v8 L=0.5u W=1u
M19802 o7 ibias vss vss sky130_fd_pr__nfet_01v8 L=0.5u W=1u
M19803 o7 ibias vss vss sky130_fd_pr__nfet_01v8 L=0.5u W=1u
M19804 o7 ibias vss vss sky130_fd_pr__nfet_01v8 L=0.5u W=1u
M19805 o7 ibias vss vss sky130_fd_pr__nfet_01v8 L=0.5u W=1u
M19806 o7 ibias vss vss sky130_fd_pr__nfet_01v8 L=0.5u W=1u
M19807 o7 ibias vss vss sky130_fd_pr__nfet_01v8 L=0.5u W=1u
M19808 o7 ibias vss vss sky130_fd_pr__nfet_01v8 L=0.5u W=1u
M19809 o7 ibias vss vss sky130_fd_pr__nfet_01v8 L=0.5u W=1u
M19810 o7 ibias vss vss sky130_fd_pr__nfet_01v8 L=0.5u W=1u
M19811 o7 ibias vss vss sky130_fd_pr__nfet_01v8 L=0.5u W=1u
M19812 o7 ibias vss vss sky130_fd_pr__nfet_01v8 L=0.5u W=1u
M19813 o7 ibias vss vss sky130_fd_pr__nfet_01v8 L=0.5u W=1u
M19814 o7 ibias vss vss sky130_fd_pr__nfet_01v8 L=0.5u W=1u
M19815 o7 ibias vss vss sky130_fd_pr__nfet_01v8 L=0.5u W=1u
M19816 o7 ibias vss vss sky130_fd_pr__nfet_01v8 L=0.5u W=1u
M19817 o7 ibias vss vss sky130_fd_pr__nfet_01v8 L=0.5u W=1u
M19818 o7 ibias vss vss sky130_fd_pr__nfet_01v8 L=0.5u W=1u
M19819 o7 ibias vss vss sky130_fd_pr__nfet_01v8 L=0.5u W=1u
M19820 o7 ibias vss vss sky130_fd_pr__nfet_01v8 L=0.5u W=1u
M19821 o7 ibias vss vss sky130_fd_pr__nfet_01v8 L=0.5u W=1u
M19822 o7 ibias vss vss sky130_fd_pr__nfet_01v8 L=0.5u W=1u
M19823 o7 ibias vss vss sky130_fd_pr__nfet_01v8 L=0.5u W=1u
M19824 o7 ibias vss vss sky130_fd_pr__nfet_01v8 L=0.5u W=1u
M19825 o7 ibias vss vss sky130_fd_pr__nfet_01v8 L=0.5u W=1u
M19826 o7 ibias vss vss sky130_fd_pr__nfet_01v8 L=0.5u W=1u
M19827 o7 ibias vss vss sky130_fd_pr__nfet_01v8 L=0.5u W=1u
M19828 o7 ibias vss vss sky130_fd_pr__nfet_01v8 L=0.5u W=1u
M19829 o7 ibias vss vss sky130_fd_pr__nfet_01v8 L=0.5u W=1u
M19830 o7 ibias vss vss sky130_fd_pr__nfet_01v8 L=0.5u W=1u
M19831 o7 ibias vss vss sky130_fd_pr__nfet_01v8 L=0.5u W=1u
M19832 o7 ibias vss vss sky130_fd_pr__nfet_01v8 L=0.5u W=1u
M19833 o7 ibias vss vss sky130_fd_pr__nfet_01v8 L=0.5u W=1u
M19834 o7 ibias vss vss sky130_fd_pr__nfet_01v8 L=0.5u W=1u
M19835 o7 ibias vss vss sky130_fd_pr__nfet_01v8 L=0.5u W=1u
M19836 o7 ibias vss vss sky130_fd_pr__nfet_01v8 L=0.5u W=1u
M19837 o7 ibias vss vss sky130_fd_pr__nfet_01v8 L=0.5u W=1u
M19838 o7 ibias vss vss sky130_fd_pr__nfet_01v8 L=0.5u W=1u
M19839 o7 ibias vss vss sky130_fd_pr__nfet_01v8 L=0.5u W=1u
M19840 o7 ibias vss vss sky130_fd_pr__nfet_01v8 L=0.5u W=1u
M19841 o7 ibias vss vss sky130_fd_pr__nfet_01v8 L=0.5u W=1u
M19842 o7 ibias vss vss sky130_fd_pr__nfet_01v8 L=0.5u W=1u
M19843 o7 ibias vss vss sky130_fd_pr__nfet_01v8 L=0.5u W=1u
M19844 o7 ibias vss vss sky130_fd_pr__nfet_01v8 L=0.5u W=1u
M19845 o7 ibias vss vss sky130_fd_pr__nfet_01v8 L=0.5u W=1u
M19846 o7 ibias vss vss sky130_fd_pr__nfet_01v8 L=0.5u W=1u
M19847 o7 ibias vss vss sky130_fd_pr__nfet_01v8 L=0.5u W=1u
M19848 o7 ibias vss vss sky130_fd_pr__nfet_01v8 L=0.5u W=1u
M19849 o7 ibias vss vss sky130_fd_pr__nfet_01v8 L=0.5u W=1u
M19850 o7 ibias vss vss sky130_fd_pr__nfet_01v8 L=0.5u W=1u
M19851 o7 ibias vss vss sky130_fd_pr__nfet_01v8 L=0.5u W=1u
M19852 o7 ibias vss vss sky130_fd_pr__nfet_01v8 L=0.5u W=1u
M19853 o7 ibias vss vss sky130_fd_pr__nfet_01v8 L=0.5u W=1u
M19854 o7 ibias vss vss sky130_fd_pr__nfet_01v8 L=0.5u W=1u
M19855 o7 ibias vss vss sky130_fd_pr__nfet_01v8 L=0.5u W=1u
M19856 o7 ibias vss vss sky130_fd_pr__nfet_01v8 L=0.5u W=1u
M19857 o7 ibias vss vss sky130_fd_pr__nfet_01v8 L=0.5u W=1u
M19858 o7 ibias vss vss sky130_fd_pr__nfet_01v8 L=0.5u W=1u
M19859 o7 ibias vss vss sky130_fd_pr__nfet_01v8 L=0.5u W=1u
M19860 o7 ibias vss vss sky130_fd_pr__nfet_01v8 L=0.5u W=1u
M19861 o7 ibias vss vss sky130_fd_pr__nfet_01v8 L=0.5u W=1u
M19862 o7 ibias vss vss sky130_fd_pr__nfet_01v8 L=0.5u W=1u
M19863 o7 ibias vss vss sky130_fd_pr__nfet_01v8 L=0.5u W=1u
M19864 o7 ibias vss vss sky130_fd_pr__nfet_01v8 L=0.5u W=1u
M19865 o7 ibias vss vss sky130_fd_pr__nfet_01v8 L=0.5u W=1u
M19866 o7 ibias vss vss sky130_fd_pr__nfet_01v8 L=0.5u W=1u
M19867 o7 ibias vss vss sky130_fd_pr__nfet_01v8 L=0.5u W=1u
M19868 o7 ibias vss vss sky130_fd_pr__nfet_01v8 L=0.5u W=1u
M19869 o7 ibias vss vss sky130_fd_pr__nfet_01v8 L=0.5u W=1u
M19870 o7 ibias vss vss sky130_fd_pr__nfet_01v8 L=0.5u W=1u
M19871 o7 ibias vss vss sky130_fd_pr__nfet_01v8 L=0.5u W=1u
M19872 o7 ibias vss vss sky130_fd_pr__nfet_01v8 L=0.5u W=1u
M19873 o7 ibias vss vss sky130_fd_pr__nfet_01v8 L=0.5u W=1u
M19874 o7 ibias vss vss sky130_fd_pr__nfet_01v8 L=0.5u W=1u
M19875 o7 ibias vss vss sky130_fd_pr__nfet_01v8 L=0.5u W=1u
M19876 o7 ibias vss vss sky130_fd_pr__nfet_01v8 L=0.5u W=1u
M19877 o7 ibias vss vss sky130_fd_pr__nfet_01v8 L=0.5u W=1u
M19878 o7 ibias vss vss sky130_fd_pr__nfet_01v8 L=0.5u W=1u
M19879 o7 ibias vss vss sky130_fd_pr__nfet_01v8 L=0.5u W=1u
M19880 o7 ibias vss vss sky130_fd_pr__nfet_01v8 L=0.5u W=1u
M19881 o7 ibias vss vss sky130_fd_pr__nfet_01v8 L=0.5u W=1u
M19882 o7 ibias vss vss sky130_fd_pr__nfet_01v8 L=0.5u W=1u
M19883 o7 ibias vss vss sky130_fd_pr__nfet_01v8 L=0.5u W=1u
M19884 o7 ibias vss vss sky130_fd_pr__nfet_01v8 L=0.5u W=1u
M19885 o7 ibias vss vss sky130_fd_pr__nfet_01v8 L=0.5u W=1u
M19886 o7 ibias vss vss sky130_fd_pr__nfet_01v8 L=0.5u W=1u
M19887 o7 ibias vss vss sky130_fd_pr__nfet_01v8 L=0.5u W=1u
M19888 o7 ibias vss vss sky130_fd_pr__nfet_01v8 L=0.5u W=1u
M19889 o7 ibias vss vss sky130_fd_pr__nfet_01v8 L=0.5u W=1u
M19890 o7 ibias vss vss sky130_fd_pr__nfet_01v8 L=0.5u W=1u
M19891 o7 ibias vss vss sky130_fd_pr__nfet_01v8 L=0.5u W=1u
M19892 o7 ibias vss vss sky130_fd_pr__nfet_01v8 L=0.5u W=1u
M19893 o7 ibias vss vss sky130_fd_pr__nfet_01v8 L=0.5u W=1u
M19894 o7 ibias vss vss sky130_fd_pr__nfet_01v8 L=0.5u W=1u
M19895 o7 ibias vss vss sky130_fd_pr__nfet_01v8 L=0.5u W=1u
M19896 o7 ibias vss vss sky130_fd_pr__nfet_01v8 L=0.5u W=1u
M19897 o7 ibias vss vss sky130_fd_pr__nfet_01v8 L=0.5u W=1u
M19898 o7 ibias vss vss sky130_fd_pr__nfet_01v8 L=0.5u W=1u
M19899 o7 ibias vss vss sky130_fd_pr__nfet_01v8 L=0.5u W=1u
M19900 o7 ibias vss vss sky130_fd_pr__nfet_01v8 L=0.5u W=1u
M19901 o7 ibias vss vss sky130_fd_pr__nfet_01v8 L=0.5u W=1u
M19902 o7 ibias vss vss sky130_fd_pr__nfet_01v8 L=0.5u W=1u
M19903 o7 ibias vss vss sky130_fd_pr__nfet_01v8 L=0.5u W=1u
M19904 o7 ibias vss vss sky130_fd_pr__nfet_01v8 L=0.5u W=1u
M19905 o7 ibias vss vss sky130_fd_pr__nfet_01v8 L=0.5u W=1u
M19906 o7 ibias vss vss sky130_fd_pr__nfet_01v8 L=0.5u W=1u
M19907 o7 ibias vss vss sky130_fd_pr__nfet_01v8 L=0.5u W=1u
M19908 o7 ibias vss vss sky130_fd_pr__nfet_01v8 L=0.5u W=1u
M19909 o7 ibias vss vss sky130_fd_pr__nfet_01v8 L=0.5u W=1u
M19910 o7 ibias vss vss sky130_fd_pr__nfet_01v8 L=0.5u W=1u
M19911 o7 ibias vss vss sky130_fd_pr__nfet_01v8 L=0.5u W=1u
M19912 o7 ibias vss vss sky130_fd_pr__nfet_01v8 L=0.5u W=1u
M19913 o7 ibias vss vss sky130_fd_pr__nfet_01v8 L=0.5u W=1u
M19914 o7 ibias vss vss sky130_fd_pr__nfet_01v8 L=0.5u W=1u
M19915 o7 ibias vss vss sky130_fd_pr__nfet_01v8 L=0.5u W=1u
M19916 o7 ibias vss vss sky130_fd_pr__nfet_01v8 L=0.5u W=1u
M19917 o7 ibias vss vss sky130_fd_pr__nfet_01v8 L=0.5u W=1u
M19918 o7 ibias vss vss sky130_fd_pr__nfet_01v8 L=0.5u W=1u
M19919 o7 ibias vss vss sky130_fd_pr__nfet_01v8 L=0.5u W=1u
M19920 o7 ibias vss vss sky130_fd_pr__nfet_01v8 L=0.5u W=1u
M19921 o7 ibias vss vss sky130_fd_pr__nfet_01v8 L=0.5u W=1u
M19922 o7 ibias vss vss sky130_fd_pr__nfet_01v8 L=0.5u W=1u
M19923 o7 ibias vss vss sky130_fd_pr__nfet_01v8 L=0.5u W=1u
M19924 o7 ibias vss vss sky130_fd_pr__nfet_01v8 L=0.5u W=1u
M19925 o7 ibias vss vss sky130_fd_pr__nfet_01v8 L=0.5u W=1u
M19926 o7 ibias vss vss sky130_fd_pr__nfet_01v8 L=0.5u W=1u
M19927 o7 ibias vss vss sky130_fd_pr__nfet_01v8 L=0.5u W=1u
M19928 o7 ibias vss vss sky130_fd_pr__nfet_01v8 L=0.5u W=1u
M19929 o7 ibias vss vss sky130_fd_pr__nfet_01v8 L=0.5u W=1u
M19930 o7 ibias vss vss sky130_fd_pr__nfet_01v8 L=0.5u W=1u
M19931 o7 ibias vss vss sky130_fd_pr__nfet_01v8 L=0.5u W=1u
M19932 o7 ibias vss vss sky130_fd_pr__nfet_01v8 L=0.5u W=1u
M19933 o7 ibias vss vss sky130_fd_pr__nfet_01v8 L=0.5u W=1u
M19934 o7 ibias vss vss sky130_fd_pr__nfet_01v8 L=0.5u W=1u
M19935 o7 ibias vss vss sky130_fd_pr__nfet_01v8 L=0.5u W=1u
M19936 o7 ibias vss vss sky130_fd_pr__nfet_01v8 L=0.5u W=1u
M19937 o7 ibias vss vss sky130_fd_pr__nfet_01v8 L=0.5u W=1u
M19938 o7 ibias vss vss sky130_fd_pr__nfet_01v8 L=0.5u W=1u
M19939 o7 ibias vss vss sky130_fd_pr__nfet_01v8 L=0.5u W=1u
M19940 o7 ibias vss vss sky130_fd_pr__nfet_01v8 L=0.5u W=1u
M19941 o7 ibias vss vss sky130_fd_pr__nfet_01v8 L=0.5u W=1u
M19942 o7 ibias vss vss sky130_fd_pr__nfet_01v8 L=0.5u W=1u
M19943 o7 ibias vss vss sky130_fd_pr__nfet_01v8 L=0.5u W=1u
M19944 o7 ibias vss vss sky130_fd_pr__nfet_01v8 L=0.5u W=1u
M19945 o7 ibias vss vss sky130_fd_pr__nfet_01v8 L=0.5u W=1u
M19946 o7 ibias vss vss sky130_fd_pr__nfet_01v8 L=0.5u W=1u
M19947 o7 ibias vss vss sky130_fd_pr__nfet_01v8 L=0.5u W=1u
M19948 o7 ibias vss vss sky130_fd_pr__nfet_01v8 L=0.5u W=1u
M19949 o7 ibias vss vss sky130_fd_pr__nfet_01v8 L=0.5u W=1u
M19950 o7 ibias vss vss sky130_fd_pr__nfet_01v8 L=0.5u W=1u
M19951 o7 ibias vss vss sky130_fd_pr__nfet_01v8 L=0.5u W=1u
M19952 o7 ibias vss vss sky130_fd_pr__nfet_01v8 L=0.5u W=1u
M19953 o7 ibias vss vss sky130_fd_pr__nfet_01v8 L=0.5u W=1u
M19954 o7 ibias vss vss sky130_fd_pr__nfet_01v8 L=0.5u W=1u
M19955 o7 ibias vss vss sky130_fd_pr__nfet_01v8 L=0.5u W=1u
M19956 o7 ibias vss vss sky130_fd_pr__nfet_01v8 L=0.5u W=1u
M19957 o7 ibias vss vss sky130_fd_pr__nfet_01v8 L=0.5u W=1u
M19958 o7 ibias vss vss sky130_fd_pr__nfet_01v8 L=0.5u W=1u
M19959 o7 ibias vss vss sky130_fd_pr__nfet_01v8 L=0.5u W=1u
M19960 o7 ibias vss vss sky130_fd_pr__nfet_01v8 L=0.5u W=1u
M19961 o7 ibias vss vss sky130_fd_pr__nfet_01v8 L=0.5u W=1u
M19962 o7 ibias vss vss sky130_fd_pr__nfet_01v8 L=0.5u W=1u
M19963 o7 ibias vss vss sky130_fd_pr__nfet_01v8 L=0.5u W=1u
M19964 o7 ibias vss vss sky130_fd_pr__nfet_01v8 L=0.5u W=1u
M19965 o7 ibias vss vss sky130_fd_pr__nfet_01v8 L=0.5u W=1u
M19966 o7 ibias vss vss sky130_fd_pr__nfet_01v8 L=0.5u W=1u
M19967 o7 ibias vss vss sky130_fd_pr__nfet_01v8 L=0.5u W=1u
M19968 o7 ibias vss vss sky130_fd_pr__nfet_01v8 L=0.5u W=1u
M19969 o7 ibias vss vss sky130_fd_pr__nfet_01v8 L=0.5u W=1u
M19970 o7 ibias vss vss sky130_fd_pr__nfet_01v8 L=0.5u W=1u
M19971 o7 ibias vss vss sky130_fd_pr__nfet_01v8 L=0.5u W=1u
M19972 o7 ibias vss vss sky130_fd_pr__nfet_01v8 L=0.5u W=1u
M19973 o7 ibias vss vss sky130_fd_pr__nfet_01v8 L=0.5u W=1u
M19974 o7 ibias vss vss sky130_fd_pr__nfet_01v8 L=0.5u W=1u
M19975 o7 ibias vss vss sky130_fd_pr__nfet_01v8 L=0.5u W=1u
M19976 o7 ibias vss vss sky130_fd_pr__nfet_01v8 L=0.5u W=1u
M19977 o7 ibias vss vss sky130_fd_pr__nfet_01v8 L=0.5u W=1u
M19978 o7 ibias vss vss sky130_fd_pr__nfet_01v8 L=0.5u W=1u
M19979 o7 ibias vss vss sky130_fd_pr__nfet_01v8 L=0.5u W=1u
M19980 o7 ibias vss vss sky130_fd_pr__nfet_01v8 L=0.5u W=1u
M19981 o7 ibias vss vss sky130_fd_pr__nfet_01v8 L=0.5u W=1u
M19982 o7 ibias vss vss sky130_fd_pr__nfet_01v8 L=0.5u W=1u
M19983 o7 ibias vss vss sky130_fd_pr__nfet_01v8 L=0.5u W=1u
M19984 o7 ibias vss vss sky130_fd_pr__nfet_01v8 L=0.5u W=1u
M19985 o7 ibias vss vss sky130_fd_pr__nfet_01v8 L=0.5u W=1u
M19986 o7 ibias vss vss sky130_fd_pr__nfet_01v8 L=0.5u W=1u
M19987 o7 ibias vss vss sky130_fd_pr__nfet_01v8 L=0.5u W=1u
M19988 o7 ibias vss vss sky130_fd_pr__nfet_01v8 L=0.5u W=1u
M19989 o7 ibias vss vss sky130_fd_pr__nfet_01v8 L=0.5u W=1u
M19990 o7 ibias vss vss sky130_fd_pr__nfet_01v8 L=0.5u W=1u
M19991 o7 ibias vss vss sky130_fd_pr__nfet_01v8 L=0.5u W=1u
M19992 o7 ibias vss vss sky130_fd_pr__nfet_01v8 L=0.5u W=1u
M19993 o7 ibias vss vss sky130_fd_pr__nfet_01v8 L=0.5u W=1u
M19994 o7 ibias vss vss sky130_fd_pr__nfet_01v8 L=0.5u W=1u
M19995 o7 ibias vss vss sky130_fd_pr__nfet_01v8 L=0.5u W=1u
M19996 o7 ibias vss vss sky130_fd_pr__nfet_01v8 L=0.5u W=1u
M19997 o7 ibias vss vss sky130_fd_pr__nfet_01v8 L=0.5u W=1u
M19998 o7 ibias vss vss sky130_fd_pr__nfet_01v8 L=0.5u W=1u
M19999 o7 ibias vss vss sky130_fd_pr__nfet_01v8 L=0.5u W=1u
M20000 o7 ibias vss vss sky130_fd_pr__nfet_01v8 L=0.5u W=1u
M20001 o7 ibias vss vss sky130_fd_pr__nfet_01v8 L=0.5u W=1u
M20002 o7 ibias vss vss sky130_fd_pr__nfet_01v8 L=0.5u W=1u
M20003 o7 ibias vss vss sky130_fd_pr__nfet_01v8 L=0.5u W=1u
M20004 o7 ibias vss vss sky130_fd_pr__nfet_01v8 L=0.5u W=1u
M20005 o7 ibias vss vss sky130_fd_pr__nfet_01v8 L=0.5u W=1u
M20006 o7 ibias vss vss sky130_fd_pr__nfet_01v8 L=0.5u W=1u
M20007 o7 ibias vss vss sky130_fd_pr__nfet_01v8 L=0.5u W=1u
M20008 o7 ibias vss vss sky130_fd_pr__nfet_01v8 L=0.5u W=1u
M20009 o7 ibias vss vss sky130_fd_pr__nfet_01v8 L=0.5u W=1u
M20010 o7 ibias vss vss sky130_fd_pr__nfet_01v8 L=0.5u W=1u
M20011 o7 ibias vss vss sky130_fd_pr__nfet_01v8 L=0.5u W=1u
M20012 o7 ibias vss vss sky130_fd_pr__nfet_01v8 L=0.5u W=1u
M20013 o7 ibias vss vss sky130_fd_pr__nfet_01v8 L=0.5u W=1u
M20014 o7 ibias vss vss sky130_fd_pr__nfet_01v8 L=0.5u W=1u
M20015 o7 ibias vss vss sky130_fd_pr__nfet_01v8 L=0.5u W=1u
M20016 o7 ibias vss vss sky130_fd_pr__nfet_01v8 L=0.5u W=1u
M20017 o7 ibias vss vss sky130_fd_pr__nfet_01v8 L=0.5u W=1u
M20018 o7 ibias vss vss sky130_fd_pr__nfet_01v8 L=0.5u W=1u
M20019 o7 ibias vss vss sky130_fd_pr__nfet_01v8 L=0.5u W=1u
M20020 o7 ibias vss vss sky130_fd_pr__nfet_01v8 L=0.5u W=1u
M20021 o7 ibias vss vss sky130_fd_pr__nfet_01v8 L=0.5u W=1u
M20022 o7 ibias vss vss sky130_fd_pr__nfet_01v8 L=0.5u W=1u
M20023 o7 ibias vss vss sky130_fd_pr__nfet_01v8 L=0.5u W=1u
M20024 o7 ibias vss vss sky130_fd_pr__nfet_01v8 L=0.5u W=1u
M20025 o7 ibias vss vss sky130_fd_pr__nfet_01v8 L=0.5u W=1u
M20026 o7 ibias vss vss sky130_fd_pr__nfet_01v8 L=0.5u W=1u
M20027 o7 ibias vss vss sky130_fd_pr__nfet_01v8 L=0.5u W=1u
M20028 o7 ibias vss vss sky130_fd_pr__nfet_01v8 L=0.5u W=1u
M20029 o7 ibias vss vss sky130_fd_pr__nfet_01v8 L=0.5u W=1u
M20030 o7 ibias vss vss sky130_fd_pr__nfet_01v8 L=0.5u W=1u
M20031 o7 ibias vss vss sky130_fd_pr__nfet_01v8 L=0.5u W=1u
M20032 o7 ibias vss vss sky130_fd_pr__nfet_01v8 L=0.5u W=1u
M20033 o7 ibias vss vss sky130_fd_pr__nfet_01v8 L=0.5u W=1u
M20034 o7 ibias vss vss sky130_fd_pr__nfet_01v8 L=0.5u W=1u
M20035 o7 ibias vss vss sky130_fd_pr__nfet_01v8 L=0.5u W=1u
M20036 o7 ibias vss vss sky130_fd_pr__nfet_01v8 L=0.5u W=1u
M20037 o7 ibias vss vss sky130_fd_pr__nfet_01v8 L=0.5u W=1u
M20038 o7 ibias vss vss sky130_fd_pr__nfet_01v8 L=0.5u W=1u
M20039 o7 ibias vss vss sky130_fd_pr__nfet_01v8 L=0.5u W=1u
M20040 o7 ibias vss vss sky130_fd_pr__nfet_01v8 L=0.5u W=1u
M20041 o7 ibias vss vss sky130_fd_pr__nfet_01v8 L=0.5u W=1u
M20042 o7 ibias vss vss sky130_fd_pr__nfet_01v8 L=0.5u W=1u
M20043 o7 ibias vss vss sky130_fd_pr__nfet_01v8 L=0.5u W=1u
M20044 o7 ibias vss vss sky130_fd_pr__nfet_01v8 L=0.5u W=1u
M20045 o7 ibias vss vss sky130_fd_pr__nfet_01v8 L=0.5u W=1u
M20046 o7 ibias vss vss sky130_fd_pr__nfet_01v8 L=0.5u W=1u
M20047 o7 ibias vss vss sky130_fd_pr__nfet_01v8 L=0.5u W=1u
M20048 o7 ibias vss vss sky130_fd_pr__nfet_01v8 L=0.5u W=1u
M20049 o7 ibias vss vss sky130_fd_pr__nfet_01v8 L=0.5u W=1u
M20050 o7 ibias vss vss sky130_fd_pr__nfet_01v8 L=0.5u W=1u
M20051 o7 ibias vss vss sky130_fd_pr__nfet_01v8 L=0.5u W=1u
M20052 o7 ibias vss vss sky130_fd_pr__nfet_01v8 L=0.5u W=1u
M20053 o7 ibias vss vss sky130_fd_pr__nfet_01v8 L=0.5u W=1u
M20054 o7 ibias vss vss sky130_fd_pr__nfet_01v8 L=0.5u W=1u
M20055 o7 ibias vss vss sky130_fd_pr__nfet_01v8 L=0.5u W=1u
M20056 o7 ibias vss vss sky130_fd_pr__nfet_01v8 L=0.5u W=1u
M20057 o7 ibias vss vss sky130_fd_pr__nfet_01v8 L=0.5u W=1u
M20058 o7 ibias vss vss sky130_fd_pr__nfet_01v8 L=0.5u W=1u
M20059 o7 ibias vss vss sky130_fd_pr__nfet_01v8 L=0.5u W=1u
M20060 o7 ibias vss vss sky130_fd_pr__nfet_01v8 L=0.5u W=1u
M20061 o7 ibias vss vss sky130_fd_pr__nfet_01v8 L=0.5u W=1u
M20062 o7 ibias vss vss sky130_fd_pr__nfet_01v8 L=0.5u W=1u
M20063 o7 ibias vss vss sky130_fd_pr__nfet_01v8 L=0.5u W=1u
M20064 o7 ibias vss vss sky130_fd_pr__nfet_01v8 L=0.5u W=1u
M20065 o7 ibias vss vss sky130_fd_pr__nfet_01v8 L=0.5u W=1u
M20066 o7 ibias vss vss sky130_fd_pr__nfet_01v8 L=0.5u W=1u
M20067 o7 ibias vss vss sky130_fd_pr__nfet_01v8 L=0.5u W=1u
M20068 o7 ibias vss vss sky130_fd_pr__nfet_01v8 L=0.5u W=1u
M20069 o7 ibias vss vss sky130_fd_pr__nfet_01v8 L=0.5u W=1u
M20070 o7 ibias vss vss sky130_fd_pr__nfet_01v8 L=0.5u W=1u
M20071 o7 ibias vss vss sky130_fd_pr__nfet_01v8 L=0.5u W=1u
M20072 o7 ibias vss vss sky130_fd_pr__nfet_01v8 L=0.5u W=1u
M20073 o7 ibias vss vss sky130_fd_pr__nfet_01v8 L=0.5u W=1u
M20074 o7 ibias vss vss sky130_fd_pr__nfet_01v8 L=0.5u W=1u
M20075 o7 ibias vss vss sky130_fd_pr__nfet_01v8 L=0.5u W=1u
M20076 o7 ibias vss vss sky130_fd_pr__nfet_01v8 L=0.5u W=1u
M20077 o7 ibias vss vss sky130_fd_pr__nfet_01v8 L=0.5u W=1u
M20078 o7 ibias vss vss sky130_fd_pr__nfet_01v8 L=0.5u W=1u
M20079 o7 ibias vss vss sky130_fd_pr__nfet_01v8 L=0.5u W=1u
M20080 o7 ibias vss vss sky130_fd_pr__nfet_01v8 L=0.5u W=1u
M20081 o7 ibias vss vss sky130_fd_pr__nfet_01v8 L=0.5u W=1u
M20082 o7 ibias vss vss sky130_fd_pr__nfet_01v8 L=0.5u W=1u
M20083 o7 ibias vss vss sky130_fd_pr__nfet_01v8 L=0.5u W=1u
M20084 o7 ibias vss vss sky130_fd_pr__nfet_01v8 L=0.5u W=1u
M20085 o7 ibias vss vss sky130_fd_pr__nfet_01v8 L=0.5u W=1u
M20086 o7 ibias vss vss sky130_fd_pr__nfet_01v8 L=0.5u W=1u
M20087 o7 ibias vss vss sky130_fd_pr__nfet_01v8 L=0.5u W=1u
M20088 o7 ibias vss vss sky130_fd_pr__nfet_01v8 L=0.5u W=1u
M20089 o7 ibias vss vss sky130_fd_pr__nfet_01v8 L=0.5u W=1u
M20090 o7 ibias vss vss sky130_fd_pr__nfet_01v8 L=0.5u W=1u
M20091 o7 ibias vss vss sky130_fd_pr__nfet_01v8 L=0.5u W=1u
M20092 o7 ibias vss vss sky130_fd_pr__nfet_01v8 L=0.5u W=1u
M20093 o7 ibias vss vss sky130_fd_pr__nfet_01v8 L=0.5u W=1u
M20094 o7 ibias vss vss sky130_fd_pr__nfet_01v8 L=0.5u W=1u
M20095 o7 ibias vss vss sky130_fd_pr__nfet_01v8 L=0.5u W=1u
M20096 o7 ibias vss vss sky130_fd_pr__nfet_01v8 L=0.5u W=1u
M20097 o7 ibias vss vss sky130_fd_pr__nfet_01v8 L=0.5u W=1u
M20098 o7 ibias vss vss sky130_fd_pr__nfet_01v8 L=0.5u W=1u
M20099 o7 ibias vss vss sky130_fd_pr__nfet_01v8 L=0.5u W=1u
M20100 o7 ibias vss vss sky130_fd_pr__nfet_01v8 L=0.5u W=1u
M20101 o7 ibias vss vss sky130_fd_pr__nfet_01v8 L=0.5u W=1u
M20102 o7 ibias vss vss sky130_fd_pr__nfet_01v8 L=0.5u W=1u
M20103 o7 ibias vss vss sky130_fd_pr__nfet_01v8 L=0.5u W=1u
M20104 o7 ibias vss vss sky130_fd_pr__nfet_01v8 L=0.5u W=1u
M20105 o7 ibias vss vss sky130_fd_pr__nfet_01v8 L=0.5u W=1u
M20106 o7 ibias vss vss sky130_fd_pr__nfet_01v8 L=0.5u W=1u
M20107 o7 ibias vss vss sky130_fd_pr__nfet_01v8 L=0.5u W=1u
M20108 o7 ibias vss vss sky130_fd_pr__nfet_01v8 L=0.5u W=1u
M20109 o7 ibias vss vss sky130_fd_pr__nfet_01v8 L=0.5u W=1u
M20110 o7 ibias vss vss sky130_fd_pr__nfet_01v8 L=0.5u W=1u
M20111 o7 ibias vss vss sky130_fd_pr__nfet_01v8 L=0.5u W=1u
M20112 o7 ibias vss vss sky130_fd_pr__nfet_01v8 L=0.5u W=1u
M20113 o7 ibias vss vss sky130_fd_pr__nfet_01v8 L=0.5u W=1u
M20114 o7 ibias vss vss sky130_fd_pr__nfet_01v8 L=0.5u W=1u
M20115 o7 ibias vss vss sky130_fd_pr__nfet_01v8 L=0.5u W=1u
M20116 o7 ibias vss vss sky130_fd_pr__nfet_01v8 L=0.5u W=1u
M20117 o7 ibias vss vss sky130_fd_pr__nfet_01v8 L=0.5u W=1u
M20118 o7 ibias vss vss sky130_fd_pr__nfet_01v8 L=0.5u W=1u
M20119 o7 ibias vss vss sky130_fd_pr__nfet_01v8 L=0.5u W=1u
M20120 o7 ibias vss vss sky130_fd_pr__nfet_01v8 L=0.5u W=1u
M20121 o7 ibias vss vss sky130_fd_pr__nfet_01v8 L=0.5u W=1u
M20122 o7 ibias vss vss sky130_fd_pr__nfet_01v8 L=0.5u W=1u
M20123 o7 ibias vss vss sky130_fd_pr__nfet_01v8 L=0.5u W=1u
M20124 o7 ibias vss vss sky130_fd_pr__nfet_01v8 L=0.5u W=1u
M20125 o7 ibias vss vss sky130_fd_pr__nfet_01v8 L=0.5u W=1u
M20126 o7 ibias vss vss sky130_fd_pr__nfet_01v8 L=0.5u W=1u
M20127 o7 ibias vss vss sky130_fd_pr__nfet_01v8 L=0.5u W=1u
M20128 o7 ibias vss vss sky130_fd_pr__nfet_01v8 L=0.5u W=1u
M20129 o7 ibias vss vss sky130_fd_pr__nfet_01v8 L=0.5u W=1u
M20130 o7 ibias vss vss sky130_fd_pr__nfet_01v8 L=0.5u W=1u
M20131 o7 ibias vss vss sky130_fd_pr__nfet_01v8 L=0.5u W=1u
M20132 o7 ibias vss vss sky130_fd_pr__nfet_01v8 L=0.5u W=1u
M20133 o7 ibias vss vss sky130_fd_pr__nfet_01v8 L=0.5u W=1u
M20134 o7 ibias vss vss sky130_fd_pr__nfet_01v8 L=0.5u W=1u
M20135 o7 ibias vss vss sky130_fd_pr__nfet_01v8 L=0.5u W=1u
M20136 o7 ibias vss vss sky130_fd_pr__nfet_01v8 L=0.5u W=1u
M20137 o7 ibias vss vss sky130_fd_pr__nfet_01v8 L=0.5u W=1u
M20138 o7 ibias vss vss sky130_fd_pr__nfet_01v8 L=0.5u W=1u
M20139 o7 ibias vss vss sky130_fd_pr__nfet_01v8 L=0.5u W=1u
M20140 o7 ibias vss vss sky130_fd_pr__nfet_01v8 L=0.5u W=1u
M20141 o7 ibias vss vss sky130_fd_pr__nfet_01v8 L=0.5u W=1u
M20142 o7 ibias vss vss sky130_fd_pr__nfet_01v8 L=0.5u W=1u
M20143 o7 ibias vss vss sky130_fd_pr__nfet_01v8 L=0.5u W=1u
M20144 o7 ibias vss vss sky130_fd_pr__nfet_01v8 L=0.5u W=1u
M20145 o7 ibias vss vss sky130_fd_pr__nfet_01v8 L=0.5u W=1u
M20146 o7 ibias vss vss sky130_fd_pr__nfet_01v8 L=0.5u W=1u
M20147 o7 ibias vss vss sky130_fd_pr__nfet_01v8 L=0.5u W=1u
M20148 o7 ibias vss vss sky130_fd_pr__nfet_01v8 L=0.5u W=1u
M20149 o7 ibias vss vss sky130_fd_pr__nfet_01v8 L=0.5u W=1u
M20150 o7 ibias vss vss sky130_fd_pr__nfet_01v8 L=0.5u W=1u
M20151 o7 ibias vss vss sky130_fd_pr__nfet_01v8 L=0.5u W=1u
M20152 o7 ibias vss vss sky130_fd_pr__nfet_01v8 L=0.5u W=1u
M20153 o7 ibias vss vss sky130_fd_pr__nfet_01v8 L=0.5u W=1u
M20154 o7 ibias vss vss sky130_fd_pr__nfet_01v8 L=0.5u W=1u
M20155 o7 ibias vss vss sky130_fd_pr__nfet_01v8 L=0.5u W=1u
M20156 o7 ibias vss vss sky130_fd_pr__nfet_01v8 L=0.5u W=1u
M20157 o7 ibias vss vss sky130_fd_pr__nfet_01v8 L=0.5u W=1u
M20158 o7 ibias vss vss sky130_fd_pr__nfet_01v8 L=0.5u W=1u
M20159 o7 ibias vss vss sky130_fd_pr__nfet_01v8 L=0.5u W=1u
M20160 o7 ibias vss vss sky130_fd_pr__nfet_01v8 L=0.5u W=1u
M20161 o7 ibias vss vss sky130_fd_pr__nfet_01v8 L=0.5u W=1u
M20162 o7 ibias vss vss sky130_fd_pr__nfet_01v8 L=0.5u W=1u
M20163 o7 ibias vss vss sky130_fd_pr__nfet_01v8 L=0.5u W=1u
M20164 o7 ibias vss vss sky130_fd_pr__nfet_01v8 L=0.5u W=1u
M20165 o7 ibias vss vss sky130_fd_pr__nfet_01v8 L=0.5u W=1u
M20166 o7 ibias vss vss sky130_fd_pr__nfet_01v8 L=0.5u W=1u
M20167 o7 ibias vss vss sky130_fd_pr__nfet_01v8 L=0.5u W=1u
M20168 o7 ibias vss vss sky130_fd_pr__nfet_01v8 L=0.5u W=1u
M20169 o7 ibias vss vss sky130_fd_pr__nfet_01v8 L=0.5u W=1u
M20170 o7 ibias vss vss sky130_fd_pr__nfet_01v8 L=0.5u W=1u
M20171 o7 ibias vss vss sky130_fd_pr__nfet_01v8 L=0.5u W=1u
M20172 o7 ibias vss vss sky130_fd_pr__nfet_01v8 L=0.5u W=1u
M20173 o7 ibias vss vss sky130_fd_pr__nfet_01v8 L=0.5u W=1u
M20174 o7 ibias vss vss sky130_fd_pr__nfet_01v8 L=0.5u W=1u
M20175 o7 ibias vss vss sky130_fd_pr__nfet_01v8 L=0.5u W=1u
M20176 o7 ibias vss vss sky130_fd_pr__nfet_01v8 L=0.5u W=1u
M20177 o7 ibias vss vss sky130_fd_pr__nfet_01v8 L=0.5u W=1u
M20178 o7 ibias vss vss sky130_fd_pr__nfet_01v8 L=0.5u W=1u
M20179 o7 ibias vss vss sky130_fd_pr__nfet_01v8 L=0.5u W=1u
M20180 o7 ibias vss vss sky130_fd_pr__nfet_01v8 L=0.5u W=1u
M20181 o7 ibias vss vss sky130_fd_pr__nfet_01v8 L=0.5u W=1u
M20182 o7 ibias vss vss sky130_fd_pr__nfet_01v8 L=0.5u W=1u
M20183 o7 ibias vss vss sky130_fd_pr__nfet_01v8 L=0.5u W=1u
M20184 o7 ibias vss vss sky130_fd_pr__nfet_01v8 L=0.5u W=1u
M20185 o7 ibias vss vss sky130_fd_pr__nfet_01v8 L=0.5u W=1u
M20186 o7 ibias vss vss sky130_fd_pr__nfet_01v8 L=0.5u W=1u
M20187 o7 ibias vss vss sky130_fd_pr__nfet_01v8 L=0.5u W=1u
M20188 o7 ibias vss vss sky130_fd_pr__nfet_01v8 L=0.5u W=1u
M20189 o7 ibias vss vss sky130_fd_pr__nfet_01v8 L=0.5u W=1u
M20190 o7 ibias vss vss sky130_fd_pr__nfet_01v8 L=0.5u W=1u
M20191 o7 ibias vss vss sky130_fd_pr__nfet_01v8 L=0.5u W=1u
M20192 o7 ibias vss vss sky130_fd_pr__nfet_01v8 L=0.5u W=1u
M20193 o7 ibias vss vss sky130_fd_pr__nfet_01v8 L=0.5u W=1u
M20194 o7 ibias vss vss sky130_fd_pr__nfet_01v8 L=0.5u W=1u
M20195 o7 ibias vss vss sky130_fd_pr__nfet_01v8 L=0.5u W=1u
M20196 o7 ibias vss vss sky130_fd_pr__nfet_01v8 L=0.5u W=1u
M20197 o7 ibias vss vss sky130_fd_pr__nfet_01v8 L=0.5u W=1u
M20198 o7 ibias vss vss sky130_fd_pr__nfet_01v8 L=0.5u W=1u
M20199 o7 ibias vss vss sky130_fd_pr__nfet_01v8 L=0.5u W=1u
M20200 o7 ibias vss vss sky130_fd_pr__nfet_01v8 L=0.5u W=1u
M20201 o7 ibias vss vss sky130_fd_pr__nfet_01v8 L=0.5u W=1u
M20202 o7 ibias vss vss sky130_fd_pr__nfet_01v8 L=0.5u W=1u
M20203 o7 ibias vss vss sky130_fd_pr__nfet_01v8 L=0.5u W=1u
M20204 o7 ibias vss vss sky130_fd_pr__nfet_01v8 L=0.5u W=1u
M20205 o7 ibias vss vss sky130_fd_pr__nfet_01v8 L=0.5u W=1u
M20206 o7 ibias vss vss sky130_fd_pr__nfet_01v8 L=0.5u W=1u
M20207 o7 ibias vss vss sky130_fd_pr__nfet_01v8 L=0.5u W=1u
M20208 o7 ibias vss vss sky130_fd_pr__nfet_01v8 L=0.5u W=1u
M20209 o7 ibias vss vss sky130_fd_pr__nfet_01v8 L=0.5u W=1u
M20210 o7 ibias vss vss sky130_fd_pr__nfet_01v8 L=0.5u W=1u
M20211 o7 ibias vss vss sky130_fd_pr__nfet_01v8 L=0.5u W=1u
M20212 o7 ibias vss vss sky130_fd_pr__nfet_01v8 L=0.5u W=1u
M20213 o7 ibias vss vss sky130_fd_pr__nfet_01v8 L=0.5u W=1u
M20214 o7 ibias vss vss sky130_fd_pr__nfet_01v8 L=0.5u W=1u
M20215 o7 ibias vss vss sky130_fd_pr__nfet_01v8 L=0.5u W=1u
M20216 o7 ibias vss vss sky130_fd_pr__nfet_01v8 L=0.5u W=1u
M20217 o7 ibias vss vss sky130_fd_pr__nfet_01v8 L=0.5u W=1u
M20218 o7 ibias vss vss sky130_fd_pr__nfet_01v8 L=0.5u W=1u
M20219 o7 ibias vss vss sky130_fd_pr__nfet_01v8 L=0.5u W=1u
M20220 o7 ibias vss vss sky130_fd_pr__nfet_01v8 L=0.5u W=1u
M20221 o7 ibias vss vss sky130_fd_pr__nfet_01v8 L=0.5u W=1u
M20222 o7 ibias vss vss sky130_fd_pr__nfet_01v8 L=0.5u W=1u
M20223 o7 ibias vss vss sky130_fd_pr__nfet_01v8 L=0.5u W=1u
M20224 o7 ibias vss vss sky130_fd_pr__nfet_01v8 L=0.5u W=1u
M20225 o7 ibias vss vss sky130_fd_pr__nfet_01v8 L=0.5u W=1u
M20226 o7 ibias vss vss sky130_fd_pr__nfet_01v8 L=0.5u W=1u
M20227 o7 ibias vss vss sky130_fd_pr__nfet_01v8 L=0.5u W=1u
M20228 o7 ibias vss vss sky130_fd_pr__nfet_01v8 L=0.5u W=1u
M20229 o7 ibias vss vss sky130_fd_pr__nfet_01v8 L=0.5u W=1u
M20230 o7 ibias vss vss sky130_fd_pr__nfet_01v8 L=0.5u W=1u
M20231 o7 ibias vss vss sky130_fd_pr__nfet_01v8 L=0.5u W=1u
M20232 o7 ibias vss vss sky130_fd_pr__nfet_01v8 L=0.5u W=1u
M20233 o7 ibias vss vss sky130_fd_pr__nfet_01v8 L=0.5u W=1u
M20234 o7 ibias vss vss sky130_fd_pr__nfet_01v8 L=0.5u W=1u
M20235 o7 ibias vss vss sky130_fd_pr__nfet_01v8 L=0.5u W=1u
M20236 o7 ibias vss vss sky130_fd_pr__nfet_01v8 L=0.5u W=1u
M20237 o7 ibias vss vss sky130_fd_pr__nfet_01v8 L=0.5u W=1u
M20238 o7 ibias vss vss sky130_fd_pr__nfet_01v8 L=0.5u W=1u
M20239 o7 ibias vss vss sky130_fd_pr__nfet_01v8 L=0.5u W=1u
M20240 o7 ibias vss vss sky130_fd_pr__nfet_01v8 L=0.5u W=1u
M20241 o7 ibias vss vss sky130_fd_pr__nfet_01v8 L=0.5u W=1u
M20242 o7 ibias vss vss sky130_fd_pr__nfet_01v8 L=0.5u W=1u
M20243 o7 ibias vss vss sky130_fd_pr__nfet_01v8 L=0.5u W=1u
M20244 o7 ibias vss vss sky130_fd_pr__nfet_01v8 L=0.5u W=1u
M20245 o7 ibias vss vss sky130_fd_pr__nfet_01v8 L=0.5u W=1u
M20246 o7 ibias vss vss sky130_fd_pr__nfet_01v8 L=0.5u W=1u
M20247 o7 ibias vss vss sky130_fd_pr__nfet_01v8 L=0.5u W=1u
M20248 o7 ibias vss vss sky130_fd_pr__nfet_01v8 L=0.5u W=1u
M20249 o7 ibias vss vss sky130_fd_pr__nfet_01v8 L=0.5u W=1u
M20250 o7 ibias vss vss sky130_fd_pr__nfet_01v8 L=0.5u W=1u
M20251 o7 ibias vss vss sky130_fd_pr__nfet_01v8 L=0.5u W=1u
M20252 o7 ibias vss vss sky130_fd_pr__nfet_01v8 L=0.5u W=1u
M20253 o7 ibias vss vss sky130_fd_pr__nfet_01v8 L=0.5u W=1u
M20254 o7 ibias vss vss sky130_fd_pr__nfet_01v8 L=0.5u W=1u
M20255 o7 ibias vss vss sky130_fd_pr__nfet_01v8 L=0.5u W=1u
M20256 o7 ibias vss vss sky130_fd_pr__nfet_01v8 L=0.5u W=1u
M20257 o7 ibias vss vss sky130_fd_pr__nfet_01v8 L=0.5u W=1u
M20258 o7 ibias vss vss sky130_fd_pr__nfet_01v8 L=0.5u W=1u
M20259 o7 ibias vss vss sky130_fd_pr__nfet_01v8 L=0.5u W=1u
M20260 o7 ibias vss vss sky130_fd_pr__nfet_01v8 L=0.5u W=1u
M20261 o7 ibias vss vss sky130_fd_pr__nfet_01v8 L=0.5u W=1u
M20262 o7 ibias vss vss sky130_fd_pr__nfet_01v8 L=0.5u W=1u
M20263 o7 ibias vss vss sky130_fd_pr__nfet_01v8 L=0.5u W=1u
M20264 o7 ibias vss vss sky130_fd_pr__nfet_01v8 L=0.5u W=1u
M20265 o7 ibias vss vss sky130_fd_pr__nfet_01v8 L=0.5u W=1u
M20266 o7 ibias vss vss sky130_fd_pr__nfet_01v8 L=0.5u W=1u
M20267 o7 ibias vss vss sky130_fd_pr__nfet_01v8 L=0.5u W=1u
M20268 o7 ibias vss vss sky130_fd_pr__nfet_01v8 L=0.5u W=1u
M20269 o7 ibias vss vss sky130_fd_pr__nfet_01v8 L=0.5u W=1u
M20270 o7 ibias vss vss sky130_fd_pr__nfet_01v8 L=0.5u W=1u
M20271 o7 ibias vss vss sky130_fd_pr__nfet_01v8 L=0.5u W=1u
M20272 o7 ibias vss vss sky130_fd_pr__nfet_01v8 L=0.5u W=1u
M20273 o7 ibias vss vss sky130_fd_pr__nfet_01v8 L=0.5u W=1u
M20274 o7 ibias vss vss sky130_fd_pr__nfet_01v8 L=0.5u W=1u
M20275 o7 ibias vss vss sky130_fd_pr__nfet_01v8 L=0.5u W=1u
M20276 o7 ibias vss vss sky130_fd_pr__nfet_01v8 L=0.5u W=1u
M20277 o7 ibias vss vss sky130_fd_pr__nfet_01v8 L=0.5u W=1u
M20278 o7 ibias vss vss sky130_fd_pr__nfet_01v8 L=0.5u W=1u
M20279 o7 ibias vss vss sky130_fd_pr__nfet_01v8 L=0.5u W=1u
M20280 o7 ibias vss vss sky130_fd_pr__nfet_01v8 L=0.5u W=1u
M20281 o7 ibias vss vss sky130_fd_pr__nfet_01v8 L=0.5u W=1u
M20282 o7 ibias vss vss sky130_fd_pr__nfet_01v8 L=0.5u W=1u
M20283 o7 ibias vss vss sky130_fd_pr__nfet_01v8 L=0.5u W=1u
M20284 o7 ibias vss vss sky130_fd_pr__nfet_01v8 L=0.5u W=1u
M20285 o7 ibias vss vss sky130_fd_pr__nfet_01v8 L=0.5u W=1u
M20286 o7 ibias vss vss sky130_fd_pr__nfet_01v8 L=0.5u W=1u
M20287 o7 ibias vss vss sky130_fd_pr__nfet_01v8 L=0.5u W=1u
M20288 o7 ibias vss vss sky130_fd_pr__nfet_01v8 L=0.5u W=1u
M20289 o7 ibias vss vss sky130_fd_pr__nfet_01v8 L=0.5u W=1u
M20290 o7 ibias vss vss sky130_fd_pr__nfet_01v8 L=0.5u W=1u
M20291 o7 ibias vss vss sky130_fd_pr__nfet_01v8 L=0.5u W=1u
M20292 o7 ibias vss vss sky130_fd_pr__nfet_01v8 L=0.5u W=1u
M20293 o7 ibias vss vss sky130_fd_pr__nfet_01v8 L=0.5u W=1u
M20294 o7 ibias vss vss sky130_fd_pr__nfet_01v8 L=0.5u W=1u
M20295 o7 ibias vss vss sky130_fd_pr__nfet_01v8 L=0.5u W=1u
M20296 o7 ibias vss vss sky130_fd_pr__nfet_01v8 L=0.5u W=1u
M20297 o7 ibias vss vss sky130_fd_pr__nfet_01v8 L=0.5u W=1u
M20298 o7 ibias vss vss sky130_fd_pr__nfet_01v8 L=0.5u W=1u
M20299 o7 ibias vss vss sky130_fd_pr__nfet_01v8 L=0.5u W=1u
M20300 o7 ibias vss vss sky130_fd_pr__nfet_01v8 L=0.5u W=1u
M20301 o7 ibias vss vss sky130_fd_pr__nfet_01v8 L=0.5u W=1u
M20302 o7 ibias vss vss sky130_fd_pr__nfet_01v8 L=0.5u W=1u
M20303 o7 ibias vss vss sky130_fd_pr__nfet_01v8 L=0.5u W=1u
M20304 o7 ibias vss vss sky130_fd_pr__nfet_01v8 L=0.5u W=1u
M20305 o7 ibias vss vss sky130_fd_pr__nfet_01v8 L=0.5u W=1u
M20306 o7 ibias vss vss sky130_fd_pr__nfet_01v8 L=0.5u W=1u
M20307 o7 ibias vss vss sky130_fd_pr__nfet_01v8 L=0.5u W=1u
M20308 o7 ibias vss vss sky130_fd_pr__nfet_01v8 L=0.5u W=1u
M20309 o7 ibias vss vss sky130_fd_pr__nfet_01v8 L=0.5u W=1u
M20310 o7 ibias vss vss sky130_fd_pr__nfet_01v8 L=0.5u W=1u
M20311 o7 ibias vss vss sky130_fd_pr__nfet_01v8 L=0.5u W=1u
M20312 o7 ibias vss vss sky130_fd_pr__nfet_01v8 L=0.5u W=1u
M20313 o7 ibias vss vss sky130_fd_pr__nfet_01v8 L=0.5u W=1u
M20314 o7 ibias vss vss sky130_fd_pr__nfet_01v8 L=0.5u W=1u
M20315 o7 ibias vss vss sky130_fd_pr__nfet_01v8 L=0.5u W=1u
M20316 o7 ibias vss vss sky130_fd_pr__nfet_01v8 L=0.5u W=1u
M20317 o7 ibias vss vss sky130_fd_pr__nfet_01v8 L=0.5u W=1u
M20318 o7 ibias vss vss sky130_fd_pr__nfet_01v8 L=0.5u W=1u
M20319 o7 ibias vss vss sky130_fd_pr__nfet_01v8 L=0.5u W=1u
M20320 o7 ibias vss vss sky130_fd_pr__nfet_01v8 L=0.5u W=1u
M20321 o7 ibias vss vss sky130_fd_pr__nfet_01v8 L=0.5u W=1u
M20322 o7 ibias vss vss sky130_fd_pr__nfet_01v8 L=0.5u W=1u
M20323 o7 ibias vss vss sky130_fd_pr__nfet_01v8 L=0.5u W=1u
M20324 o7 ibias vss vss sky130_fd_pr__nfet_01v8 L=0.5u W=1u
M20325 o7 ibias vss vss sky130_fd_pr__nfet_01v8 L=0.5u W=1u
M20326 o7 ibias vss vss sky130_fd_pr__nfet_01v8 L=0.5u W=1u
M20327 o7 ibias vss vss sky130_fd_pr__nfet_01v8 L=0.5u W=1u
M20328 o7 ibias vss vss sky130_fd_pr__nfet_01v8 L=0.5u W=1u
M20329 o7 ibias vss vss sky130_fd_pr__nfet_01v8 L=0.5u W=1u
M20330 o7 ibias vss vss sky130_fd_pr__nfet_01v8 L=0.5u W=1u
M20331 o7 ibias vss vss sky130_fd_pr__nfet_01v8 L=0.5u W=1u
M20332 o7 ibias vss vss sky130_fd_pr__nfet_01v8 L=0.5u W=1u
M20333 o7 ibias vss vss sky130_fd_pr__nfet_01v8 L=0.5u W=1u
M20334 o7 ibias vss vss sky130_fd_pr__nfet_01v8 L=0.5u W=1u
M20335 o7 ibias vss vss sky130_fd_pr__nfet_01v8 L=0.5u W=1u
M20336 o7 ibias vss vss sky130_fd_pr__nfet_01v8 L=0.5u W=1u
M20337 o7 ibias vss vss sky130_fd_pr__nfet_01v8 L=0.5u W=1u
M20338 o7 ibias vss vss sky130_fd_pr__nfet_01v8 L=0.5u W=1u
M20339 o7 ibias vss vss sky130_fd_pr__nfet_01v8 L=0.5u W=1u
M20340 o7 ibias vss vss sky130_fd_pr__nfet_01v8 L=0.5u W=1u
M20341 o7 ibias vss vss sky130_fd_pr__nfet_01v8 L=0.5u W=1u
M20342 o7 ibias vss vss sky130_fd_pr__nfet_01v8 L=0.5u W=1u
M20343 o7 ibias vss vss sky130_fd_pr__nfet_01v8 L=0.5u W=1u
M20344 o7 ibias vss vss sky130_fd_pr__nfet_01v8 L=0.5u W=1u
M20345 o7 ibias vss vss sky130_fd_pr__nfet_01v8 L=0.5u W=1u
M20346 o7 ibias vss vss sky130_fd_pr__nfet_01v8 L=0.5u W=1u
M20347 o7 ibias vss vss sky130_fd_pr__nfet_01v8 L=0.5u W=1u
M20348 o7 ibias vss vss sky130_fd_pr__nfet_01v8 L=0.5u W=1u
M20349 o7 ibias vss vss sky130_fd_pr__nfet_01v8 L=0.5u W=1u
M20350 o7 ibias vss vss sky130_fd_pr__nfet_01v8 L=0.5u W=1u
M20351 o7 ibias vss vss sky130_fd_pr__nfet_01v8 L=0.5u W=1u
M20352 o7 ibias vss vss sky130_fd_pr__nfet_01v8 L=0.5u W=1u
M20353 o7 ibias vss vss sky130_fd_pr__nfet_01v8 L=0.5u W=1u
M20354 o7 ibias vss vss sky130_fd_pr__nfet_01v8 L=0.5u W=1u
M20355 o7 ibias vss vss sky130_fd_pr__nfet_01v8 L=0.5u W=1u
M20356 o7 ibias vss vss sky130_fd_pr__nfet_01v8 L=0.5u W=1u
M20357 o7 ibias vss vss sky130_fd_pr__nfet_01v8 L=0.5u W=1u
M20358 o7 ibias vss vss sky130_fd_pr__nfet_01v8 L=0.5u W=1u
M20359 o7 ibias vss vss sky130_fd_pr__nfet_01v8 L=0.5u W=1u
M20360 o7 ibias vss vss sky130_fd_pr__nfet_01v8 L=0.5u W=1u
M20361 o7 ibias vss vss sky130_fd_pr__nfet_01v8 L=0.5u W=1u
M20362 o7 ibias vss vss sky130_fd_pr__nfet_01v8 L=0.5u W=1u
M20363 o7 ibias vss vss sky130_fd_pr__nfet_01v8 L=0.5u W=1u
M20364 o7 ibias vss vss sky130_fd_pr__nfet_01v8 L=0.5u W=1u
M20365 o7 ibias vss vss sky130_fd_pr__nfet_01v8 L=0.5u W=1u
M20366 o7 ibias vss vss sky130_fd_pr__nfet_01v8 L=0.5u W=1u
M20367 o7 ibias vss vss sky130_fd_pr__nfet_01v8 L=0.5u W=1u
M20368 o7 ibias vss vss sky130_fd_pr__nfet_01v8 L=0.5u W=1u
M20369 o7 ibias vss vss sky130_fd_pr__nfet_01v8 L=0.5u W=1u
M20370 o7 ibias vss vss sky130_fd_pr__nfet_01v8 L=0.5u W=1u
M20371 o7 ibias vss vss sky130_fd_pr__nfet_01v8 L=0.5u W=1u
M20372 o7 ibias vss vss sky130_fd_pr__nfet_01v8 L=0.5u W=1u
M20373 o7 ibias vss vss sky130_fd_pr__nfet_01v8 L=0.5u W=1u
M20374 o7 ibias vss vss sky130_fd_pr__nfet_01v8 L=0.5u W=1u
M20375 o7 ibias vss vss sky130_fd_pr__nfet_01v8 L=0.5u W=1u
M20376 o7 ibias vss vss sky130_fd_pr__nfet_01v8 L=0.5u W=1u
M20377 o7 ibias vss vss sky130_fd_pr__nfet_01v8 L=0.5u W=1u
M20378 o7 ibias vss vss sky130_fd_pr__nfet_01v8 L=0.5u W=1u
M20379 o7 ibias vss vss sky130_fd_pr__nfet_01v8 L=0.5u W=1u
M20380 o7 ibias vss vss sky130_fd_pr__nfet_01v8 L=0.5u W=1u
M20381 o7 ibias vss vss sky130_fd_pr__nfet_01v8 L=0.5u W=1u
M20382 o7 ibias vss vss sky130_fd_pr__nfet_01v8 L=0.5u W=1u
M20383 o7 ibias vss vss sky130_fd_pr__nfet_01v8 L=0.5u W=1u
M20384 o7 ibias vss vss sky130_fd_pr__nfet_01v8 L=0.5u W=1u
M20385 o7 ibias vss vss sky130_fd_pr__nfet_01v8 L=0.5u W=1u
M20386 o7 ibias vss vss sky130_fd_pr__nfet_01v8 L=0.5u W=1u
M20387 o7 ibias vss vss sky130_fd_pr__nfet_01v8 L=0.5u W=1u
M20388 o7 ibias vss vss sky130_fd_pr__nfet_01v8 L=0.5u W=1u
M20389 o7 ibias vss vss sky130_fd_pr__nfet_01v8 L=0.5u W=1u
M20390 o7 ibias vss vss sky130_fd_pr__nfet_01v8 L=0.5u W=1u
M20391 o7 ibias vss vss sky130_fd_pr__nfet_01v8 L=0.5u W=1u
M20392 o7 ibias vss vss sky130_fd_pr__nfet_01v8 L=0.5u W=1u
M20393 o7 ibias vss vss sky130_fd_pr__nfet_01v8 L=0.5u W=1u
M20394 o7 ibias vss vss sky130_fd_pr__nfet_01v8 L=0.5u W=1u
M20395 o7 ibias vss vss sky130_fd_pr__nfet_01v8 L=0.5u W=1u
M20396 o7 ibias vss vss sky130_fd_pr__nfet_01v8 L=0.5u W=1u
M20397 o7 ibias vss vss sky130_fd_pr__nfet_01v8 L=0.5u W=1u
M20398 o7 ibias vss vss sky130_fd_pr__nfet_01v8 L=0.5u W=1u
M20399 o7 ibias vss vss sky130_fd_pr__nfet_01v8 L=0.5u W=1u
M20400 o7 ibias vss vss sky130_fd_pr__nfet_01v8 L=0.5u W=1u
M20401 o7 ibias vss vss sky130_fd_pr__nfet_01v8 L=0.5u W=1u
M20402 o7 ibias vss vss sky130_fd_pr__nfet_01v8 L=0.5u W=1u
M20403 o7 ibias vss vss sky130_fd_pr__nfet_01v8 L=0.5u W=1u
M20404 o7 ibias vss vss sky130_fd_pr__nfet_01v8 L=0.5u W=1u
M20405 o7 ibias vss vss sky130_fd_pr__nfet_01v8 L=0.5u W=1u
M20406 o7 ibias vss vss sky130_fd_pr__nfet_01v8 L=0.5u W=1u
M20407 o7 ibias vss vss sky130_fd_pr__nfet_01v8 L=0.5u W=1u
M20408 o7 ibias vss vss sky130_fd_pr__nfet_01v8 L=0.5u W=1u
M20409 o7 ibias vss vss sky130_fd_pr__nfet_01v8 L=0.5u W=1u
M20410 o7 ibias vss vss sky130_fd_pr__nfet_01v8 L=0.5u W=1u
M20411 o7 ibias vss vss sky130_fd_pr__nfet_01v8 L=0.5u W=1u
M20412 o7 ibias vss vss sky130_fd_pr__nfet_01v8 L=0.5u W=1u
M20413 o7 ibias vss vss sky130_fd_pr__nfet_01v8 L=0.5u W=1u
M20414 o7 ibias vss vss sky130_fd_pr__nfet_01v8 L=0.5u W=1u
M20415 o7 ibias vss vss sky130_fd_pr__nfet_01v8 L=0.5u W=1u
M20416 o7 ibias vss vss sky130_fd_pr__nfet_01v8 L=0.5u W=1u
M20417 o7 ibias vss vss sky130_fd_pr__nfet_01v8 L=0.5u W=1u
M20418 o7 ibias vss vss sky130_fd_pr__nfet_01v8 L=0.5u W=1u
M20419 o7 ibias vss vss sky130_fd_pr__nfet_01v8 L=0.5u W=1u
M20420 o7 ibias vss vss sky130_fd_pr__nfet_01v8 L=0.5u W=1u
M20421 o7 ibias vss vss sky130_fd_pr__nfet_01v8 L=0.5u W=1u
M20422 o7 ibias vss vss sky130_fd_pr__nfet_01v8 L=0.5u W=1u
M20423 o7 ibias vss vss sky130_fd_pr__nfet_01v8 L=0.5u W=1u
M20424 o7 ibias vss vss sky130_fd_pr__nfet_01v8 L=0.5u W=1u
M20425 o7 ibias vss vss sky130_fd_pr__nfet_01v8 L=0.5u W=1u
M20426 o7 ibias vss vss sky130_fd_pr__nfet_01v8 L=0.5u W=1u
M20427 o7 ibias vss vss sky130_fd_pr__nfet_01v8 L=0.5u W=1u
M20428 o7 ibias vss vss sky130_fd_pr__nfet_01v8 L=0.5u W=1u
M20429 o7 ibias vss vss sky130_fd_pr__nfet_01v8 L=0.5u W=1u
M20430 o7 ibias vss vss sky130_fd_pr__nfet_01v8 L=0.5u W=1u
M20431 o7 ibias vss vss sky130_fd_pr__nfet_01v8 L=0.5u W=1u
M20432 o7 ibias vss vss sky130_fd_pr__nfet_01v8 L=0.5u W=1u
M20433 o7 ibias vss vss sky130_fd_pr__nfet_01v8 L=0.5u W=1u
M20434 o7 ibias vss vss sky130_fd_pr__nfet_01v8 L=0.5u W=1u
M20435 o7 ibias vss vss sky130_fd_pr__nfet_01v8 L=0.5u W=1u
M20436 o7 ibias vss vss sky130_fd_pr__nfet_01v8 L=0.5u W=1u
M20437 o7 ibias vss vss sky130_fd_pr__nfet_01v8 L=0.5u W=1u
M20438 o7 ibias vss vss sky130_fd_pr__nfet_01v8 L=0.5u W=1u
M20439 o7 ibias vss vss sky130_fd_pr__nfet_01v8 L=0.5u W=1u
M20440 o7 ibias vss vss sky130_fd_pr__nfet_01v8 L=0.5u W=1u
M20441 o7 ibias vss vss sky130_fd_pr__nfet_01v8 L=0.5u W=1u
M20442 o7 ibias vss vss sky130_fd_pr__nfet_01v8 L=0.5u W=1u
M20443 o7 ibias vss vss sky130_fd_pr__nfet_01v8 L=0.5u W=1u
M20444 o7 ibias vss vss sky130_fd_pr__nfet_01v8 L=0.5u W=1u
M20445 o7 ibias vss vss sky130_fd_pr__nfet_01v8 L=0.5u W=1u
M20446 o7 ibias vss vss sky130_fd_pr__nfet_01v8 L=0.5u W=1u
M20447 o7 ibias vss vss sky130_fd_pr__nfet_01v8 L=0.5u W=1u
M20448 o7 ibias vss vss sky130_fd_pr__nfet_01v8 L=0.5u W=1u
M20449 o7 ibias vss vss sky130_fd_pr__nfet_01v8 L=0.5u W=1u
M20450 o7 ibias vss vss sky130_fd_pr__nfet_01v8 L=0.5u W=1u
M20451 o7 ibias vss vss sky130_fd_pr__nfet_01v8 L=0.5u W=1u
M20452 o7 ibias vss vss sky130_fd_pr__nfet_01v8 L=0.5u W=1u
M20453 o7 ibias vss vss sky130_fd_pr__nfet_01v8 L=0.5u W=1u
M20454 o7 ibias vss vss sky130_fd_pr__nfet_01v8 L=0.5u W=1u
M20455 o7 ibias vss vss sky130_fd_pr__nfet_01v8 L=0.5u W=1u
M20456 o7 ibias vss vss sky130_fd_pr__nfet_01v8 L=0.5u W=1u
M20457 o7 ibias vss vss sky130_fd_pr__nfet_01v8 L=0.5u W=1u
M20458 o7 ibias vss vss sky130_fd_pr__nfet_01v8 L=0.5u W=1u
M20459 o7 ibias vss vss sky130_fd_pr__nfet_01v8 L=0.5u W=1u
M20460 o7 ibias vss vss sky130_fd_pr__nfet_01v8 L=0.5u W=1u
M20461 o7 ibias vss vss sky130_fd_pr__nfet_01v8 L=0.5u W=1u
M20462 o7 ibias vss vss sky130_fd_pr__nfet_01v8 L=0.5u W=1u
M20463 o7 ibias vss vss sky130_fd_pr__nfet_01v8 L=0.5u W=1u
M20464 o7 ibias vss vss sky130_fd_pr__nfet_01v8 L=0.5u W=1u
M20465 o7 ibias vss vss sky130_fd_pr__nfet_01v8 L=0.5u W=1u
M20466 o7 ibias vss vss sky130_fd_pr__nfet_01v8 L=0.5u W=1u
M20467 o7 ibias vss vss sky130_fd_pr__nfet_01v8 L=0.5u W=1u
M20468 o7 ibias vss vss sky130_fd_pr__nfet_01v8 L=0.5u W=1u
M20469 o7 ibias vss vss sky130_fd_pr__nfet_01v8 L=0.5u W=1u
M20470 o7 ibias vss vss sky130_fd_pr__nfet_01v8 L=0.5u W=1u
M20471 o7 ibias vss vss sky130_fd_pr__nfet_01v8 L=0.5u W=1u
M20472 o7 ibias vss vss sky130_fd_pr__nfet_01v8 L=0.5u W=1u
M20473 o7 ibias vss vss sky130_fd_pr__nfet_01v8 L=0.5u W=1u
M20474 o7 ibias vss vss sky130_fd_pr__nfet_01v8 L=0.5u W=1u
M20475 o7 ibias vss vss sky130_fd_pr__nfet_01v8 L=0.5u W=1u
M20476 o7 ibias vss vss sky130_fd_pr__nfet_01v8 L=0.5u W=1u
M20477 o7 ibias vss vss sky130_fd_pr__nfet_01v8 L=0.5u W=1u
M20478 o7 ibias vss vss sky130_fd_pr__nfet_01v8 L=0.5u W=1u
M20479 o7 ibias vss vss sky130_fd_pr__nfet_01v8 L=0.5u W=1u
M20480 o7 ibias vss vss sky130_fd_pr__nfet_01v8 L=0.5u W=1u
M20481 o7 ibias vss vss sky130_fd_pr__nfet_01v8 L=0.5u W=1u
M20482 o7 ibias vss vss sky130_fd_pr__nfet_01v8 L=0.5u W=1u
M20483 o7 ibias vss vss sky130_fd_pr__nfet_01v8 L=0.5u W=1u
M20484 o7 ibias vss vss sky130_fd_pr__nfet_01v8 L=0.5u W=1u
M20485 o7 ibias vss vss sky130_fd_pr__nfet_01v8 L=0.5u W=1u
M20486 o7 ibias vss vss sky130_fd_pr__nfet_01v8 L=0.5u W=1u
M20487 o7 ibias vss vss sky130_fd_pr__nfet_01v8 L=0.5u W=1u
M20488 o7 ibias vss vss sky130_fd_pr__nfet_01v8 L=0.5u W=1u
M20489 o7 ibias vss vss sky130_fd_pr__nfet_01v8 L=0.5u W=1u
M20490 o7 ibias vss vss sky130_fd_pr__nfet_01v8 L=0.5u W=1u
M20491 o7 ibias vss vss sky130_fd_pr__nfet_01v8 L=0.5u W=1u
M20492 o7 ibias vss vss sky130_fd_pr__nfet_01v8 L=0.5u W=1u
M20493 o7 ibias vss vss sky130_fd_pr__nfet_01v8 L=0.5u W=1u
M20494 o7 ibias vss vss sky130_fd_pr__nfet_01v8 L=0.5u W=1u
M20495 o7 ibias vss vss sky130_fd_pr__nfet_01v8 L=0.5u W=1u
M20496 o7 ibias vss vss sky130_fd_pr__nfet_01v8 L=0.5u W=1u
M20497 o7 ibias vss vss sky130_fd_pr__nfet_01v8 L=0.5u W=1u
M20498 o7 ibias vss vss sky130_fd_pr__nfet_01v8 L=0.5u W=1u
M20499 o7 ibias vss vss sky130_fd_pr__nfet_01v8 L=0.5u W=1u
M20500 o7 ibias vss vss sky130_fd_pr__nfet_01v8 L=0.5u W=1u
M20501 o7 ibias vss vss sky130_fd_pr__nfet_01v8 L=0.5u W=1u
M20502 o7 ibias vss vss sky130_fd_pr__nfet_01v8 L=0.5u W=1u
M20503 o7 ibias vss vss sky130_fd_pr__nfet_01v8 L=0.5u W=1u
M20504 o7 ibias vss vss sky130_fd_pr__nfet_01v8 L=0.5u W=1u
M20505 o7 ibias vss vss sky130_fd_pr__nfet_01v8 L=0.5u W=1u
M20506 o7 ibias vss vss sky130_fd_pr__nfet_01v8 L=0.5u W=1u
M20507 o7 ibias vss vss sky130_fd_pr__nfet_01v8 L=0.5u W=1u
M20508 o7 ibias vss vss sky130_fd_pr__nfet_01v8 L=0.5u W=1u
M20509 o7 ibias vss vss sky130_fd_pr__nfet_01v8 L=0.5u W=1u
M20510 o7 ibias vss vss sky130_fd_pr__nfet_01v8 L=0.5u W=1u
M20511 o7 ibias vss vss sky130_fd_pr__nfet_01v8 L=0.5u W=1u
M20512 o7 ibias vss vss sky130_fd_pr__nfet_01v8 L=0.5u W=1u
M20513 o7 ibias vss vss sky130_fd_pr__nfet_01v8 L=0.5u W=1u
M20514 o7 ibias vss vss sky130_fd_pr__nfet_01v8 L=0.5u W=1u
M20515 o7 ibias vss vss sky130_fd_pr__nfet_01v8 L=0.5u W=1u
M20516 o7 ibias vss vss sky130_fd_pr__nfet_01v8 L=0.5u W=1u
M20517 o7 ibias vss vss sky130_fd_pr__nfet_01v8 L=0.5u W=1u
M20518 o7 ibias vss vss sky130_fd_pr__nfet_01v8 L=0.5u W=1u
M20519 o7 ibias vss vss sky130_fd_pr__nfet_01v8 L=0.5u W=1u
M20520 o7 ibias vss vss sky130_fd_pr__nfet_01v8 L=0.5u W=1u
M20521 o7 ibias vss vss sky130_fd_pr__nfet_01v8 L=0.5u W=1u
M20522 o7 ibias vss vss sky130_fd_pr__nfet_01v8 L=0.5u W=1u
M20523 o7 ibias vss vss sky130_fd_pr__nfet_01v8 L=0.5u W=1u
M20524 o7 ibias vss vss sky130_fd_pr__nfet_01v8 L=0.5u W=1u
M20525 o7 ibias vss vss sky130_fd_pr__nfet_01v8 L=0.5u W=1u
M20526 o7 ibias vss vss sky130_fd_pr__nfet_01v8 L=0.5u W=1u
M20527 o7 ibias vss vss sky130_fd_pr__nfet_01v8 L=0.5u W=1u
M20528 o7 ibias vss vss sky130_fd_pr__nfet_01v8 L=0.5u W=1u
M20529 o7 ibias vss vss sky130_fd_pr__nfet_01v8 L=0.5u W=1u
M20530 o7 ibias vss vss sky130_fd_pr__nfet_01v8 L=0.5u W=1u
M20531 o7 ibias vss vss sky130_fd_pr__nfet_01v8 L=0.5u W=1u
M20532 o7 ibias vss vss sky130_fd_pr__nfet_01v8 L=0.5u W=1u
M20533 o7 ibias vss vss sky130_fd_pr__nfet_01v8 L=0.5u W=1u
M20534 o7 ibias vss vss sky130_fd_pr__nfet_01v8 L=0.5u W=1u
M20535 o7 ibias vss vss sky130_fd_pr__nfet_01v8 L=0.5u W=1u
M20536 o7 ibias vss vss sky130_fd_pr__nfet_01v8 L=0.5u W=1u
M20537 o7 ibias vss vss sky130_fd_pr__nfet_01v8 L=0.5u W=1u
M20538 o7 ibias vss vss sky130_fd_pr__nfet_01v8 L=0.5u W=1u
M20539 o7 ibias vss vss sky130_fd_pr__nfet_01v8 L=0.5u W=1u
M20540 o7 ibias vss vss sky130_fd_pr__nfet_01v8 L=0.5u W=1u
M20541 o7 ibias vss vss sky130_fd_pr__nfet_01v8 L=0.5u W=1u
M20542 o7 ibias vss vss sky130_fd_pr__nfet_01v8 L=0.5u W=1u
M20543 o7 ibias vss vss sky130_fd_pr__nfet_01v8 L=0.5u W=1u
M20544 o7 ibias vss vss sky130_fd_pr__nfet_01v8 L=0.5u W=1u
M20545 o7 ibias vss vss sky130_fd_pr__nfet_01v8 L=0.5u W=1u
M20546 o7 ibias vss vss sky130_fd_pr__nfet_01v8 L=0.5u W=1u
M20547 o7 ibias vss vss sky130_fd_pr__nfet_01v8 L=0.5u W=1u
M20548 o7 ibias vss vss sky130_fd_pr__nfet_01v8 L=0.5u W=1u
M20549 o7 ibias vss vss sky130_fd_pr__nfet_01v8 L=0.5u W=1u
M20550 o7 ibias vss vss sky130_fd_pr__nfet_01v8 L=0.5u W=1u
M20551 o7 ibias vss vss sky130_fd_pr__nfet_01v8 L=0.5u W=1u
M20552 o7 ibias vss vss sky130_fd_pr__nfet_01v8 L=0.5u W=1u
M20553 o7 ibias vss vss sky130_fd_pr__nfet_01v8 L=0.5u W=1u
M20554 o7 ibias vss vss sky130_fd_pr__nfet_01v8 L=0.5u W=1u
M20555 o7 ibias vss vss sky130_fd_pr__nfet_01v8 L=0.5u W=1u
M20556 o7 ibias vss vss sky130_fd_pr__nfet_01v8 L=0.5u W=1u
M20557 o7 ibias vss vss sky130_fd_pr__nfet_01v8 L=0.5u W=1u
M20558 o7 ibias vss vss sky130_fd_pr__nfet_01v8 L=0.5u W=1u
M20559 o7 ibias vss vss sky130_fd_pr__nfet_01v8 L=0.5u W=1u
M20560 o7 ibias vss vss sky130_fd_pr__nfet_01v8 L=0.5u W=1u
M20561 o7 ibias vss vss sky130_fd_pr__nfet_01v8 L=0.5u W=1u
M20562 o7 ibias vss vss sky130_fd_pr__nfet_01v8 L=0.5u W=1u
M20563 o7 ibias vss vss sky130_fd_pr__nfet_01v8 L=0.5u W=1u
M20564 o7 ibias vss vss sky130_fd_pr__nfet_01v8 L=0.5u W=1u
M20565 o7 ibias vss vss sky130_fd_pr__nfet_01v8 L=0.5u W=1u
M20566 o7 ibias vss vss sky130_fd_pr__nfet_01v8 L=0.5u W=1u
M20567 o7 ibias vss vss sky130_fd_pr__nfet_01v8 L=0.5u W=1u
M20568 o7 ibias vss vss sky130_fd_pr__nfet_01v8 L=0.5u W=1u
M20569 o7 ibias vss vss sky130_fd_pr__nfet_01v8 L=0.5u W=1u
M20570 o7 ibias vss vss sky130_fd_pr__nfet_01v8 L=0.5u W=1u
M20571 o7 ibias vss vss sky130_fd_pr__nfet_01v8 L=0.5u W=1u
M20572 o7 ibias vss vss sky130_fd_pr__nfet_01v8 L=0.5u W=1u
M20573 o7 ibias vss vss sky130_fd_pr__nfet_01v8 L=0.5u W=1u
M20574 o7 ibias vss vss sky130_fd_pr__nfet_01v8 L=0.5u W=1u
M20575 o7 ibias vss vss sky130_fd_pr__nfet_01v8 L=0.5u W=1u
M20576 o7 ibias vss vss sky130_fd_pr__nfet_01v8 L=0.5u W=1u
M20577 o7 ibias vss vss sky130_fd_pr__nfet_01v8 L=0.5u W=1u
M20578 o7 ibias vss vss sky130_fd_pr__nfet_01v8 L=0.5u W=1u
M20579 o7 ibias vss vss sky130_fd_pr__nfet_01v8 L=0.5u W=1u
M20580 o7 ibias vss vss sky130_fd_pr__nfet_01v8 L=0.5u W=1u
M20581 o7 ibias vss vss sky130_fd_pr__nfet_01v8 L=0.5u W=1u
M20582 o7 ibias vss vss sky130_fd_pr__nfet_01v8 L=0.5u W=1u
M20583 o7 ibias vss vss sky130_fd_pr__nfet_01v8 L=0.5u W=1u
M20584 o7 ibias vss vss sky130_fd_pr__nfet_01v8 L=0.5u W=1u
M20585 o7 ibias vss vss sky130_fd_pr__nfet_01v8 L=0.5u W=1u
M20586 o7 ibias vss vss sky130_fd_pr__nfet_01v8 L=0.5u W=1u
M20587 o7 ibias vss vss sky130_fd_pr__nfet_01v8 L=0.5u W=1u
M20588 o7 ibias vss vss sky130_fd_pr__nfet_01v8 L=0.5u W=1u
M20589 o7 ibias vss vss sky130_fd_pr__nfet_01v8 L=0.5u W=1u
M20590 o7 ibias vss vss sky130_fd_pr__nfet_01v8 L=0.5u W=1u
M20591 o7 ibias vss vss sky130_fd_pr__nfet_01v8 L=0.5u W=1u
M20592 o7 ibias vss vss sky130_fd_pr__nfet_01v8 L=0.5u W=1u
M20593 o7 ibias vss vss sky130_fd_pr__nfet_01v8 L=0.5u W=1u
M20594 o7 ibias vss vss sky130_fd_pr__nfet_01v8 L=0.5u W=1u
M20595 o7 ibias vss vss sky130_fd_pr__nfet_01v8 L=0.5u W=1u
M20596 o7 ibias vss vss sky130_fd_pr__nfet_01v8 L=0.5u W=1u
M20597 o7 ibias vss vss sky130_fd_pr__nfet_01v8 L=0.5u W=1u
M20598 o7 ibias vss vss sky130_fd_pr__nfet_01v8 L=0.5u W=1u
M20599 o7 ibias vss vss sky130_fd_pr__nfet_01v8 L=0.5u W=1u
M20600 o7 ibias vss vss sky130_fd_pr__nfet_01v8 L=0.5u W=1u
M20601 o7 ibias vss vss sky130_fd_pr__nfet_01v8 L=0.5u W=1u
M20602 o7 ibias vss vss sky130_fd_pr__nfet_01v8 L=0.5u W=1u
M20603 o7 ibias vss vss sky130_fd_pr__nfet_01v8 L=0.5u W=1u
M20604 o7 ibias vss vss sky130_fd_pr__nfet_01v8 L=0.5u W=1u
M20605 o7 ibias vss vss sky130_fd_pr__nfet_01v8 L=0.5u W=1u
M20606 o7 ibias vss vss sky130_fd_pr__nfet_01v8 L=0.5u W=1u
M20607 o7 ibias vss vss sky130_fd_pr__nfet_01v8 L=0.5u W=1u
M20608 o7 ibias vss vss sky130_fd_pr__nfet_01v8 L=0.5u W=1u
M20609 o7 ibias vss vss sky130_fd_pr__nfet_01v8 L=0.5u W=1u
M20610 o7 ibias vss vss sky130_fd_pr__nfet_01v8 L=0.5u W=1u
M20611 o7 ibias vss vss sky130_fd_pr__nfet_01v8 L=0.5u W=1u
M20612 o7 ibias vss vss sky130_fd_pr__nfet_01v8 L=0.5u W=1u
M20613 o7 ibias vss vss sky130_fd_pr__nfet_01v8 L=0.5u W=1u
M20614 o7 ibias vss vss sky130_fd_pr__nfet_01v8 L=0.5u W=1u
M20615 o7 ibias vss vss sky130_fd_pr__nfet_01v8 L=0.5u W=1u
M20616 o7 ibias vss vss sky130_fd_pr__nfet_01v8 L=0.5u W=1u
M20617 o7 ibias vss vss sky130_fd_pr__nfet_01v8 L=0.5u W=1u
M20618 o7 ibias vss vss sky130_fd_pr__nfet_01v8 L=0.5u W=1u
M20619 o7 ibias vss vss sky130_fd_pr__nfet_01v8 L=0.5u W=1u
M20620 o7 ibias vss vss sky130_fd_pr__nfet_01v8 L=0.5u W=1u
M20621 o7 ibias vss vss sky130_fd_pr__nfet_01v8 L=0.5u W=1u
M20622 o7 ibias vss vss sky130_fd_pr__nfet_01v8 L=0.5u W=1u
M20623 o7 ibias vss vss sky130_fd_pr__nfet_01v8 L=0.5u W=1u
M20624 o7 ibias vss vss sky130_fd_pr__nfet_01v8 L=0.5u W=1u
M20625 o7 ibias vss vss sky130_fd_pr__nfet_01v8 L=0.5u W=1u
M20626 o7 ibias vss vss sky130_fd_pr__nfet_01v8 L=0.5u W=1u
M20627 o7 ibias vss vss sky130_fd_pr__nfet_01v8 L=0.5u W=1u
M20628 o7 ibias vss vss sky130_fd_pr__nfet_01v8 L=0.5u W=1u
M20629 o7 ibias vss vss sky130_fd_pr__nfet_01v8 L=0.5u W=1u
M20630 o7 ibias vss vss sky130_fd_pr__nfet_01v8 L=0.5u W=1u
M20631 o7 ibias vss vss sky130_fd_pr__nfet_01v8 L=0.5u W=1u
M20632 o7 ibias vss vss sky130_fd_pr__nfet_01v8 L=0.5u W=1u
M20633 o7 ibias vss vss sky130_fd_pr__nfet_01v8 L=0.5u W=1u
M20634 o7 ibias vss vss sky130_fd_pr__nfet_01v8 L=0.5u W=1u
M20635 o7 ibias vss vss sky130_fd_pr__nfet_01v8 L=0.5u W=1u
M20636 o7 ibias vss vss sky130_fd_pr__nfet_01v8 L=0.5u W=1u
M20637 o7 ibias vss vss sky130_fd_pr__nfet_01v8 L=0.5u W=1u
M20638 o7 ibias vss vss sky130_fd_pr__nfet_01v8 L=0.5u W=1u
M20639 o7 ibias vss vss sky130_fd_pr__nfet_01v8 L=0.5u W=1u
M20640 o7 ibias vss vss sky130_fd_pr__nfet_01v8 L=0.5u W=1u
M20641 o7 ibias vss vss sky130_fd_pr__nfet_01v8 L=0.5u W=1u
M20642 o7 ibias vss vss sky130_fd_pr__nfet_01v8 L=0.5u W=1u
M20643 o7 ibias vss vss sky130_fd_pr__nfet_01v8 L=0.5u W=1u
M20644 o7 ibias vss vss sky130_fd_pr__nfet_01v8 L=0.5u W=1u
M20645 o7 ibias vss vss sky130_fd_pr__nfet_01v8 L=0.5u W=1u
M20646 o7 ibias vss vss sky130_fd_pr__nfet_01v8 L=0.5u W=1u
M20647 o7 ibias vss vss sky130_fd_pr__nfet_01v8 L=0.5u W=1u
M20648 o7 ibias vss vss sky130_fd_pr__nfet_01v8 L=0.5u W=1u
M20649 o7 ibias vss vss sky130_fd_pr__nfet_01v8 L=0.5u W=1u
M20650 o7 ibias vss vss sky130_fd_pr__nfet_01v8 L=0.5u W=1u
M20651 o7 ibias vss vss sky130_fd_pr__nfet_01v8 L=0.5u W=1u
M20652 o7 ibias vss vss sky130_fd_pr__nfet_01v8 L=0.5u W=1u
M20653 o7 ibias vss vss sky130_fd_pr__nfet_01v8 L=0.5u W=1u
M20654 o7 ibias vss vss sky130_fd_pr__nfet_01v8 L=0.5u W=1u
M20655 o7 ibias vss vss sky130_fd_pr__nfet_01v8 L=0.5u W=1u
M20656 ibias ibias vss vss sky130_fd_pr__nfet_01v8 L=0.5u W=1u
M20657 ibias ibias vss vss sky130_fd_pr__nfet_01v8 L=0.5u W=1u
M20658 ibias ibias vss vss sky130_fd_pr__nfet_01v8 L=0.5u W=1u
M20659 ibias ibias vss vss sky130_fd_pr__nfet_01v8 L=0.5u W=1u
M20660 ibias ibias vss vss sky130_fd_pr__nfet_01v8 L=0.5u W=1u
M20661 ibias ibias vss vss sky130_fd_pr__nfet_01v8 L=0.5u W=1u
M20662 ibias ibias vss vss sky130_fd_pr__nfet_01v8 L=0.5u W=1u
M20663 ibias ibias vss vss sky130_fd_pr__nfet_01v8 L=0.5u W=1u
M20664 ibias ibias vss vss sky130_fd_pr__nfet_01v8 L=0.5u W=1u
M20665 ibias ibias vss vss sky130_fd_pr__nfet_01v8 L=0.5u W=1u
M20666 ibias ibias vss vss sky130_fd_pr__nfet_01v8 L=0.5u W=1u
M20667 ibias ibias vss vss sky130_fd_pr__nfet_01v8 L=0.5u W=1u
M20668 ibias ibias vss vss sky130_fd_pr__nfet_01v8 L=0.5u W=1u
M20669 ibias ibias vss vss sky130_fd_pr__nfet_01v8 L=0.5u W=1u
M20670 ibias ibias vss vss sky130_fd_pr__nfet_01v8 L=0.5u W=1u
M20671 ibias ibias vss vss sky130_fd_pr__nfet_01v8 L=0.5u W=1u
M20672 ibias ibias vss vss sky130_fd_pr__nfet_01v8 L=0.5u W=1u
M20673 ibias ibias vss vss sky130_fd_pr__nfet_01v8 L=0.5u W=1u
M20674 ibias ibias vss vss sky130_fd_pr__nfet_01v8 L=0.5u W=1u
M20675 ibias ibias vss vss sky130_fd_pr__nfet_01v8 L=0.5u W=1u
M20676 ibias ibias vss vss sky130_fd_pr__nfet_01v8 L=0.5u W=1u
M20677 ibias ibias vss vss sky130_fd_pr__nfet_01v8 L=0.5u W=1u
M20678 ibias ibias vss vss sky130_fd_pr__nfet_01v8 L=0.5u W=1u
M20679 ibias ibias vss vss sky130_fd_pr__nfet_01v8 L=0.5u W=1u
M20680 ibias ibias vss vss sky130_fd_pr__nfet_01v8 L=0.5u W=1u
M20681 ibias ibias vss vss sky130_fd_pr__nfet_01v8 L=0.5u W=1u
M20682 ibias ibias vss vss sky130_fd_pr__nfet_01v8 L=0.5u W=1u
M20683 ibias ibias vss vss sky130_fd_pr__nfet_01v8 L=0.5u W=1u
M20684 ibias ibias vss vss sky130_fd_pr__nfet_01v8 L=0.5u W=1u
M20685 ibias ibias vss vss sky130_fd_pr__nfet_01v8 L=0.5u W=1u
M20686 ibias ibias vss vss sky130_fd_pr__nfet_01v8 L=0.5u W=1u
M20687 ibias ibias vss vss sky130_fd_pr__nfet_01v8 L=0.5u W=1u
M20688 ibias ibias vss vss sky130_fd_pr__nfet_01v8 L=0.5u W=1u
M20689 ibias ibias vss vss sky130_fd_pr__nfet_01v8 L=0.5u W=1u
M20690 ibias ibias vss vss sky130_fd_pr__nfet_01v8 L=0.5u W=1u
M20691 ibias ibias vss vss sky130_fd_pr__nfet_01v8 L=0.5u W=1u
M20692 ibias ibias vss vss sky130_fd_pr__nfet_01v8 L=0.5u W=1u
M20693 ibias ibias vss vss sky130_fd_pr__nfet_01v8 L=0.5u W=1u
M20694 ibias ibias vss vss sky130_fd_pr__nfet_01v8 L=0.5u W=1u
M20695 ibias ibias vss vss sky130_fd_pr__nfet_01v8 L=0.5u W=1u
M20696 ibias ibias vss vss sky130_fd_pr__nfet_01v8 L=0.5u W=1u
M20697 ibias ibias vss vss sky130_fd_pr__nfet_01v8 L=0.5u W=1u
M20698 ibias ibias vss vss sky130_fd_pr__nfet_01v8 L=0.5u W=1u
M20699 ibias ibias vss vss sky130_fd_pr__nfet_01v8 L=0.5u W=1u
M20700 ibias ibias vss vss sky130_fd_pr__nfet_01v8 L=0.5u W=1u
M20701 ibias ibias vss vss sky130_fd_pr__nfet_01v8 L=0.5u W=1u
M20702 ibias ibias vss vss sky130_fd_pr__nfet_01v8 L=0.5u W=1u
M20703 ibias ibias vss vss sky130_fd_pr__nfet_01v8 L=0.5u W=1u
M20704 ibias ibias vss vss sky130_fd_pr__nfet_01v8 L=0.5u W=1u
M20705 ibias ibias vss vss sky130_fd_pr__nfet_01v8 L=0.5u W=1u
M20706 ibias ibias vss vss sky130_fd_pr__nfet_01v8 L=0.5u W=1u
M20707 ibias ibias vss vss sky130_fd_pr__nfet_01v8 L=0.5u W=1u
M20708 ibias ibias vss vss sky130_fd_pr__nfet_01v8 L=0.5u W=1u
M20709 ibias ibias vss vss sky130_fd_pr__nfet_01v8 L=0.5u W=1u
M20710 ibias ibias vss vss sky130_fd_pr__nfet_01v8 L=0.5u W=1u
M20711 ibias ibias vss vss sky130_fd_pr__nfet_01v8 L=0.5u W=1u
M20712 ibias ibias vss vss sky130_fd_pr__nfet_01v8 L=0.5u W=1u
M20713 ibias ibias vss vss sky130_fd_pr__nfet_01v8 L=0.5u W=1u
M20714 ibias ibias vss vss sky130_fd_pr__nfet_01v8 L=0.5u W=1u
M20715 ibias ibias vss vss sky130_fd_pr__nfet_01v8 L=0.5u W=1u
M20716 ibias ibias vss vss sky130_fd_pr__nfet_01v8 L=0.5u W=1u
M20717 ibias ibias vss vss sky130_fd_pr__nfet_01v8 L=0.5u W=1u
M20718 ibias ibias vss vss sky130_fd_pr__nfet_01v8 L=0.5u W=1u
M20719 ibias ibias vss vss sky130_fd_pr__nfet_01v8 L=0.5u W=1u
M20720 ibias ibias vss vss sky130_fd_pr__nfet_01v8 L=0.5u W=1u
M20721 ibias ibias vss vss sky130_fd_pr__nfet_01v8 L=0.5u W=1u
M20722 ibias ibias vss vss sky130_fd_pr__nfet_01v8 L=0.5u W=1u
M20723 ibias ibias vss vss sky130_fd_pr__nfet_01v8 L=0.5u W=1u
M20724 ibias ibias vss vss sky130_fd_pr__nfet_01v8 L=0.5u W=1u
M20725 ibias ibias vss vss sky130_fd_pr__nfet_01v8 L=0.5u W=1u
M20726 ibias ibias vss vss sky130_fd_pr__nfet_01v8 L=0.5u W=1u
M20727 ibias ibias vss vss sky130_fd_pr__nfet_01v8 L=0.5u W=1u
M20728 ibias ibias vss vss sky130_fd_pr__nfet_01v8 L=0.5u W=1u
M20729 ibias ibias vss vss sky130_fd_pr__nfet_01v8 L=0.5u W=1u
M20730 ibias ibias vss vss sky130_fd_pr__nfet_01v8 L=0.5u W=1u
M20731 ibias ibias vss vss sky130_fd_pr__nfet_01v8 L=0.5u W=1u
M20732 ibias ibias vss vss sky130_fd_pr__nfet_01v8 L=0.5u W=1u
M20733 ibias ibias vss vss sky130_fd_pr__nfet_01v8 L=0.5u W=1u
M20734 ibias ibias vss vss sky130_fd_pr__nfet_01v8 L=0.5u W=1u
M20735 ibias ibias vss vss sky130_fd_pr__nfet_01v8 L=0.5u W=1u
M20736 ibias ibias vss vss sky130_fd_pr__nfet_01v8 L=0.5u W=1u
M20737 ibias ibias vss vss sky130_fd_pr__nfet_01v8 L=0.5u W=1u
M20738 ibias ibias vss vss sky130_fd_pr__nfet_01v8 L=0.5u W=1u
M20739 ibias ibias vss vss sky130_fd_pr__nfet_01v8 L=0.5u W=1u
M20740 ibias ibias vss vss sky130_fd_pr__nfet_01v8 L=0.5u W=1u
M20741 ibias ibias vss vss sky130_fd_pr__nfet_01v8 L=0.5u W=1u
M20742 ibias ibias vss vss sky130_fd_pr__nfet_01v8 L=0.5u W=1u
M20743 ibias ibias vss vss sky130_fd_pr__nfet_01v8 L=0.5u W=1u
M20744 ibias ibias vss vss sky130_fd_pr__nfet_01v8 L=0.5u W=1u
M20745 ibias ibias vss vss sky130_fd_pr__nfet_01v8 L=0.5u W=1u
M20746 ibias ibias vss vss sky130_fd_pr__nfet_01v8 L=0.5u W=1u
M20747 ibias ibias vss vss sky130_fd_pr__nfet_01v8 L=0.5u W=1u
M20748 ibias ibias vss vss sky130_fd_pr__nfet_01v8 L=0.5u W=1u
M20749 ibias ibias vss vss sky130_fd_pr__nfet_01v8 L=0.5u W=1u
M20750 ibias ibias vss vss sky130_fd_pr__nfet_01v8 L=0.5u W=1u
M20751 ibias ibias vss vss sky130_fd_pr__nfet_01v8 L=0.5u W=1u
M20752 ibias ibias vss vss sky130_fd_pr__nfet_01v8 L=0.5u W=1u
M20753 ibias ibias vss vss sky130_fd_pr__nfet_01v8 L=0.5u W=1u
M20754 ibias ibias vss vss sky130_fd_pr__nfet_01v8 L=0.5u W=1u
M20755 ibias ibias vss vss sky130_fd_pr__nfet_01v8 L=0.5u W=1u
M20756 ibias ibias vss vss sky130_fd_pr__nfet_01v8 L=0.5u W=1u
M20757 ibias ibias vss vss sky130_fd_pr__nfet_01v8 L=0.5u W=1u
M20758 ibias ibias vss vss sky130_fd_pr__nfet_01v8 L=0.5u W=1u
M20759 ibias ibias vss vss sky130_fd_pr__nfet_01v8 L=0.5u W=1u
M20760 ibias ibias vss vss sky130_fd_pr__nfet_01v8 L=0.5u W=1u
M20761 ibias ibias vss vss sky130_fd_pr__nfet_01v8 L=0.5u W=1u
M20762 ibias ibias vss vss sky130_fd_pr__nfet_01v8 L=0.5u W=1u
M20763 ibias ibias vss vss sky130_fd_pr__nfet_01v8 L=0.5u W=1u
M20764 ibias ibias vss vss sky130_fd_pr__nfet_01v8 L=0.5u W=1u
M20765 ibias ibias vss vss sky130_fd_pr__nfet_01v8 L=0.5u W=1u
M20766 ibias ibias vss vss sky130_fd_pr__nfet_01v8 L=0.5u W=1u
M20767 ibias ibias vss vss sky130_fd_pr__nfet_01v8 L=0.5u W=1u
M20768 ibias ibias vss vss sky130_fd_pr__nfet_01v8 L=0.5u W=1u
M20769 ibias ibias vss vss sky130_fd_pr__nfet_01v8 L=0.5u W=1u
M20770 ibias ibias vss vss sky130_fd_pr__nfet_01v8 L=0.5u W=1u
M20771 ibias ibias vss vss sky130_fd_pr__nfet_01v8 L=0.5u W=1u
M20772 ibias ibias vss vss sky130_fd_pr__nfet_01v8 L=0.5u W=1u
M20773 ibias ibias vss vss sky130_fd_pr__nfet_01v8 L=0.5u W=1u
M20774 ibias ibias vss vss sky130_fd_pr__nfet_01v8 L=0.5u W=1u
M20775 ibias ibias vss vss sky130_fd_pr__nfet_01v8 L=0.5u W=1u
M20776 ibias ibias vss vss sky130_fd_pr__nfet_01v8 L=0.5u W=1u
M20777 ibias ibias vss vss sky130_fd_pr__nfet_01v8 L=0.5u W=1u
M20778 ibias ibias vss vss sky130_fd_pr__nfet_01v8 L=0.5u W=1u
M20779 ibias ibias vss vss sky130_fd_pr__nfet_01v8 L=0.5u W=1u
M20780 ibias ibias vss vss sky130_fd_pr__nfet_01v8 L=0.5u W=1u
M20781 ibias ibias vss vss sky130_fd_pr__nfet_01v8 L=0.5u W=1u
M20782 ibias ibias vss vss sky130_fd_pr__nfet_01v8 L=0.5u W=1u
M20783 ibias ibias vss vss sky130_fd_pr__nfet_01v8 L=0.5u W=1u
M20784 ibias ibias vss vss sky130_fd_pr__nfet_01v8 L=0.5u W=1u
M20785 ibias ibias vss vss sky130_fd_pr__nfet_01v8 L=0.5u W=1u
M20786 ibias ibias vss vss sky130_fd_pr__nfet_01v8 L=0.5u W=1u
M20787 ibias ibias vss vss sky130_fd_pr__nfet_01v8 L=0.5u W=1u
M20788 ibias ibias vss vss sky130_fd_pr__nfet_01v8 L=0.5u W=1u
M20789 ibias ibias vss vss sky130_fd_pr__nfet_01v8 L=0.5u W=1u
M20790 ibias ibias vss vss sky130_fd_pr__nfet_01v8 L=0.5u W=1u
M20791 ibias ibias vss vss sky130_fd_pr__nfet_01v8 L=0.5u W=1u
M20792 ibias ibias vss vss sky130_fd_pr__nfet_01v8 L=0.5u W=1u
M20793 ibias ibias vss vss sky130_fd_pr__nfet_01v8 L=0.5u W=1u
M20794 ibias ibias vss vss sky130_fd_pr__nfet_01v8 L=0.5u W=1u
M20795 ibias ibias vss vss sky130_fd_pr__nfet_01v8 L=0.5u W=1u
M20796 ibias ibias vss vss sky130_fd_pr__nfet_01v8 L=0.5u W=1u
M20797 ibias ibias vss vss sky130_fd_pr__nfet_01v8 L=0.5u W=1u
M20798 ibias ibias vss vss sky130_fd_pr__nfet_01v8 L=0.5u W=1u
M20799 ibias ibias vss vss sky130_fd_pr__nfet_01v8 L=0.5u W=1u
M20800 ibias ibias vss vss sky130_fd_pr__nfet_01v8 L=0.5u W=1u
M20801 ibias ibias vss vss sky130_fd_pr__nfet_01v8 L=0.5u W=1u
M20802 ibias ibias vss vss sky130_fd_pr__nfet_01v8 L=0.5u W=1u
M20803 ibias ibias vss vss sky130_fd_pr__nfet_01v8 L=0.5u W=1u
M20804 ibias ibias vss vss sky130_fd_pr__nfet_01v8 L=0.5u W=1u
M20805 ibias ibias vss vss sky130_fd_pr__nfet_01v8 L=0.5u W=1u
M20806 ibias ibias vss vss sky130_fd_pr__nfet_01v8 L=0.5u W=1u
M20807 ibias ibias vss vss sky130_fd_pr__nfet_01v8 L=0.5u W=1u
M20808 ibias ibias vss vss sky130_fd_pr__nfet_01v8 L=0.5u W=1u
M20809 ibias ibias vss vss sky130_fd_pr__nfet_01v8 L=0.5u W=1u
M20810 ibias ibias vss vss sky130_fd_pr__nfet_01v8 L=0.5u W=1u
M20811 ibias ibias vss vss sky130_fd_pr__nfet_01v8 L=0.5u W=1u
M20812 ibias ibias vss vss sky130_fd_pr__nfet_01v8 L=0.5u W=1u
M20813 ibias ibias vss vss sky130_fd_pr__nfet_01v8 L=0.5u W=1u
M20814 ibias ibias vss vss sky130_fd_pr__nfet_01v8 L=0.5u W=1u
M20815 ibias ibias vss vss sky130_fd_pr__nfet_01v8 L=0.5u W=1u
M20816 ibias ibias vss vss sky130_fd_pr__nfet_01v8 L=0.5u W=1u
M20817 ibias ibias vss vss sky130_fd_pr__nfet_01v8 L=0.5u W=1u
M20818 ibias ibias vss vss sky130_fd_pr__nfet_01v8 L=0.5u W=1u
M20819 ibias ibias vss vss sky130_fd_pr__nfet_01v8 L=0.5u W=1u
M20820 ibias ibias vss vss sky130_fd_pr__nfet_01v8 L=0.5u W=1u
M20821 ibias ibias vss vss sky130_fd_pr__nfet_01v8 L=0.5u W=1u
M20822 ibias ibias vss vss sky130_fd_pr__nfet_01v8 L=0.5u W=1u
M20823 ibias ibias vss vss sky130_fd_pr__nfet_01v8 L=0.5u W=1u
M20824 ibias ibias vss vss sky130_fd_pr__nfet_01v8 L=0.5u W=1u
M20825 ibias ibias vss vss sky130_fd_pr__nfet_01v8 L=0.5u W=1u
M20826 ibias ibias vss vss sky130_fd_pr__nfet_01v8 L=0.5u W=1u
M20827 ibias ibias vss vss sky130_fd_pr__nfet_01v8 L=0.5u W=1u
M20828 ibias ibias vss vss sky130_fd_pr__nfet_01v8 L=0.5u W=1u
M20829 ibias ibias vss vss sky130_fd_pr__nfet_01v8 L=0.5u W=1u
M20830 ibias ibias vss vss sky130_fd_pr__nfet_01v8 L=0.5u W=1u
M20831 ibias ibias vss vss sky130_fd_pr__nfet_01v8 L=0.5u W=1u
M20832 ibias ibias vss vss sky130_fd_pr__nfet_01v8 L=0.5u W=1u
M20833 ibias ibias vss vss sky130_fd_pr__nfet_01v8 L=0.5u W=1u
M20834 ibias ibias vss vss sky130_fd_pr__nfet_01v8 L=0.5u W=1u
M20835 ibias ibias vss vss sky130_fd_pr__nfet_01v8 L=0.5u W=1u
M20836 ibias ibias vss vss sky130_fd_pr__nfet_01v8 L=0.5u W=1u
M20837 ibias ibias vss vss sky130_fd_pr__nfet_01v8 L=0.5u W=1u
M20838 ibias ibias vss vss sky130_fd_pr__nfet_01v8 L=0.5u W=1u
M20839 ibias ibias vss vss sky130_fd_pr__nfet_01v8 L=0.5u W=1u
M20840 ibias ibias vss vss sky130_fd_pr__nfet_01v8 L=0.5u W=1u
M20841 ibias ibias vss vss sky130_fd_pr__nfet_01v8 L=0.5u W=1u
M20842 ibias ibias vss vss sky130_fd_pr__nfet_01v8 L=0.5u W=1u
M20843 ibias ibias vss vss sky130_fd_pr__nfet_01v8 L=0.5u W=1u
M20844 ibias ibias vss vss sky130_fd_pr__nfet_01v8 L=0.5u W=1u
M20845 ibias ibias vss vss sky130_fd_pr__nfet_01v8 L=0.5u W=1u
M20846 ibias ibias vss vss sky130_fd_pr__nfet_01v8 L=0.5u W=1u
M20847 ibias ibias vss vss sky130_fd_pr__nfet_01v8 L=0.5u W=1u
M20848 ibias ibias vss vss sky130_fd_pr__nfet_01v8 L=0.5u W=1u
M20849 ibias ibias vss vss sky130_fd_pr__nfet_01v8 L=0.5u W=1u
M20850 ibias ibias vss vss sky130_fd_pr__nfet_01v8 L=0.5u W=1u
M20851 ibias ibias vss vss sky130_fd_pr__nfet_01v8 L=0.5u W=1u
M20852 ibias ibias vss vss sky130_fd_pr__nfet_01v8 L=0.5u W=1u
M20853 ibias ibias vss vss sky130_fd_pr__nfet_01v8 L=0.5u W=1u
M20854 ibias ibias vss vss sky130_fd_pr__nfet_01v8 L=0.5u W=1u
M20855 ibias ibias vss vss sky130_fd_pr__nfet_01v8 L=0.5u W=1u
M20856 ibias ibias vss vss sky130_fd_pr__nfet_01v8 L=0.5u W=1u
M20857 ibias ibias vss vss sky130_fd_pr__nfet_01v8 L=0.5u W=1u
M20858 ibias ibias vss vss sky130_fd_pr__nfet_01v8 L=0.5u W=1u
M20859 ibias ibias vss vss sky130_fd_pr__nfet_01v8 L=0.5u W=1u
M20860 ibias ibias vss vss sky130_fd_pr__nfet_01v8 L=0.5u W=1u
M20861 ibias ibias vss vss sky130_fd_pr__nfet_01v8 L=0.5u W=1u
M20862 ibias ibias vss vss sky130_fd_pr__nfet_01v8 L=0.5u W=1u
M20863 ibias ibias vss vss sky130_fd_pr__nfet_01v8 L=0.5u W=1u
M20864 ibias ibias vss vss sky130_fd_pr__nfet_01v8 L=0.5u W=1u
M20865 ibias ibias vss vss sky130_fd_pr__nfet_01v8 L=0.5u W=1u
M20866 ibias ibias vss vss sky130_fd_pr__nfet_01v8 L=0.5u W=1u
M20867 ibias ibias vss vss sky130_fd_pr__nfet_01v8 L=0.5u W=1u
M20868 ibias ibias vss vss sky130_fd_pr__nfet_01v8 L=0.5u W=1u
M20869 ibias ibias vss vss sky130_fd_pr__nfet_01v8 L=0.5u W=1u
M20870 ibias ibias vss vss sky130_fd_pr__nfet_01v8 L=0.5u W=1u
M20871 ibias ibias vss vss sky130_fd_pr__nfet_01v8 L=0.5u W=1u
M20872 ibias ibias vss vss sky130_fd_pr__nfet_01v8 L=0.5u W=1u
M20873 ibias ibias vss vss sky130_fd_pr__nfet_01v8 L=0.5u W=1u
M20874 ibias ibias vss vss sky130_fd_pr__nfet_01v8 L=0.5u W=1u
M20875 ibias ibias vss vss sky130_fd_pr__nfet_01v8 L=0.5u W=1u
M20876 ibias ibias vss vss sky130_fd_pr__nfet_01v8 L=0.5u W=1u
M20877 ibias ibias vss vss sky130_fd_pr__nfet_01v8 L=0.5u W=1u
M20878 ibias ibias vss vss sky130_fd_pr__nfet_01v8 L=0.5u W=1u
M20879 ibias ibias vss vss sky130_fd_pr__nfet_01v8 L=0.5u W=1u
M20880 ibias ibias vss vss sky130_fd_pr__nfet_01v8 L=0.5u W=1u
M20881 ibias ibias vss vss sky130_fd_pr__nfet_01v8 L=0.5u W=1u
M20882 ibias ibias vss vss sky130_fd_pr__nfet_01v8 L=0.5u W=1u
M20883 ibias ibias vss vss sky130_fd_pr__nfet_01v8 L=0.5u W=1u
M20884 ibias ibias vss vss sky130_fd_pr__nfet_01v8 L=0.5u W=1u
M20885 ibias ibias vss vss sky130_fd_pr__nfet_01v8 L=0.5u W=1u
M20886 ibias ibias vss vss sky130_fd_pr__nfet_01v8 L=0.5u W=1u
M20887 ibias ibias vss vss sky130_fd_pr__nfet_01v8 L=0.5u W=1u
M20888 ibias ibias vss vss sky130_fd_pr__nfet_01v8 L=0.5u W=1u
M20889 ibias ibias vss vss sky130_fd_pr__nfet_01v8 L=0.5u W=1u
M20890 ibias ibias vss vss sky130_fd_pr__nfet_01v8 L=0.5u W=1u
M20891 ibias ibias vss vss sky130_fd_pr__nfet_01v8 L=0.5u W=1u
M20892 ibias ibias vss vss sky130_fd_pr__nfet_01v8 L=0.5u W=1u
M20893 ibias ibias vss vss sky130_fd_pr__nfet_01v8 L=0.5u W=1u
M20894 ibias ibias vss vss sky130_fd_pr__nfet_01v8 L=0.5u W=1u
M20895 ibias ibias vss vss sky130_fd_pr__nfet_01v8 L=0.5u W=1u
M20896 ibias ibias vss vss sky130_fd_pr__nfet_01v8 L=0.5u W=1u
M20897 ibias ibias vss vss sky130_fd_pr__nfet_01v8 L=0.5u W=1u
M20898 ibias ibias vss vss sky130_fd_pr__nfet_01v8 L=0.5u W=1u
M20899 ibias ibias vss vss sky130_fd_pr__nfet_01v8 L=0.5u W=1u
M20900 ibias ibias vss vss sky130_fd_pr__nfet_01v8 L=0.5u W=1u
M20901 ibias ibias vss vss sky130_fd_pr__nfet_01v8 L=0.5u W=1u
M20902 ibias ibias vss vss sky130_fd_pr__nfet_01v8 L=0.5u W=1u
M20903 ibias ibias vss vss sky130_fd_pr__nfet_01v8 L=0.5u W=1u
M20904 ibias ibias vss vss sky130_fd_pr__nfet_01v8 L=0.5u W=1u
M20905 ibias ibias vss vss sky130_fd_pr__nfet_01v8 L=0.5u W=1u
M20906 ibias ibias vss vss sky130_fd_pr__nfet_01v8 L=0.5u W=1u
M20907 ibias ibias vss vss sky130_fd_pr__nfet_01v8 L=0.5u W=1u
M20908 ibias ibias vss vss sky130_fd_pr__nfet_01v8 L=0.5u W=1u
M20909 ibias ibias vss vss sky130_fd_pr__nfet_01v8 L=0.5u W=1u
M20910 ibias ibias vss vss sky130_fd_pr__nfet_01v8 L=0.5u W=1u
M20911 ibias ibias vss vss sky130_fd_pr__nfet_01v8 L=0.5u W=1u
M20912 ibias ibias vss vss sky130_fd_pr__nfet_01v8 L=0.5u W=1u
M20913 ibias ibias vss vss sky130_fd_pr__nfet_01v8 L=0.5u W=1u
M20914 ibias ibias vss vss sky130_fd_pr__nfet_01v8 L=0.5u W=1u
M20915 ibias ibias vss vss sky130_fd_pr__nfet_01v8 L=0.5u W=1u
M20916 ibias ibias vss vss sky130_fd_pr__nfet_01v8 L=0.5u W=1u
M20917 ibias ibias vss vss sky130_fd_pr__nfet_01v8 L=0.5u W=1u
M20918 ibias ibias vss vss sky130_fd_pr__nfet_01v8 L=0.5u W=1u
M20919 ibias ibias vss vss sky130_fd_pr__nfet_01v8 L=0.5u W=1u
M20920 ibias ibias vss vss sky130_fd_pr__nfet_01v8 L=0.5u W=1u
M20921 ibias ibias vss vss sky130_fd_pr__nfet_01v8 L=0.5u W=1u
M20922 ibias ibias vss vss sky130_fd_pr__nfet_01v8 L=0.5u W=1u
M20923 ibias ibias vss vss sky130_fd_pr__nfet_01v8 L=0.5u W=1u
M20924 ibias ibias vss vss sky130_fd_pr__nfet_01v8 L=0.5u W=1u
M20925 ibias ibias vss vss sky130_fd_pr__nfet_01v8 L=0.5u W=1u
M20926 ibias ibias vss vss sky130_fd_pr__nfet_01v8 L=0.5u W=1u
M20927 ibias ibias vss vss sky130_fd_pr__nfet_01v8 L=0.5u W=1u
M20928 ibias ibias vss vss sky130_fd_pr__nfet_01v8 L=0.5u W=1u
M20929 ibias ibias vss vss sky130_fd_pr__nfet_01v8 L=0.5u W=1u
M20930 ibias ibias vss vss sky130_fd_pr__nfet_01v8 L=0.5u W=1u
M20931 ibias ibias vss vss sky130_fd_pr__nfet_01v8 L=0.5u W=1u
M20932 ibias ibias vss vss sky130_fd_pr__nfet_01v8 L=0.5u W=1u
M20933 ibias ibias vss vss sky130_fd_pr__nfet_01v8 L=0.5u W=1u
M20934 ibias ibias vss vss sky130_fd_pr__nfet_01v8 L=0.5u W=1u
M20935 ibias ibias vss vss sky130_fd_pr__nfet_01v8 L=0.5u W=1u
M20936 ibias ibias vss vss sky130_fd_pr__nfet_01v8 L=0.5u W=1u
M20937 ibias ibias vss vss sky130_fd_pr__nfet_01v8 L=0.5u W=1u
M20938 ibias ibias vss vss sky130_fd_pr__nfet_01v8 L=0.5u W=1u
M20939 ibias ibias vss vss sky130_fd_pr__nfet_01v8 L=0.5u W=1u
M20940 ibias ibias vss vss sky130_fd_pr__nfet_01v8 L=0.5u W=1u
M20941 ibias ibias vss vss sky130_fd_pr__nfet_01v8 L=0.5u W=1u
M20942 ibias ibias vss vss sky130_fd_pr__nfet_01v8 L=0.5u W=1u
M20943 ibias ibias vss vss sky130_fd_pr__nfet_01v8 L=0.5u W=1u
M20944 ibias ibias vss vss sky130_fd_pr__nfet_01v8 L=0.5u W=1u
M20945 ibias ibias vss vss sky130_fd_pr__nfet_01v8 L=0.5u W=1u
M20946 ibias ibias vss vss sky130_fd_pr__nfet_01v8 L=0.5u W=1u
M20947 ibias ibias vss vss sky130_fd_pr__nfet_01v8 L=0.5u W=1u
M20948 ibias ibias vss vss sky130_fd_pr__nfet_01v8 L=0.5u W=1u
M20949 ibias ibias vss vss sky130_fd_pr__nfet_01v8 L=0.5u W=1u
M20950 ibias ibias vss vss sky130_fd_pr__nfet_01v8 L=0.5u W=1u
M20951 ibias ibias vss vss sky130_fd_pr__nfet_01v8 L=0.5u W=1u
M20952 ibias ibias vss vss sky130_fd_pr__nfet_01v8 L=0.5u W=1u
M20953 ibias ibias vss vss sky130_fd_pr__nfet_01v8 L=0.5u W=1u
M20954 ibias ibias vss vss sky130_fd_pr__nfet_01v8 L=0.5u W=1u
M20955 ibias ibias vss vss sky130_fd_pr__nfet_01v8 L=0.5u W=1u
M20956 ibias ibias vss vss sky130_fd_pr__nfet_01v8 L=0.5u W=1u
M20957 ibias ibias vss vss sky130_fd_pr__nfet_01v8 L=0.5u W=1u
M20958 ibias ibias vss vss sky130_fd_pr__nfet_01v8 L=0.5u W=1u
M20959 ibias ibias vss vss sky130_fd_pr__nfet_01v8 L=0.5u W=1u
M20960 ibias ibias vss vss sky130_fd_pr__nfet_01v8 L=0.5u W=1u
M20961 ibias ibias vss vss sky130_fd_pr__nfet_01v8 L=0.5u W=1u
M20962 ibias ibias vss vss sky130_fd_pr__nfet_01v8 L=0.5u W=1u
M20963 ibias ibias vss vss sky130_fd_pr__nfet_01v8 L=0.5u W=1u
M20964 ibias ibias vss vss sky130_fd_pr__nfet_01v8 L=0.5u W=1u
M20965 ibias ibias vss vss sky130_fd_pr__nfet_01v8 L=0.5u W=1u
M20966 ibias ibias vss vss sky130_fd_pr__nfet_01v8 L=0.5u W=1u
M20967 ibias ibias vss vss sky130_fd_pr__nfet_01v8 L=0.5u W=1u
M20968 ibias ibias vss vss sky130_fd_pr__nfet_01v8 L=0.5u W=1u
M20969 ibias ibias vss vss sky130_fd_pr__nfet_01v8 L=0.5u W=1u
M20970 ibias ibias vss vss sky130_fd_pr__nfet_01v8 L=0.5u W=1u
M20971 ibias ibias vss vss sky130_fd_pr__nfet_01v8 L=0.5u W=1u
M20972 ibias ibias vss vss sky130_fd_pr__nfet_01v8 L=0.5u W=1u
M20973 ibias ibias vss vss sky130_fd_pr__nfet_01v8 L=0.5u W=1u
M20974 ibias ibias vss vss sky130_fd_pr__nfet_01v8 L=0.5u W=1u
M20975 ibias ibias vss vss sky130_fd_pr__nfet_01v8 L=0.5u W=1u
M20976 ibias ibias vss vss sky130_fd_pr__nfet_01v8 L=0.5u W=1u
M20977 ibias ibias vss vss sky130_fd_pr__nfet_01v8 L=0.5u W=1u
M20978 ibias ibias vss vss sky130_fd_pr__nfet_01v8 L=0.5u W=1u
M20979 ibias ibias vss vss sky130_fd_pr__nfet_01v8 L=0.5u W=1u
M20980 ibias ibias vss vss sky130_fd_pr__nfet_01v8 L=0.5u W=1u
M20981 ibias ibias vss vss sky130_fd_pr__nfet_01v8 L=0.5u W=1u
M20982 ibias ibias vss vss sky130_fd_pr__nfet_01v8 L=0.5u W=1u
M20983 ibias ibias vss vss sky130_fd_pr__nfet_01v8 L=0.5u W=1u
M20984 ibias ibias vss vss sky130_fd_pr__nfet_01v8 L=0.5u W=1u
M20985 ibias ibias vss vss sky130_fd_pr__nfet_01v8 L=0.5u W=1u
M20986 ibias ibias vss vss sky130_fd_pr__nfet_01v8 L=0.5u W=1u
M20987 ibias ibias vss vss sky130_fd_pr__nfet_01v8 L=0.5u W=1u
M20988 ibias ibias vss vss sky130_fd_pr__nfet_01v8 L=0.5u W=1u
M20989 ibias ibias vss vss sky130_fd_pr__nfet_01v8 L=0.5u W=1u
M20990 ibias ibias vss vss sky130_fd_pr__nfet_01v8 L=0.5u W=1u
M20991 ibias ibias vss vss sky130_fd_pr__nfet_01v8 L=0.5u W=1u
M20992 ibias ibias vss vss sky130_fd_pr__nfet_01v8 L=0.5u W=1u
M20993 ibias ibias vss vss sky130_fd_pr__nfet_01v8 L=0.5u W=1u
M20994 ibias ibias vss vss sky130_fd_pr__nfet_01v8 L=0.5u W=1u
M20995 ibias ibias vss vss sky130_fd_pr__nfet_01v8 L=0.5u W=1u
M20996 ibias ibias vss vss sky130_fd_pr__nfet_01v8 L=0.5u W=1u
M20997 ibias ibias vss vss sky130_fd_pr__nfet_01v8 L=0.5u W=1u
M20998 ibias ibias vss vss sky130_fd_pr__nfet_01v8 L=0.5u W=1u
M20999 ibias ibias vss vss sky130_fd_pr__nfet_01v8 L=0.5u W=1u
M21000 ibias ibias vss vss sky130_fd_pr__nfet_01v8 L=0.5u W=1u
M21001 ibias ibias vss vss sky130_fd_pr__nfet_01v8 L=0.5u W=1u
M21002 ibias ibias vss vss sky130_fd_pr__nfet_01v8 L=0.5u W=1u
M21003 ibias ibias vss vss sky130_fd_pr__nfet_01v8 L=0.5u W=1u
M21004 ibias ibias vss vss sky130_fd_pr__nfet_01v8 L=0.5u W=1u
M21005 ibias ibias vss vss sky130_fd_pr__nfet_01v8 L=0.5u W=1u
M21006 ibias ibias vss vss sky130_fd_pr__nfet_01v8 L=0.5u W=1u
M21007 ibias ibias vss vss sky130_fd_pr__nfet_01v8 L=0.5u W=1u
M21008 ibias ibias vss vss sky130_fd_pr__nfet_01v8 L=0.5u W=1u
M21009 ibias ibias vss vss sky130_fd_pr__nfet_01v8 L=0.5u W=1u
M21010 ibias ibias vss vss sky130_fd_pr__nfet_01v8 L=0.5u W=1u
M21011 ibias ibias vss vss sky130_fd_pr__nfet_01v8 L=0.5u W=1u
M21012 ibias ibias vss vss sky130_fd_pr__nfet_01v8 L=0.5u W=1u
M21013 ibias ibias vss vss sky130_fd_pr__nfet_01v8 L=0.5u W=1u
M21014 ibias ibias vss vss sky130_fd_pr__nfet_01v8 L=0.5u W=1u
M21015 ibias ibias vss vss sky130_fd_pr__nfet_01v8 L=0.5u W=1u
M21016 ibias ibias vss vss sky130_fd_pr__nfet_01v8 L=0.5u W=1u
M21017 ibias ibias vss vss sky130_fd_pr__nfet_01v8 L=0.5u W=1u
M21018 ibias ibias vss vss sky130_fd_pr__nfet_01v8 L=0.5u W=1u
M21019 ibias ibias vss vss sky130_fd_pr__nfet_01v8 L=0.5u W=1u
M21020 ibias ibias vss vss sky130_fd_pr__nfet_01v8 L=0.5u W=1u
M21021 ibias ibias vss vss sky130_fd_pr__nfet_01v8 L=0.5u W=1u
M21022 ibias ibias vss vss sky130_fd_pr__nfet_01v8 L=0.5u W=1u
M21023 ibias ibias vss vss sky130_fd_pr__nfet_01v8 L=0.5u W=1u
M21024 ibias ibias vss vss sky130_fd_pr__nfet_01v8 L=0.5u W=1u
M21025 ibias ibias vss vss sky130_fd_pr__nfet_01v8 L=0.5u W=1u
M21026 ibias ibias vss vss sky130_fd_pr__nfet_01v8 L=0.5u W=1u
M21027 ibias ibias vss vss sky130_fd_pr__nfet_01v8 L=0.5u W=1u
M21028 ibias ibias vss vss sky130_fd_pr__nfet_01v8 L=0.5u W=1u
M21029 ibias ibias vss vss sky130_fd_pr__nfet_01v8 L=0.5u W=1u
M21030 ibias ibias vss vss sky130_fd_pr__nfet_01v8 L=0.5u W=1u
M21031 ibias ibias vss vss sky130_fd_pr__nfet_01v8 L=0.5u W=1u
M21032 ibias ibias vss vss sky130_fd_pr__nfet_01v8 L=0.5u W=1u
M21033 ibias ibias vss vss sky130_fd_pr__nfet_01v8 L=0.5u W=1u
M21034 ibias ibias vss vss sky130_fd_pr__nfet_01v8 L=0.5u W=1u
M21035 ibias ibias vss vss sky130_fd_pr__nfet_01v8 L=0.5u W=1u
M21036 ibias ibias vss vss sky130_fd_pr__nfet_01v8 L=0.5u W=1u
M21037 ibias ibias vss vss sky130_fd_pr__nfet_01v8 L=0.5u W=1u
M21038 ibias ibias vss vss sky130_fd_pr__nfet_01v8 L=0.5u W=1u
M21039 ibias ibias vss vss sky130_fd_pr__nfet_01v8 L=0.5u W=1u
M21040 outn inp tail vss sky130_fd_pr__nfet_01v8 L=0.5u W=1u
M21041 outn inp tail vss sky130_fd_pr__nfet_01v8 L=0.5u W=1u
M21042 outn inp tail vss sky130_fd_pr__nfet_01v8 L=0.5u W=1u
M21043 outn inp tail vss sky130_fd_pr__nfet_01v8 L=0.5u W=1u
M21044 outn inp tail vss sky130_fd_pr__nfet_01v8 L=0.5u W=1u
M21045 outn inp tail vss sky130_fd_pr__nfet_01v8 L=0.5u W=1u
M21046 outn inp tail vss sky130_fd_pr__nfet_01v8 L=0.5u W=1u
M21047 outn inp tail vss sky130_fd_pr__nfet_01v8 L=0.5u W=1u
M21048 outn inp tail vss sky130_fd_pr__nfet_01v8 L=0.5u W=1u
M21049 outn inp tail vss sky130_fd_pr__nfet_01v8 L=0.5u W=1u
M21050 outn inp tail vss sky130_fd_pr__nfet_01v8 L=0.5u W=1u
M21051 outn inp tail vss sky130_fd_pr__nfet_01v8 L=0.5u W=1u
M21052 outn inp tail vss sky130_fd_pr__nfet_01v8 L=0.5u W=1u
M21053 outn inp tail vss sky130_fd_pr__nfet_01v8 L=0.5u W=1u
M21054 outn inp tail vss sky130_fd_pr__nfet_01v8 L=0.5u W=1u
M21055 outn inp tail vss sky130_fd_pr__nfet_01v8 L=0.5u W=1u
M21056 outn inp tail vss sky130_fd_pr__nfet_01v8 L=0.5u W=1u
M21057 outn inp tail vss sky130_fd_pr__nfet_01v8 L=0.5u W=1u
M21058 outn inp tail vss sky130_fd_pr__nfet_01v8 L=0.5u W=1u
M21059 outn inp tail vss sky130_fd_pr__nfet_01v8 L=0.5u W=1u
M21060 outn inp tail vss sky130_fd_pr__nfet_01v8 L=0.5u W=1u
M21061 outn inp tail vss sky130_fd_pr__nfet_01v8 L=0.5u W=1u
M21062 outn inp tail vss sky130_fd_pr__nfet_01v8 L=0.5u W=1u
M21063 outn inp tail vss sky130_fd_pr__nfet_01v8 L=0.5u W=1u
M21064 outn inp tail vss sky130_fd_pr__nfet_01v8 L=0.5u W=1u
M21065 outn inp tail vss sky130_fd_pr__nfet_01v8 L=0.5u W=1u
M21066 outn inp tail vss sky130_fd_pr__nfet_01v8 L=0.5u W=1u
M21067 outn inp tail vss sky130_fd_pr__nfet_01v8 L=0.5u W=1u
M21068 outn inp tail vss sky130_fd_pr__nfet_01v8 L=0.5u W=1u
M21069 outn inp tail vss sky130_fd_pr__nfet_01v8 L=0.5u W=1u
M21070 outn inp tail vss sky130_fd_pr__nfet_01v8 L=0.5u W=1u
M21071 outn inp tail vss sky130_fd_pr__nfet_01v8 L=0.5u W=1u
M21072 outn inp tail vss sky130_fd_pr__nfet_01v8 L=0.5u W=1u
M21073 outn inp tail vss sky130_fd_pr__nfet_01v8 L=0.5u W=1u
M21074 outn inp tail vss sky130_fd_pr__nfet_01v8 L=0.5u W=1u
M21075 outn inp tail vss sky130_fd_pr__nfet_01v8 L=0.5u W=1u
M21076 outn inp tail vss sky130_fd_pr__nfet_01v8 L=0.5u W=1u
M21077 outn inp tail vss sky130_fd_pr__nfet_01v8 L=0.5u W=1u
M21078 outn inp tail vss sky130_fd_pr__nfet_01v8 L=0.5u W=1u
M21079 outn inp tail vss sky130_fd_pr__nfet_01v8 L=0.5u W=1u
M21080 outn inp tail vss sky130_fd_pr__nfet_01v8 L=0.5u W=1u
M21081 outn inp tail vss sky130_fd_pr__nfet_01v8 L=0.5u W=1u
M21082 outn inp tail vss sky130_fd_pr__nfet_01v8 L=0.5u W=1u
M21083 outn inp tail vss sky130_fd_pr__nfet_01v8 L=0.5u W=1u
M21084 outn inp tail vss sky130_fd_pr__nfet_01v8 L=0.5u W=1u
M21085 outn inp tail vss sky130_fd_pr__nfet_01v8 L=0.5u W=1u
M21086 outn inp tail vss sky130_fd_pr__nfet_01v8 L=0.5u W=1u
M21087 outn inp tail vss sky130_fd_pr__nfet_01v8 L=0.5u W=1u
M21088 outn inp tail vss sky130_fd_pr__nfet_01v8 L=0.5u W=1u
M21089 outn inp tail vss sky130_fd_pr__nfet_01v8 L=0.5u W=1u
M21090 outn inp tail vss sky130_fd_pr__nfet_01v8 L=0.5u W=1u
M21091 outn inp tail vss sky130_fd_pr__nfet_01v8 L=0.5u W=1u
M21092 outn inp tail vss sky130_fd_pr__nfet_01v8 L=0.5u W=1u
M21093 outn inp tail vss sky130_fd_pr__nfet_01v8 L=0.5u W=1u
M21094 outn inp tail vss sky130_fd_pr__nfet_01v8 L=0.5u W=1u
M21095 outn inp tail vss sky130_fd_pr__nfet_01v8 L=0.5u W=1u
M21096 outn inp tail vss sky130_fd_pr__nfet_01v8 L=0.5u W=1u
M21097 outn inp tail vss sky130_fd_pr__nfet_01v8 L=0.5u W=1u
M21098 outn inp tail vss sky130_fd_pr__nfet_01v8 L=0.5u W=1u
M21099 outn inp tail vss sky130_fd_pr__nfet_01v8 L=0.5u W=1u
M21100 outn inp tail vss sky130_fd_pr__nfet_01v8 L=0.5u W=1u
M21101 outn inp tail vss sky130_fd_pr__nfet_01v8 L=0.5u W=1u
M21102 outn inp tail vss sky130_fd_pr__nfet_01v8 L=0.5u W=1u
M21103 outn inp tail vss sky130_fd_pr__nfet_01v8 L=0.5u W=1u
M21104 outn inp tail vss sky130_fd_pr__nfet_01v8 L=0.5u W=1u
M21105 outn inp tail vss sky130_fd_pr__nfet_01v8 L=0.5u W=1u
M21106 outn inp tail vss sky130_fd_pr__nfet_01v8 L=0.5u W=1u
M21107 outn inp tail vss sky130_fd_pr__nfet_01v8 L=0.5u W=1u
M21108 outn inp tail vss sky130_fd_pr__nfet_01v8 L=0.5u W=1u
M21109 outn inp tail vss sky130_fd_pr__nfet_01v8 L=0.5u W=1u
M21110 outn inp tail vss sky130_fd_pr__nfet_01v8 L=0.5u W=1u
M21111 outn inp tail vss sky130_fd_pr__nfet_01v8 L=0.5u W=1u
M21112 outn inp tail vss sky130_fd_pr__nfet_01v8 L=0.5u W=1u
M21113 outn inp tail vss sky130_fd_pr__nfet_01v8 L=0.5u W=1u
M21114 outn inp tail vss sky130_fd_pr__nfet_01v8 L=0.5u W=1u
M21115 outn inp tail vss sky130_fd_pr__nfet_01v8 L=0.5u W=1u
M21116 outn inp tail vss sky130_fd_pr__nfet_01v8 L=0.5u W=1u
M21117 outn inp tail vss sky130_fd_pr__nfet_01v8 L=0.5u W=1u
M21118 outn inp tail vss sky130_fd_pr__nfet_01v8 L=0.5u W=1u
M21119 outn inp tail vss sky130_fd_pr__nfet_01v8 L=0.5u W=1u
M21120 outn inp tail vss sky130_fd_pr__nfet_01v8 L=0.5u W=1u
M21121 outn inp tail vss sky130_fd_pr__nfet_01v8 L=0.5u W=1u
M21122 outn inp tail vss sky130_fd_pr__nfet_01v8 L=0.5u W=1u
M21123 outn inp tail vss sky130_fd_pr__nfet_01v8 L=0.5u W=1u
M21124 outn inp tail vss sky130_fd_pr__nfet_01v8 L=0.5u W=1u
M21125 outn inp tail vss sky130_fd_pr__nfet_01v8 L=0.5u W=1u
M21126 outn inp tail vss sky130_fd_pr__nfet_01v8 L=0.5u W=1u
M21127 outn inp tail vss sky130_fd_pr__nfet_01v8 L=0.5u W=1u
M21128 outn inp tail vss sky130_fd_pr__nfet_01v8 L=0.5u W=1u
M21129 outn inp tail vss sky130_fd_pr__nfet_01v8 L=0.5u W=1u
M21130 outn inp tail vss sky130_fd_pr__nfet_01v8 L=0.5u W=1u
M21131 outn inp tail vss sky130_fd_pr__nfet_01v8 L=0.5u W=1u
M21132 outn inp tail vss sky130_fd_pr__nfet_01v8 L=0.5u W=1u
M21133 outn inp tail vss sky130_fd_pr__nfet_01v8 L=0.5u W=1u
M21134 outn inp tail vss sky130_fd_pr__nfet_01v8 L=0.5u W=1u
M21135 outn inp tail vss sky130_fd_pr__nfet_01v8 L=0.5u W=1u
M21136 outn inp tail vss sky130_fd_pr__nfet_01v8 L=0.5u W=1u
M21137 outn inp tail vss sky130_fd_pr__nfet_01v8 L=0.5u W=1u
M21138 outn inp tail vss sky130_fd_pr__nfet_01v8 L=0.5u W=1u
M21139 outn inp tail vss sky130_fd_pr__nfet_01v8 L=0.5u W=1u
M21140 outn inp tail vss sky130_fd_pr__nfet_01v8 L=0.5u W=1u
M21141 outn inp tail vss sky130_fd_pr__nfet_01v8 L=0.5u W=1u
M21142 outn inp tail vss sky130_fd_pr__nfet_01v8 L=0.5u W=1u
M21143 outn inp tail vss sky130_fd_pr__nfet_01v8 L=0.5u W=1u
M21144 outn inp tail vss sky130_fd_pr__nfet_01v8 L=0.5u W=1u
M21145 outn inp tail vss sky130_fd_pr__nfet_01v8 L=0.5u W=1u
M21146 outn inp tail vss sky130_fd_pr__nfet_01v8 L=0.5u W=1u
M21147 outn inp tail vss sky130_fd_pr__nfet_01v8 L=0.5u W=1u
M21148 outn inp tail vss sky130_fd_pr__nfet_01v8 L=0.5u W=1u
M21149 outn inp tail vss sky130_fd_pr__nfet_01v8 L=0.5u W=1u
M21150 outn inp tail vss sky130_fd_pr__nfet_01v8 L=0.5u W=1u
M21151 outn inp tail vss sky130_fd_pr__nfet_01v8 L=0.5u W=1u
M21152 outn inp tail vss sky130_fd_pr__nfet_01v8 L=0.5u W=1u
M21153 outn inp tail vss sky130_fd_pr__nfet_01v8 L=0.5u W=1u
M21154 outn inp tail vss sky130_fd_pr__nfet_01v8 L=0.5u W=1u
M21155 outn inp tail vss sky130_fd_pr__nfet_01v8 L=0.5u W=1u
M21156 outn inp tail vss sky130_fd_pr__nfet_01v8 L=0.5u W=1u
M21157 outn inp tail vss sky130_fd_pr__nfet_01v8 L=0.5u W=1u
M21158 outn inp tail vss sky130_fd_pr__nfet_01v8 L=0.5u W=1u
M21159 outn inp tail vss sky130_fd_pr__nfet_01v8 L=0.5u W=1u
M21160 outn inp tail vss sky130_fd_pr__nfet_01v8 L=0.5u W=1u
M21161 outn inp tail vss sky130_fd_pr__nfet_01v8 L=0.5u W=1u
M21162 outn inp tail vss sky130_fd_pr__nfet_01v8 L=0.5u W=1u
M21163 outn inp tail vss sky130_fd_pr__nfet_01v8 L=0.5u W=1u
M21164 outn inp tail vss sky130_fd_pr__nfet_01v8 L=0.5u W=1u
M21165 outn inp tail vss sky130_fd_pr__nfet_01v8 L=0.5u W=1u
M21166 outn inp tail vss sky130_fd_pr__nfet_01v8 L=0.5u W=1u
M21167 outn inp tail vss sky130_fd_pr__nfet_01v8 L=0.5u W=1u
M21168 outp inn tail vss sky130_fd_pr__nfet_01v8 L=0.5u W=1u
M21169 outp inn tail vss sky130_fd_pr__nfet_01v8 L=0.5u W=1u
M21170 outp inn tail vss sky130_fd_pr__nfet_01v8 L=0.5u W=1u
M21171 outp inn tail vss sky130_fd_pr__nfet_01v8 L=0.5u W=1u
M21172 outp inn tail vss sky130_fd_pr__nfet_01v8 L=0.5u W=1u
M21173 outp inn tail vss sky130_fd_pr__nfet_01v8 L=0.5u W=1u
M21174 outp inn tail vss sky130_fd_pr__nfet_01v8 L=0.5u W=1u
M21175 outp inn tail vss sky130_fd_pr__nfet_01v8 L=0.5u W=1u
M21176 outp inn tail vss sky130_fd_pr__nfet_01v8 L=0.5u W=1u
M21177 outp inn tail vss sky130_fd_pr__nfet_01v8 L=0.5u W=1u
M21178 outp inn tail vss sky130_fd_pr__nfet_01v8 L=0.5u W=1u
M21179 outp inn tail vss sky130_fd_pr__nfet_01v8 L=0.5u W=1u
M21180 outp inn tail vss sky130_fd_pr__nfet_01v8 L=0.5u W=1u
M21181 outp inn tail vss sky130_fd_pr__nfet_01v8 L=0.5u W=1u
M21182 outp inn tail vss sky130_fd_pr__nfet_01v8 L=0.5u W=1u
M21183 outp inn tail vss sky130_fd_pr__nfet_01v8 L=0.5u W=1u
M21184 outp inn tail vss sky130_fd_pr__nfet_01v8 L=0.5u W=1u
M21185 outp inn tail vss sky130_fd_pr__nfet_01v8 L=0.5u W=1u
M21186 outp inn tail vss sky130_fd_pr__nfet_01v8 L=0.5u W=1u
M21187 outp inn tail vss sky130_fd_pr__nfet_01v8 L=0.5u W=1u
M21188 outp inn tail vss sky130_fd_pr__nfet_01v8 L=0.5u W=1u
M21189 outp inn tail vss sky130_fd_pr__nfet_01v8 L=0.5u W=1u
M21190 outp inn tail vss sky130_fd_pr__nfet_01v8 L=0.5u W=1u
M21191 outp inn tail vss sky130_fd_pr__nfet_01v8 L=0.5u W=1u
M21192 outp inn tail vss sky130_fd_pr__nfet_01v8 L=0.5u W=1u
M21193 outp inn tail vss sky130_fd_pr__nfet_01v8 L=0.5u W=1u
M21194 outp inn tail vss sky130_fd_pr__nfet_01v8 L=0.5u W=1u
M21195 outp inn tail vss sky130_fd_pr__nfet_01v8 L=0.5u W=1u
M21196 outp inn tail vss sky130_fd_pr__nfet_01v8 L=0.5u W=1u
M21197 outp inn tail vss sky130_fd_pr__nfet_01v8 L=0.5u W=1u
M21198 outp inn tail vss sky130_fd_pr__nfet_01v8 L=0.5u W=1u
M21199 outp inn tail vss sky130_fd_pr__nfet_01v8 L=0.5u W=1u
M21200 outp inn tail vss sky130_fd_pr__nfet_01v8 L=0.5u W=1u
M21201 outp inn tail vss sky130_fd_pr__nfet_01v8 L=0.5u W=1u
M21202 outp inn tail vss sky130_fd_pr__nfet_01v8 L=0.5u W=1u
M21203 outp inn tail vss sky130_fd_pr__nfet_01v8 L=0.5u W=1u
M21204 outp inn tail vss sky130_fd_pr__nfet_01v8 L=0.5u W=1u
M21205 outp inn tail vss sky130_fd_pr__nfet_01v8 L=0.5u W=1u
M21206 outp inn tail vss sky130_fd_pr__nfet_01v8 L=0.5u W=1u
M21207 outp inn tail vss sky130_fd_pr__nfet_01v8 L=0.5u W=1u
M21208 outp inn tail vss sky130_fd_pr__nfet_01v8 L=0.5u W=1u
M21209 outp inn tail vss sky130_fd_pr__nfet_01v8 L=0.5u W=1u
M21210 outp inn tail vss sky130_fd_pr__nfet_01v8 L=0.5u W=1u
M21211 outp inn tail vss sky130_fd_pr__nfet_01v8 L=0.5u W=1u
M21212 outp inn tail vss sky130_fd_pr__nfet_01v8 L=0.5u W=1u
M21213 outp inn tail vss sky130_fd_pr__nfet_01v8 L=0.5u W=1u
M21214 outp inn tail vss sky130_fd_pr__nfet_01v8 L=0.5u W=1u
M21215 outp inn tail vss sky130_fd_pr__nfet_01v8 L=0.5u W=1u
M21216 outp inn tail vss sky130_fd_pr__nfet_01v8 L=0.5u W=1u
M21217 outp inn tail vss sky130_fd_pr__nfet_01v8 L=0.5u W=1u
M21218 outp inn tail vss sky130_fd_pr__nfet_01v8 L=0.5u W=1u
M21219 outp inn tail vss sky130_fd_pr__nfet_01v8 L=0.5u W=1u
M21220 outp inn tail vss sky130_fd_pr__nfet_01v8 L=0.5u W=1u
M21221 outp inn tail vss sky130_fd_pr__nfet_01v8 L=0.5u W=1u
M21222 outp inn tail vss sky130_fd_pr__nfet_01v8 L=0.5u W=1u
M21223 outp inn tail vss sky130_fd_pr__nfet_01v8 L=0.5u W=1u
M21224 outp inn tail vss sky130_fd_pr__nfet_01v8 L=0.5u W=1u
M21225 outp inn tail vss sky130_fd_pr__nfet_01v8 L=0.5u W=1u
M21226 outp inn tail vss sky130_fd_pr__nfet_01v8 L=0.5u W=1u
M21227 outp inn tail vss sky130_fd_pr__nfet_01v8 L=0.5u W=1u
M21228 outp inn tail vss sky130_fd_pr__nfet_01v8 L=0.5u W=1u
M21229 outp inn tail vss sky130_fd_pr__nfet_01v8 L=0.5u W=1u
M21230 outp inn tail vss sky130_fd_pr__nfet_01v8 L=0.5u W=1u
M21231 outp inn tail vss sky130_fd_pr__nfet_01v8 L=0.5u W=1u
M21232 outp inn tail vss sky130_fd_pr__nfet_01v8 L=0.5u W=1u
M21233 outp inn tail vss sky130_fd_pr__nfet_01v8 L=0.5u W=1u
M21234 outp inn tail vss sky130_fd_pr__nfet_01v8 L=0.5u W=1u
M21235 outp inn tail vss sky130_fd_pr__nfet_01v8 L=0.5u W=1u
M21236 outp inn tail vss sky130_fd_pr__nfet_01v8 L=0.5u W=1u
M21237 outp inn tail vss sky130_fd_pr__nfet_01v8 L=0.5u W=1u
M21238 outp inn tail vss sky130_fd_pr__nfet_01v8 L=0.5u W=1u
M21239 outp inn tail vss sky130_fd_pr__nfet_01v8 L=0.5u W=1u
M21240 outp inn tail vss sky130_fd_pr__nfet_01v8 L=0.5u W=1u
M21241 outp inn tail vss sky130_fd_pr__nfet_01v8 L=0.5u W=1u
M21242 outp inn tail vss sky130_fd_pr__nfet_01v8 L=0.5u W=1u
M21243 outp inn tail vss sky130_fd_pr__nfet_01v8 L=0.5u W=1u
M21244 outp inn tail vss sky130_fd_pr__nfet_01v8 L=0.5u W=1u
M21245 outp inn tail vss sky130_fd_pr__nfet_01v8 L=0.5u W=1u
M21246 outp inn tail vss sky130_fd_pr__nfet_01v8 L=0.5u W=1u
M21247 outp inn tail vss sky130_fd_pr__nfet_01v8 L=0.5u W=1u
M21248 outp inn tail vss sky130_fd_pr__nfet_01v8 L=0.5u W=1u
M21249 outp inn tail vss sky130_fd_pr__nfet_01v8 L=0.5u W=1u
M21250 outp inn tail vss sky130_fd_pr__nfet_01v8 L=0.5u W=1u
M21251 outp inn tail vss sky130_fd_pr__nfet_01v8 L=0.5u W=1u
M21252 outp inn tail vss sky130_fd_pr__nfet_01v8 L=0.5u W=1u
M21253 outp inn tail vss sky130_fd_pr__nfet_01v8 L=0.5u W=1u
M21254 outp inn tail vss sky130_fd_pr__nfet_01v8 L=0.5u W=1u
M21255 outp inn tail vss sky130_fd_pr__nfet_01v8 L=0.5u W=1u
M21256 outp inn tail vss sky130_fd_pr__nfet_01v8 L=0.5u W=1u
M21257 outp inn tail vss sky130_fd_pr__nfet_01v8 L=0.5u W=1u
M21258 outp inn tail vss sky130_fd_pr__nfet_01v8 L=0.5u W=1u
M21259 outp inn tail vss sky130_fd_pr__nfet_01v8 L=0.5u W=1u
M21260 outp inn tail vss sky130_fd_pr__nfet_01v8 L=0.5u W=1u
M21261 outp inn tail vss sky130_fd_pr__nfet_01v8 L=0.5u W=1u
M21262 outp inn tail vss sky130_fd_pr__nfet_01v8 L=0.5u W=1u
M21263 outp inn tail vss sky130_fd_pr__nfet_01v8 L=0.5u W=1u
M21264 outp inn tail vss sky130_fd_pr__nfet_01v8 L=0.5u W=1u
M21265 outp inn tail vss sky130_fd_pr__nfet_01v8 L=0.5u W=1u
M21266 outp inn tail vss sky130_fd_pr__nfet_01v8 L=0.5u W=1u
M21267 outp inn tail vss sky130_fd_pr__nfet_01v8 L=0.5u W=1u
M21268 outp inn tail vss sky130_fd_pr__nfet_01v8 L=0.5u W=1u
M21269 outp inn tail vss sky130_fd_pr__nfet_01v8 L=0.5u W=1u
M21270 outp inn tail vss sky130_fd_pr__nfet_01v8 L=0.5u W=1u
M21271 outp inn tail vss sky130_fd_pr__nfet_01v8 L=0.5u W=1u
M21272 outp inn tail vss sky130_fd_pr__nfet_01v8 L=0.5u W=1u
M21273 outp inn tail vss sky130_fd_pr__nfet_01v8 L=0.5u W=1u
M21274 outp inn tail vss sky130_fd_pr__nfet_01v8 L=0.5u W=1u
M21275 outp inn tail vss sky130_fd_pr__nfet_01v8 L=0.5u W=1u
M21276 outp inn tail vss sky130_fd_pr__nfet_01v8 L=0.5u W=1u
M21277 outp inn tail vss sky130_fd_pr__nfet_01v8 L=0.5u W=1u
M21278 outp inn tail vss sky130_fd_pr__nfet_01v8 L=0.5u W=1u
M21279 outp inn tail vss sky130_fd_pr__nfet_01v8 L=0.5u W=1u
M21280 outp inn tail vss sky130_fd_pr__nfet_01v8 L=0.5u W=1u
M21281 outp inn tail vss sky130_fd_pr__nfet_01v8 L=0.5u W=1u
M21282 outp inn tail vss sky130_fd_pr__nfet_01v8 L=0.5u W=1u
M21283 outp inn tail vss sky130_fd_pr__nfet_01v8 L=0.5u W=1u
M21284 outp inn tail vss sky130_fd_pr__nfet_01v8 L=0.5u W=1u
M21285 outp inn tail vss sky130_fd_pr__nfet_01v8 L=0.5u W=1u
M21286 outp inn tail vss sky130_fd_pr__nfet_01v8 L=0.5u W=1u
M21287 outp inn tail vss sky130_fd_pr__nfet_01v8 L=0.5u W=1u
M21288 outp inn tail vss sky130_fd_pr__nfet_01v8 L=0.5u W=1u
M21289 outp inn tail vss sky130_fd_pr__nfet_01v8 L=0.5u W=1u
M21290 outp inn tail vss sky130_fd_pr__nfet_01v8 L=0.5u W=1u
M21291 outp inn tail vss sky130_fd_pr__nfet_01v8 L=0.5u W=1u
M21292 outp inn tail vss sky130_fd_pr__nfet_01v8 L=0.5u W=1u
M21293 outp inn tail vss sky130_fd_pr__nfet_01v8 L=0.5u W=1u
M21294 outp inn tail vss sky130_fd_pr__nfet_01v8 L=0.5u W=1u
M21295 outp inn tail vss sky130_fd_pr__nfet_01v8 L=0.5u W=1u
M21296 tail ibias vss vss sky130_fd_pr__nfet_01v8 L=0.5u W=1u
M21297 tail ibias vss vss sky130_fd_pr__nfet_01v8 L=0.5u W=1u
M21298 tail ibias vss vss sky130_fd_pr__nfet_01v8 L=0.5u W=1u
M21299 tail ibias vss vss sky130_fd_pr__nfet_01v8 L=0.5u W=1u
M21300 tail ibias vss vss sky130_fd_pr__nfet_01v8 L=0.5u W=1u
M21301 tail ibias vss vss sky130_fd_pr__nfet_01v8 L=0.5u W=1u
M21302 tail ibias vss vss sky130_fd_pr__nfet_01v8 L=0.5u W=1u
M21303 tail ibias vss vss sky130_fd_pr__nfet_01v8 L=0.5u W=1u
M21304 tail ibias vss vss sky130_fd_pr__nfet_01v8 L=0.5u W=1u
M21305 tail ibias vss vss sky130_fd_pr__nfet_01v8 L=0.5u W=1u
M21306 tail ibias vss vss sky130_fd_pr__nfet_01v8 L=0.5u W=1u
M21307 tail ibias vss vss sky130_fd_pr__nfet_01v8 L=0.5u W=1u
M21308 tail ibias vss vss sky130_fd_pr__nfet_01v8 L=0.5u W=1u
M21309 tail ibias vss vss sky130_fd_pr__nfet_01v8 L=0.5u W=1u
M21310 tail ibias vss vss sky130_fd_pr__nfet_01v8 L=0.5u W=1u
M21311 tail ibias vss vss sky130_fd_pr__nfet_01v8 L=0.5u W=1u
M21312 tail ibias vss vss sky130_fd_pr__nfet_01v8 L=0.5u W=1u
M21313 tail ibias vss vss sky130_fd_pr__nfet_01v8 L=0.5u W=1u
M21314 tail ibias vss vss sky130_fd_pr__nfet_01v8 L=0.5u W=1u
M21315 tail ibias vss vss sky130_fd_pr__nfet_01v8 L=0.5u W=1u
M21316 tail ibias vss vss sky130_fd_pr__nfet_01v8 L=0.5u W=1u
M21317 tail ibias vss vss sky130_fd_pr__nfet_01v8 L=0.5u W=1u
M21318 tail ibias vss vss sky130_fd_pr__nfet_01v8 L=0.5u W=1u
M21319 tail ibias vss vss sky130_fd_pr__nfet_01v8 L=0.5u W=1u
M21320 tail ibias vss vss sky130_fd_pr__nfet_01v8 L=0.5u W=1u
M21321 tail ibias vss vss sky130_fd_pr__nfet_01v8 L=0.5u W=1u
M21322 tail ibias vss vss sky130_fd_pr__nfet_01v8 L=0.5u W=1u
M21323 tail ibias vss vss sky130_fd_pr__nfet_01v8 L=0.5u W=1u
M21324 tail ibias vss vss sky130_fd_pr__nfet_01v8 L=0.5u W=1u
M21325 tail ibias vss vss sky130_fd_pr__nfet_01v8 L=0.5u W=1u
M21326 tail ibias vss vss sky130_fd_pr__nfet_01v8 L=0.5u W=1u
M21327 tail ibias vss vss sky130_fd_pr__nfet_01v8 L=0.5u W=1u
M21328 tail ibias vss vss sky130_fd_pr__nfet_01v8 L=0.5u W=1u
M21329 tail ibias vss vss sky130_fd_pr__nfet_01v8 L=0.5u W=1u
M21330 tail ibias vss vss sky130_fd_pr__nfet_01v8 L=0.5u W=1u
M21331 tail ibias vss vss sky130_fd_pr__nfet_01v8 L=0.5u W=1u
M21332 tail ibias vss vss sky130_fd_pr__nfet_01v8 L=0.5u W=1u
M21333 tail ibias vss vss sky130_fd_pr__nfet_01v8 L=0.5u W=1u
M21334 tail ibias vss vss sky130_fd_pr__nfet_01v8 L=0.5u W=1u
M21335 tail ibias vss vss sky130_fd_pr__nfet_01v8 L=0.5u W=1u
M21336 tail ibias vss vss sky130_fd_pr__nfet_01v8 L=0.5u W=1u
M21337 tail ibias vss vss sky130_fd_pr__nfet_01v8 L=0.5u W=1u
M21338 tail ibias vss vss sky130_fd_pr__nfet_01v8 L=0.5u W=1u
M21339 tail ibias vss vss sky130_fd_pr__nfet_01v8 L=0.5u W=1u
M21340 tail ibias vss vss sky130_fd_pr__nfet_01v8 L=0.5u W=1u
M21341 tail ibias vss vss sky130_fd_pr__nfet_01v8 L=0.5u W=1u
M21342 tail ibias vss vss sky130_fd_pr__nfet_01v8 L=0.5u W=1u
M21343 tail ibias vss vss sky130_fd_pr__nfet_01v8 L=0.5u W=1u
M21344 tail ibias vss vss sky130_fd_pr__nfet_01v8 L=0.5u W=1u
M21345 tail ibias vss vss sky130_fd_pr__nfet_01v8 L=0.5u W=1u
M21346 tail ibias vss vss sky130_fd_pr__nfet_01v8 L=0.5u W=1u
M21347 tail ibias vss vss sky130_fd_pr__nfet_01v8 L=0.5u W=1u
M21348 tail ibias vss vss sky130_fd_pr__nfet_01v8 L=0.5u W=1u
M21349 tail ibias vss vss sky130_fd_pr__nfet_01v8 L=0.5u W=1u
M21350 tail ibias vss vss sky130_fd_pr__nfet_01v8 L=0.5u W=1u
M21351 tail ibias vss vss sky130_fd_pr__nfet_01v8 L=0.5u W=1u
M21352 tail ibias vss vss sky130_fd_pr__nfet_01v8 L=0.5u W=1u
M21353 tail ibias vss vss sky130_fd_pr__nfet_01v8 L=0.5u W=1u
M21354 tail ibias vss vss sky130_fd_pr__nfet_01v8 L=0.5u W=1u
M21355 tail ibias vss vss sky130_fd_pr__nfet_01v8 L=0.5u W=1u
M21356 tail ibias vss vss sky130_fd_pr__nfet_01v8 L=0.5u W=1u
M21357 tail ibias vss vss sky130_fd_pr__nfet_01v8 L=0.5u W=1u
M21358 tail ibias vss vss sky130_fd_pr__nfet_01v8 L=0.5u W=1u
M21359 tail ibias vss vss sky130_fd_pr__nfet_01v8 L=0.5u W=1u
M21360 tail ibias vss vss sky130_fd_pr__nfet_01v8 L=0.5u W=1u
M21361 tail ibias vss vss sky130_fd_pr__nfet_01v8 L=0.5u W=1u
M21362 tail ibias vss vss sky130_fd_pr__nfet_01v8 L=0.5u W=1u
M21363 tail ibias vss vss sky130_fd_pr__nfet_01v8 L=0.5u W=1u
M21364 tail ibias vss vss sky130_fd_pr__nfet_01v8 L=0.5u W=1u
M21365 tail ibias vss vss sky130_fd_pr__nfet_01v8 L=0.5u W=1u
M21366 tail ibias vss vss sky130_fd_pr__nfet_01v8 L=0.5u W=1u
M21367 tail ibias vss vss sky130_fd_pr__nfet_01v8 L=0.5u W=1u
M21368 tail ibias vss vss sky130_fd_pr__nfet_01v8 L=0.5u W=1u
M21369 tail ibias vss vss sky130_fd_pr__nfet_01v8 L=0.5u W=1u
M21370 tail ibias vss vss sky130_fd_pr__nfet_01v8 L=0.5u W=1u
M21371 tail ibias vss vss sky130_fd_pr__nfet_01v8 L=0.5u W=1u
M21372 tail ibias vss vss sky130_fd_pr__nfet_01v8 L=0.5u W=1u
M21373 tail ibias vss vss sky130_fd_pr__nfet_01v8 L=0.5u W=1u
M21374 tail ibias vss vss sky130_fd_pr__nfet_01v8 L=0.5u W=1u
M21375 tail ibias vss vss sky130_fd_pr__nfet_01v8 L=0.5u W=1u
M21376 tail ibias vss vss sky130_fd_pr__nfet_01v8 L=0.5u W=1u
M21377 tail ibias vss vss sky130_fd_pr__nfet_01v8 L=0.5u W=1u
M21378 tail ibias vss vss sky130_fd_pr__nfet_01v8 L=0.5u W=1u
M21379 tail ibias vss vss sky130_fd_pr__nfet_01v8 L=0.5u W=1u
M21380 tail ibias vss vss sky130_fd_pr__nfet_01v8 L=0.5u W=1u
M21381 tail ibias vss vss sky130_fd_pr__nfet_01v8 L=0.5u W=1u
M21382 tail ibias vss vss sky130_fd_pr__nfet_01v8 L=0.5u W=1u
M21383 tail ibias vss vss sky130_fd_pr__nfet_01v8 L=0.5u W=1u
M21384 tail ibias vss vss sky130_fd_pr__nfet_01v8 L=0.5u W=1u
M21385 tail ibias vss vss sky130_fd_pr__nfet_01v8 L=0.5u W=1u
M21386 tail ibias vss vss sky130_fd_pr__nfet_01v8 L=0.5u W=1u
M21387 tail ibias vss vss sky130_fd_pr__nfet_01v8 L=0.5u W=1u
M21388 tail ibias vss vss sky130_fd_pr__nfet_01v8 L=0.5u W=1u
M21389 tail ibias vss vss sky130_fd_pr__nfet_01v8 L=0.5u W=1u
M21390 tail ibias vss vss sky130_fd_pr__nfet_01v8 L=0.5u W=1u
M21391 tail ibias vss vss sky130_fd_pr__nfet_01v8 L=0.5u W=1u
M21392 tail ibias vss vss sky130_fd_pr__nfet_01v8 L=0.5u W=1u
M21393 tail ibias vss vss sky130_fd_pr__nfet_01v8 L=0.5u W=1u
M21394 tail ibias vss vss sky130_fd_pr__nfet_01v8 L=0.5u W=1u
M21395 tail ibias vss vss sky130_fd_pr__nfet_01v8 L=0.5u W=1u
M21396 tail ibias vss vss sky130_fd_pr__nfet_01v8 L=0.5u W=1u
M21397 tail ibias vss vss sky130_fd_pr__nfet_01v8 L=0.5u W=1u
M21398 tail ibias vss vss sky130_fd_pr__nfet_01v8 L=0.5u W=1u
M21399 tail ibias vss vss sky130_fd_pr__nfet_01v8 L=0.5u W=1u
M21400 tail ibias vss vss sky130_fd_pr__nfet_01v8 L=0.5u W=1u
M21401 tail ibias vss vss sky130_fd_pr__nfet_01v8 L=0.5u W=1u
M21402 tail ibias vss vss sky130_fd_pr__nfet_01v8 L=0.5u W=1u
M21403 tail ibias vss vss sky130_fd_pr__nfet_01v8 L=0.5u W=1u
M21404 tail ibias vss vss sky130_fd_pr__nfet_01v8 L=0.5u W=1u
M21405 tail ibias vss vss sky130_fd_pr__nfet_01v8 L=0.5u W=1u
M21406 tail ibias vss vss sky130_fd_pr__nfet_01v8 L=0.5u W=1u
M21407 tail ibias vss vss sky130_fd_pr__nfet_01v8 L=0.5u W=1u
M21408 tail ibias vss vss sky130_fd_pr__nfet_01v8 L=0.5u W=1u
M21409 tail ibias vss vss sky130_fd_pr__nfet_01v8 L=0.5u W=1u
M21410 tail ibias vss vss sky130_fd_pr__nfet_01v8 L=0.5u W=1u
M21411 tail ibias vss vss sky130_fd_pr__nfet_01v8 L=0.5u W=1u
M21412 tail ibias vss vss sky130_fd_pr__nfet_01v8 L=0.5u W=1u
M21413 tail ibias vss vss sky130_fd_pr__nfet_01v8 L=0.5u W=1u
M21414 tail ibias vss vss sky130_fd_pr__nfet_01v8 L=0.5u W=1u
M21415 tail ibias vss vss sky130_fd_pr__nfet_01v8 L=0.5u W=1u
M21416 tail ibias vss vss sky130_fd_pr__nfet_01v8 L=0.5u W=1u
M21417 tail ibias vss vss sky130_fd_pr__nfet_01v8 L=0.5u W=1u
M21418 tail ibias vss vss sky130_fd_pr__nfet_01v8 L=0.5u W=1u
M21419 tail ibias vss vss sky130_fd_pr__nfet_01v8 L=0.5u W=1u
M21420 tail ibias vss vss sky130_fd_pr__nfet_01v8 L=0.5u W=1u
M21421 tail ibias vss vss sky130_fd_pr__nfet_01v8 L=0.5u W=1u
M21422 tail ibias vss vss sky130_fd_pr__nfet_01v8 L=0.5u W=1u
M21423 tail ibias vss vss sky130_fd_pr__nfet_01v8 L=0.5u W=1u
M21424 tail ibias vss vss sky130_fd_pr__nfet_01v8 L=0.5u W=1u
M21425 tail ibias vss vss sky130_fd_pr__nfet_01v8 L=0.5u W=1u
M21426 tail ibias vss vss sky130_fd_pr__nfet_01v8 L=0.5u W=1u
M21427 tail ibias vss vss sky130_fd_pr__nfet_01v8 L=0.5u W=1u
M21428 tail ibias vss vss sky130_fd_pr__nfet_01v8 L=0.5u W=1u
M21429 tail ibias vss vss sky130_fd_pr__nfet_01v8 L=0.5u W=1u
M21430 tail ibias vss vss sky130_fd_pr__nfet_01v8 L=0.5u W=1u
M21431 tail ibias vss vss sky130_fd_pr__nfet_01v8 L=0.5u W=1u
M21432 tail ibias vss vss sky130_fd_pr__nfet_01v8 L=0.5u W=1u
M21433 tail ibias vss vss sky130_fd_pr__nfet_01v8 L=0.5u W=1u
M21434 tail ibias vss vss sky130_fd_pr__nfet_01v8 L=0.5u W=1u
M21435 tail ibias vss vss sky130_fd_pr__nfet_01v8 L=0.5u W=1u
M21436 tail ibias vss vss sky130_fd_pr__nfet_01v8 L=0.5u W=1u
M21437 tail ibias vss vss sky130_fd_pr__nfet_01v8 L=0.5u W=1u
M21438 tail ibias vss vss sky130_fd_pr__nfet_01v8 L=0.5u W=1u
M21439 tail ibias vss vss sky130_fd_pr__nfet_01v8 L=0.5u W=1u
M21440 tail ibias vss vss sky130_fd_pr__nfet_01v8 L=0.5u W=1u
M21441 tail ibias vss vss sky130_fd_pr__nfet_01v8 L=0.5u W=1u
M21442 tail ibias vss vss sky130_fd_pr__nfet_01v8 L=0.5u W=1u
M21443 tail ibias vss vss sky130_fd_pr__nfet_01v8 L=0.5u W=1u
M21444 tail ibias vss vss sky130_fd_pr__nfet_01v8 L=0.5u W=1u
M21445 tail ibias vss vss sky130_fd_pr__nfet_01v8 L=0.5u W=1u
M21446 tail ibias vss vss sky130_fd_pr__nfet_01v8 L=0.5u W=1u
M21447 tail ibias vss vss sky130_fd_pr__nfet_01v8 L=0.5u W=1u
M21448 tail ibias vss vss sky130_fd_pr__nfet_01v8 L=0.5u W=1u
M21449 tail ibias vss vss sky130_fd_pr__nfet_01v8 L=0.5u W=1u
M21450 tail ibias vss vss sky130_fd_pr__nfet_01v8 L=0.5u W=1u
M21451 tail ibias vss vss sky130_fd_pr__nfet_01v8 L=0.5u W=1u
M21452 tail ibias vss vss sky130_fd_pr__nfet_01v8 L=0.5u W=1u
M21453 tail ibias vss vss sky130_fd_pr__nfet_01v8 L=0.5u W=1u
M21454 tail ibias vss vss sky130_fd_pr__nfet_01v8 L=0.5u W=1u
M21455 tail ibias vss vss sky130_fd_pr__nfet_01v8 L=0.5u W=1u
M21456 tail ibias vss vss sky130_fd_pr__nfet_01v8 L=0.5u W=1u
M21457 tail ibias vss vss sky130_fd_pr__nfet_01v8 L=0.5u W=1u
M21458 tail ibias vss vss sky130_fd_pr__nfet_01v8 L=0.5u W=1u
M21459 tail ibias vss vss sky130_fd_pr__nfet_01v8 L=0.5u W=1u
M21460 tail ibias vss vss sky130_fd_pr__nfet_01v8 L=0.5u W=1u
M21461 tail ibias vss vss sky130_fd_pr__nfet_01v8 L=0.5u W=1u
M21462 tail ibias vss vss sky130_fd_pr__nfet_01v8 L=0.5u W=1u
M21463 tail ibias vss vss sky130_fd_pr__nfet_01v8 L=0.5u W=1u
M21464 tail ibias vss vss sky130_fd_pr__nfet_01v8 L=0.5u W=1u
M21465 tail ibias vss vss sky130_fd_pr__nfet_01v8 L=0.5u W=1u
M21466 tail ibias vss vss sky130_fd_pr__nfet_01v8 L=0.5u W=1u
M21467 tail ibias vss vss sky130_fd_pr__nfet_01v8 L=0.5u W=1u
M21468 tail ibias vss vss sky130_fd_pr__nfet_01v8 L=0.5u W=1u
M21469 tail ibias vss vss sky130_fd_pr__nfet_01v8 L=0.5u W=1u
M21470 tail ibias vss vss sky130_fd_pr__nfet_01v8 L=0.5u W=1u
M21471 tail ibias vss vss sky130_fd_pr__nfet_01v8 L=0.5u W=1u
M21472 tail ibias vss vss sky130_fd_pr__nfet_01v8 L=0.5u W=1u
M21473 tail ibias vss vss sky130_fd_pr__nfet_01v8 L=0.5u W=1u
M21474 tail ibias vss vss sky130_fd_pr__nfet_01v8 L=0.5u W=1u
M21475 tail ibias vss vss sky130_fd_pr__nfet_01v8 L=0.5u W=1u
M21476 tail ibias vss vss sky130_fd_pr__nfet_01v8 L=0.5u W=1u
M21477 tail ibias vss vss sky130_fd_pr__nfet_01v8 L=0.5u W=1u
M21478 tail ibias vss vss sky130_fd_pr__nfet_01v8 L=0.5u W=1u
M21479 tail ibias vss vss sky130_fd_pr__nfet_01v8 L=0.5u W=1u
M21480 tail ibias vss vss sky130_fd_pr__nfet_01v8 L=0.5u W=1u
M21481 tail ibias vss vss sky130_fd_pr__nfet_01v8 L=0.5u W=1u
M21482 tail ibias vss vss sky130_fd_pr__nfet_01v8 L=0.5u W=1u
M21483 tail ibias vss vss sky130_fd_pr__nfet_01v8 L=0.5u W=1u
M21484 tail ibias vss vss sky130_fd_pr__nfet_01v8 L=0.5u W=1u
M21485 tail ibias vss vss sky130_fd_pr__nfet_01v8 L=0.5u W=1u
M21486 tail ibias vss vss sky130_fd_pr__nfet_01v8 L=0.5u W=1u
M21487 tail ibias vss vss sky130_fd_pr__nfet_01v8 L=0.5u W=1u
.ends idac
