* TopMetal2 microstrip models at 122 GHz (RLGC, 20 lumped sections; R is the loss at 122 GHz, constant in frequency).
* Source: the public interface rows of the reference design (RF interconnect: 13 um line 50.9 ohm, 1.00 dB/mm, 6.58 ps/mm)
* and its line table (6 um 65.5 ohm 1.00 dB/mm eps_eff 3.87; 23 um 38.4 ohm 0.78 dB/mm eps_eff 3.89), simulated with openEMS
* over a two-layer slotted Metal1 + Metal2 ground. Use: X<name> a b tm2_w13 len=<metres>, len <= 1e-3. Ground is node 0.
* The series resistors are noisy (thermal noise of the line loss). Do not change this file.

* 6 um TopMetal2: 65.5 ohm, 1.00 dB/mm, eps_eff 3.87 (6.56 ps/mm)
.subckt tm2_w6 a b len=100e-6
.param ls={4.296800e-07*len/20} cs={1.001527e-10*len/20} rs={1.508174e+04*len/20}
R0 a m0 {rs}
L0 m0 n1 {ls}
C0 n1 0 {cs}
R1 n1 m1 {rs}
L1 m1 n2 {ls}
C1 n2 0 {cs}
R2 n2 m2 {rs}
L2 m2 n3 {ls}
C2 n3 0 {cs}
R3 n3 m3 {rs}
L3 m3 n4 {ls}
C3 n4 0 {cs}
R4 n4 m4 {rs}
L4 m4 n5 {ls}
C4 n5 0 {cs}
R5 n5 m5 {rs}
L5 m5 n6 {ls}
C5 n6 0 {cs}
R6 n6 m6 {rs}
L6 m6 n7 {ls}
C6 n7 0 {cs}
R7 n7 m7 {rs}
L7 m7 n8 {ls}
C7 n8 0 {cs}
R8 n8 m8 {rs}
L8 m8 n9 {ls}
C8 n9 0 {cs}
R9 n9 m9 {rs}
L9 m9 n10 {ls}
C9 n10 0 {cs}
R10 n10 m10 {rs}
L10 m10 n11 {ls}
C10 n11 0 {cs}
R11 n11 m11 {rs}
L11 m11 n12 {ls}
C11 n12 0 {cs}
R12 n12 m12 {rs}
L12 m12 n13 {ls}
C12 n13 0 {cs}
R13 n13 m13 {rs}
L13 m13 n14 {ls}
C13 n14 0 {cs}
R14 n14 m14 {rs}
L14 m14 n15 {ls}
C14 n15 0 {cs}
R15 n15 m15 {rs}
L15 m15 n16 {ls}
C15 n16 0 {cs}
R16 n16 m16 {rs}
L16 m16 n17 {ls}
C16 n17 0 {cs}
R17 n17 m17 {rs}
L17 m17 n18 {ls}
C17 n18 0 {cs}
R18 n18 m18 {rs}
L18 m18 n19 {ls}
C18 n19 0 {cs}
R19 n19 m19 {rs}
L19 m19 b {ls}
C19 b 0 {cs}
.ends tm2_w6

* 13 um TopMetal2: 50.9 ohm, 1.00 dB/mm, 6.58 ps/mm
.subckt tm2_w13 a b len=100e-6
.param ls={3.349220e-07*len/20} cs={1.292731e-10*len/20} rs={1.172001e+04*len/20}
R0 a m0 {rs}
L0 m0 n1 {ls}
C0 n1 0 {cs}
R1 n1 m1 {rs}
L1 m1 n2 {ls}
C1 n2 0 {cs}
R2 n2 m2 {rs}
L2 m2 n3 {ls}
C2 n3 0 {cs}
R3 n3 m3 {rs}
L3 m3 n4 {ls}
C3 n4 0 {cs}
R4 n4 m4 {rs}
L4 m4 n5 {ls}
C4 n5 0 {cs}
R5 n5 m5 {rs}
L5 m5 n6 {ls}
C5 n6 0 {cs}
R6 n6 m6 {rs}
L6 m6 n7 {ls}
C6 n7 0 {cs}
R7 n7 m7 {rs}
L7 m7 n8 {ls}
C7 n8 0 {cs}
R8 n8 m8 {rs}
L8 m8 n9 {ls}
C8 n9 0 {cs}
R9 n9 m9 {rs}
L9 m9 n10 {ls}
C9 n10 0 {cs}
R10 n10 m10 {rs}
L10 m10 n11 {ls}
C10 n11 0 {cs}
R11 n11 m11 {rs}
L11 m11 n12 {ls}
C11 n12 0 {cs}
R12 n12 m12 {rs}
L12 m12 n13 {ls}
C12 n13 0 {cs}
R13 n13 m13 {rs}
L13 m13 n14 {ls}
C13 n14 0 {cs}
R14 n14 m14 {rs}
L14 m14 n15 {ls}
C14 n15 0 {cs}
R15 n15 m15 {rs}
L15 m15 n16 {ls}
C15 n16 0 {cs}
R16 n16 m16 {rs}
L16 m16 n17 {ls}
C16 n17 0 {cs}
R17 n17 m17 {rs}
L17 m17 n18 {ls}
C17 n18 0 {cs}
R18 n18 m18 {rs}
L18 m18 n19 {ls}
C18 n19 0 {cs}
R19 n19 m19 {rs}
L19 m19 b {ls}
C19 b 0 {cs}
.ends tm2_w13

* 23 um TopMetal2: 38.4 ohm, 0.78 dB/mm, eps_eff 3.89 (6.58 ps/mm)
.subckt tm2_w23 a b len=100e-6
.param ls={2.526720e-07*len/20} cs={1.713542e-10*len/20} rs={6.896615e+03*len/20}
R0 a m0 {rs}
L0 m0 n1 {ls}
C0 n1 0 {cs}
R1 n1 m1 {rs}
L1 m1 n2 {ls}
C1 n2 0 {cs}
R2 n2 m2 {rs}
L2 m2 n3 {ls}
C2 n3 0 {cs}
R3 n3 m3 {rs}
L3 m3 n4 {ls}
C3 n4 0 {cs}
R4 n4 m4 {rs}
L4 m4 n5 {ls}
C4 n5 0 {cs}
R5 n5 m5 {rs}
L5 m5 n6 {ls}
C5 n6 0 {cs}
R6 n6 m6 {rs}
L6 m6 n7 {ls}
C6 n7 0 {cs}
R7 n7 m7 {rs}
L7 m7 n8 {ls}
C7 n8 0 {cs}
R8 n8 m8 {rs}
L8 m8 n9 {ls}
C8 n9 0 {cs}
R9 n9 m9 {rs}
L9 m9 n10 {ls}
C9 n10 0 {cs}
R10 n10 m10 {rs}
L10 m10 n11 {ls}
C10 n11 0 {cs}
R11 n11 m11 {rs}
L11 m11 n12 {ls}
C11 n12 0 {cs}
R12 n12 m12 {rs}
L12 m12 n13 {ls}
C12 n13 0 {cs}
R13 n13 m13 {rs}
L13 m13 n14 {ls}
C13 n14 0 {cs}
R14 n14 m14 {rs}
L14 m14 n15 {ls}
C14 n15 0 {cs}
R15 n15 m15 {rs}
L15 m15 n16 {ls}
C15 n16 0 {cs}
R16 n16 m16 {rs}
L16 m16 n17 {ls}
C16 n17 0 {cs}
R17 n17 m17 {rs}
L17 m17 n18 {ls}
C17 n18 0 {cs}
R18 n18 m18 {rs}
L18 m18 n19 {ls}
C18 n19 0 {cs}
R19 n19 m19 {rs}
L19 m19 b {ls}
C19 b 0 {cs}
.ends tm2_w23
