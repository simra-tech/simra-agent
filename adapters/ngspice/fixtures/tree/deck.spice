* top deck
.include "sub/a.spice"
.lib "models.lib" tt
.include missing.spice
